* NGSPICE file created from registerfile.ext - technology: sky130A

* Black-box entry subcircuit for sky130_fd_sc_hd__fill_2 abstract view
.subckt sky130_fd_sc_hd__fill_2 VGND VNB VPB VPWR
.ends

* Black-box entry subcircuit for sky130_fd_sc_hd__decap_3 abstract view
.subckt sky130_fd_sc_hd__decap_3 VGND VNB VPB VPWR
.ends

* Black-box entry subcircuit for sky130_fd_sc_hd__mux4_2 abstract view
.subckt sky130_fd_sc_hd__mux4_2 A0 A1 A2 A3 S0 S1 VGND VNB VPB VPWR X
.ends

* Black-box entry subcircuit for sky130_fd_sc_hd__tapvpwrvgnd_1 abstract view
.subckt sky130_fd_sc_hd__tapvpwrvgnd_1 VGND VPWR
.ends

* Black-box entry subcircuit for sky130_fd_sc_hd__nor2_2 abstract view
.subckt sky130_fd_sc_hd__nor2_2 A B VGND VNB VPB VPWR Y
.ends

* Black-box entry subcircuit for sky130_fd_sc_hd__dfxtp_2 abstract view
.subckt sky130_fd_sc_hd__dfxtp_2 CLK D VGND VNB VPB VPWR Q
.ends

* Black-box entry subcircuit for sky130_fd_sc_hd__o31a_2 abstract view
.subckt sky130_fd_sc_hd__o31a_2 A1 A2 A3 B1 VGND VNB VPB VPWR X
.ends

* Black-box entry subcircuit for sky130_fd_sc_hd__a22o_2 abstract view
.subckt sky130_fd_sc_hd__a22o_2 A1 A2 B1 B2 VGND VNB VPB VPWR X
.ends

* Black-box entry subcircuit for sky130_fd_sc_hd__fill_1 abstract view
.subckt sky130_fd_sc_hd__fill_1 VGND VNB VPB VPWR
.ends

* Black-box entry subcircuit for sky130_fd_sc_hd__dlymetal6s4s_1 abstract view
.subckt sky130_fd_sc_hd__dlymetal6s4s_1 A VGND VNB VPB VPWR X
.ends

* Black-box entry subcircuit for sky130_fd_sc_hd__clkdlybuf4s25_1 abstract view
.subckt sky130_fd_sc_hd__clkdlybuf4s25_1 A VGND VNB VPB VPWR X
.ends

* Black-box entry subcircuit for sky130_fd_sc_hd__o22a_2 abstract view
.subckt sky130_fd_sc_hd__o22a_2 A1 A2 B1 B2 VGND VNB VPB VPWR X
.ends

* Black-box entry subcircuit for sky130_fd_sc_hd__mux2_1 abstract view
.subckt sky130_fd_sc_hd__mux2_1 A0 A1 S VGND VNB VPB VPWR X
.ends

* Black-box entry subcircuit for sky130_fd_sc_hd__a32o_2 abstract view
.subckt sky130_fd_sc_hd__a32o_2 A1 A2 A3 B1 B2 VGND VNB VPB VPWR X
.ends

* Black-box entry subcircuit for sky130_fd_sc_hd__dlymetal6s2s_1 abstract view
.subckt sky130_fd_sc_hd__dlymetal6s2s_1 A VGND VNB VPB VPWR X
.ends

* Black-box entry subcircuit for sky130_fd_sc_hd__dlygate4sd3_1 abstract view
.subckt sky130_fd_sc_hd__dlygate4sd3_1 A VGND VNB VPB VPWR X
.ends

* Black-box entry subcircuit for sky130_fd_sc_hd__clkbuf_8 abstract view
.subckt sky130_fd_sc_hd__clkbuf_8 A VGND VNB VPB VPWR X
.ends

* Black-box entry subcircuit for sky130_fd_sc_hd__or2_2 abstract view
.subckt sky130_fd_sc_hd__or2_2 A B VGND VNB VPB VPWR X
.ends

* Black-box entry subcircuit for sky130_fd_sc_hd__clkbuf_4 abstract view
.subckt sky130_fd_sc_hd__clkbuf_4 A VGND VNB VPB VPWR X
.ends

* Black-box entry subcircuit for sky130_fd_sc_hd__buf_4 abstract view
.subckt sky130_fd_sc_hd__buf_4 A VGND VNB VPB VPWR X
.ends

* Black-box entry subcircuit for sky130_fd_sc_hd__a21o_2 abstract view
.subckt sky130_fd_sc_hd__a21o_2 A1 A2 B1 VGND VNB VPB VPWR X
.ends

* Black-box entry subcircuit for sky130_fd_sc_hd__and2b_2 abstract view
.subckt sky130_fd_sc_hd__and2b_2 A_N B VGND VNB VPB VPWR X
.ends

* Black-box entry subcircuit for sky130_fd_sc_hd__diode_2 abstract view
.subckt sky130_fd_sc_hd__diode_2 DIODE VGND VNB VPB VPWR
.ends

* Black-box entry subcircuit for sky130_fd_sc_hd__clkbuf_2 abstract view
.subckt sky130_fd_sc_hd__clkbuf_2 A VGND VNB VPB VPWR X
.ends

* Black-box entry subcircuit for sky130_fd_sc_hd__a31o_2 abstract view
.subckt sky130_fd_sc_hd__a31o_2 A1 A2 A3 B1 VGND VNB VPB VPWR X
.ends

* Black-box entry subcircuit for sky130_fd_sc_hd__buf_2 abstract view
.subckt sky130_fd_sc_hd__buf_2 A VGND VNB VPB VPWR X
.ends

* Black-box entry subcircuit for sky130_fd_sc_hd__o211a_2 abstract view
.subckt sky130_fd_sc_hd__o211a_2 A1 A2 B1 C1 VGND VNB VPB VPWR X
.ends

* Black-box entry subcircuit for sky130_fd_sc_hd__o21a_2 abstract view
.subckt sky130_fd_sc_hd__o21a_2 A1 A2 B1 VGND VNB VPB VPWR X
.ends

* Black-box entry subcircuit for sky130_fd_sc_hd__or3b_4 abstract view
.subckt sky130_fd_sc_hd__or3b_4 A B C_N VGND VNB VPB VPWR X
.ends

* Black-box entry subcircuit for sky130_fd_sc_hd__and2_2 abstract view
.subckt sky130_fd_sc_hd__and2_2 A B VGND VNB VPB VPWR X
.ends

* Black-box entry subcircuit for sky130_fd_sc_hd__dlygate4sd1_1 abstract view
.subckt sky130_fd_sc_hd__dlygate4sd1_1 A VGND VNB VPB VPWR X
.ends

* Black-box entry subcircuit for sky130_fd_sc_hd__or3b_2 abstract view
.subckt sky130_fd_sc_hd__or3b_2 A B C_N VGND VNB VPB VPWR X
.ends

* Black-box entry subcircuit for sky130_fd_sc_hd__buf_6 abstract view
.subckt sky130_fd_sc_hd__buf_6 A VGND VNB VPB VPWR X
.ends

* Black-box entry subcircuit for sky130_fd_sc_hd__o221a_2 abstract view
.subckt sky130_fd_sc_hd__o221a_2 A1 A2 B1 B2 C1 VGND VNB VPB VPWR X
.ends

* Black-box entry subcircuit for sky130_fd_sc_hd__o21ai_2 abstract view
.subckt sky130_fd_sc_hd__o21ai_2 A1 A2 B1 VGND VNB VPB VPWR Y
.ends

* Black-box entry subcircuit for sky130_fd_sc_hd__and3_2 abstract view
.subckt sky130_fd_sc_hd__and3_2 A B C VGND VNB VPB VPWR X
.ends

* Black-box entry subcircuit for sky130_fd_sc_hd__nand2_2 abstract view
.subckt sky130_fd_sc_hd__nand2_2 A B VGND VNB VPB VPWR Y
.ends

* Black-box entry subcircuit for sky130_fd_sc_hd__a211o_2 abstract view
.subckt sky130_fd_sc_hd__a211o_2 A1 A2 B1 C1 VGND VNB VPB VPWR X
.ends

* Black-box entry subcircuit for sky130_fd_sc_hd__nand3b_2 abstract view
.subckt sky130_fd_sc_hd__nand3b_2 A_N B C VGND VNB VPB VPWR Y
.ends

* Black-box entry subcircuit for sky130_fd_sc_hd__inv_2 abstract view
.subckt sky130_fd_sc_hd__inv_2 A VGND VNB VPB VPWR Y
.ends

* Black-box entry subcircuit for sky130_fd_sc_hd__bufinv_16 abstract view
.subckt sky130_fd_sc_hd__bufinv_16 A VGND VNB VPB VPWR Y
.ends

* Black-box entry subcircuit for sky130_fd_sc_hd__clkinv_2 abstract view
.subckt sky130_fd_sc_hd__clkinv_2 A VGND VNB VPB VPWR Y
.ends

* Black-box entry subcircuit for sky130_fd_sc_hd__nand2b_2 abstract view
.subckt sky130_fd_sc_hd__nand2b_2 A_N B VGND VNB VPB VPWR Y
.ends

* Black-box entry subcircuit for sky130_fd_sc_hd__clkbuf_16 abstract view
.subckt sky130_fd_sc_hd__clkbuf_16 A VGND VNB VPB VPWR X
.ends

* Black-box entry subcircuit for sky130_fd_sc_hd__nand2b_4 abstract view
.subckt sky130_fd_sc_hd__nand2b_4 A_N B VGND VNB VPB VPWR Y
.ends

* Black-box entry subcircuit for sky130_fd_sc_hd__or3_2 abstract view
.subckt sky130_fd_sc_hd__or3_2 A B C VGND VNB VPB VPWR X
.ends

* Black-box entry subcircuit for sky130_fd_sc_hd__a311o_2 abstract view
.subckt sky130_fd_sc_hd__a311o_2 A1 A2 A3 B1 C1 VGND VNB VPB VPWR X
.ends

* Black-box entry subcircuit for sky130_fd_sc_hd__nor2_1 abstract view
.subckt sky130_fd_sc_hd__nor2_1 A B VGND VNB VPB VPWR Y
.ends

* Black-box entry subcircuit for sky130_fd_sc_hd__or2_4 abstract view
.subckt sky130_fd_sc_hd__or2_4 A B VGND VNB VPB VPWR X
.ends

* Black-box entry subcircuit for sky130_fd_sc_hd__nor2_4 abstract view
.subckt sky130_fd_sc_hd__nor2_4 A B VGND VNB VPB VPWR Y
.ends

* Black-box entry subcircuit for sky130_fd_sc_hd__clkinvlp_4 abstract view
.subckt sky130_fd_sc_hd__clkinvlp_4 A VGND VNB VPB VPWR Y
.ends

* Black-box entry subcircuit for sky130_fd_sc_hd__clkdlybuf4s15_2 abstract view
.subckt sky130_fd_sc_hd__clkdlybuf4s15_2 A VGND VNB VPB VPWR X
.ends

* Black-box entry subcircuit for sky130_fd_sc_hd__and4b_2 abstract view
.subckt sky130_fd_sc_hd__and4b_2 A_N B C D VGND VNB VPB VPWR X
.ends

* Black-box entry subcircuit for sky130_fd_sc_hd__or4b_2 abstract view
.subckt sky130_fd_sc_hd__or4b_2 A B C D_N VGND VNB VPB VPWR X
.ends

.subckt registerfile VGND VPWR clk rd1[0] rd1[10] rd1[11] rd1[12] rd1[13] rd1[14]
+ rd1[15] rd1[16] rd1[17] rd1[18] rd1[19] rd1[1] rd1[20] rd1[21] rd1[22] rd1[23] rd1[24]
+ rd1[25] rd1[26] rd1[27] rd1[28] rd1[29] rd1[2] rd1[30] rd1[31] rd1[3] rd1[4] rd1[5]
+ rd1[6] rd1[7] rd1[8] rd1[9] rd2[0] rd2[10] rd2[11] rd2[12] rd2[13] rd2[14] rd2[15]
+ rd2[16] rd2[17] rd2[18] rd2[19] rd2[1] rd2[20] rd2[21] rd2[22] rd2[23] rd2[24] rd2[25]
+ rd2[26] rd2[27] rd2[28] rd2[29] rd2[2] rd2[30] rd2[31] rd2[3] rd2[4] rd2[5] rd2[6]
+ rd2[7] rd2[8] rd2[9] rd[0] rd[1] rd[2] rd[3] rd[4] rs1[0] rs1[1] rs1[2] rs1[3] rs1[4]
+ rs2[0] rs2[1] rs2[2] rs2[3] rs2[4] rst wd[0] wd[10] wd[11] wd[12] wd[13] wd[14]
+ wd[15] wd[16] wd[17] wd[18] wd[19] wd[1] wd[20] wd[21] wd[22] wd[23] wd[24] wd[25]
+ wd[26] wd[27] wd[28] wd[29] wd[2] wd[30] wd[31] wd[3] wd[4] wd[5] wd[6] wd[7] wd[8]
+ wd[9] we
XFILLER_39_222 VGND VGND VPWR VPWR sky130_fd_sc_hd__fill_2
XFILLER_67_520 VGND VGND VPWR VPWR sky130_fd_sc_hd__decap_3
X_3155_ _5844_/Q _5460_/Q _6068_/Q _5972_/Q _3155_/S0 _3157_/S1 VGND VGND VPWR VPWR
+ _3156_/B sky130_fd_sc_hd__mux4_2
X_3086_ _5937_/Q _5905_/Q _5873_/Q _5777_/Q _3088_/S _3086_/S1 VGND VGND VPWR VPWR
+ _3086_/X sky130_fd_sc_hd__mux4_2
XFILLER_22_100 VGND VGND VPWR VPWR sky130_fd_sc_hd__decap_3
XFILLER_82_589 VGND VGND VPWR VPWR sky130_fd_sc_hd__fill_2
XFILLER_62_280 VGND VGND VPWR VPWR sky130_fd_sc_hd__decap_3
XTAP_TAPCELL_ROW_81_1226 VGND VPWR sky130_fd_sc_hd__tapvpwrvgnd_1
XFILLER_22_144 VGND VGND VPWR VPWR sky130_fd_sc_hd__decap_3
XTAP_TAPCELL_ROW_33_640 VGND VPWR sky130_fd_sc_hd__tapvpwrvgnd_1
XTAP_TAPCELL_ROW_33_651 VGND VPWR sky130_fd_sc_hd__tapvpwrvgnd_1
XTAP_TAPCELL_ROW_61_982 VGND VPWR sky130_fd_sc_hd__tapvpwrvgnd_1
X_3988_ _4437_/A _3988_/B VGND VGND VPWR VPWR _3988_/Y sky130_fd_sc_hd__nor2_2
XFILLER_22_177 VGND VGND VPWR VPWR sky130_fd_sc_hd__decap_3
X_5727_ _5802_/CLK _5727_/D VGND VGND VPWR VPWR _5727_/Q sky130_fd_sc_hd__dfxtp_2
X_2939_ _2927_/X _2937_/X _2938_/X _3231_/B1 VGND VGND VPWR VPWR _2939_/X sky130_fd_sc_hd__o31a_2
XFILLER_108_205 VGND VGND VPWR VPWR sky130_fd_sc_hd__decap_3
X_5658_ _5658_/CLK _5658_/D VGND VGND VPWR VPWR _5658_/Q sky130_fd_sc_hd__dfxtp_2
XTAP_TAPCELL_ROW_79_1199 VGND VPWR sky130_fd_sc_hd__tapvpwrvgnd_1
X_5589_ _5589_/CLK _5589_/D VGND VGND VPWR VPWR _5589_/Q sky130_fd_sc_hd__dfxtp_2
X_4609_ _4880_/A1 wire407/A wire186/X _4609_/B2 VGND VGND VPWR VPWR _5656_/D sky130_fd_sc_hd__a22o_2
XFILLER_104_400 VGND VGND VPWR VPWR sky130_fd_sc_hd__fill_1
XFILLER_104_411 VGND VGND VPWR VPWR sky130_fd_sc_hd__fill_1
XFILLER_77_26 VGND VGND VPWR VPWR sky130_fd_sc_hd__decap_3
XTAP_TAPCELL_ROW_92_1355 VGND VPWR sky130_fd_sc_hd__tapvpwrvgnd_1
XFILLER_104_477 VGND VGND VPWR VPWR sky130_fd_sc_hd__decap_3
XFILLER_89_166 VGND VGND VPWR VPWR sky130_fd_sc_hd__fill_2
XTAP_TAPCELL_ROW_5_310 VGND VPWR sky130_fd_sc_hd__tapvpwrvgnd_1
Xfanout842 _3209_/S0 VGND VGND VPWR VPWR _2919_/S sky130_fd_sc_hd__dlymetal6s4s_1
Xfanout831 fanout863/X VGND VGND VPWR VPWR _3194_/S sky130_fd_sc_hd__clkdlybuf4s25_1
Xfanout820 fanout822/X VGND VGND VPWR VPWR fanout820/X sky130_fd_sc_hd__clkdlybuf4s25_1
Xfanout875 input46/X VGND VGND VPWR VPWR _4989_/A1 sky130_fd_sc_hd__clkdlybuf4s25_1
XFILLER_58_575 VGND VGND VPWR VPWR sky130_fd_sc_hd__fill_2
XFILLER_73_501 VGND VGND VPWR VPWR sky130_fd_sc_hd__decap_3
Xfanout897 _4468_/A1 VGND VGND VPWR VPWR _5012_/A1 sky130_fd_sc_hd__clkdlybuf4s25_1
Xfanout886 input43/X VGND VGND VPWR VPWR _4986_/A1 sky130_fd_sc_hd__clkdlybuf4s25_1
XFILLER_45_225 VGND VGND VPWR VPWR sky130_fd_sc_hd__fill_2
XFILLER_73_556 VGND VGND VPWR VPWR sky130_fd_sc_hd__decap_3
XFILLER_26_472 VGND VGND VPWR VPWR sky130_fd_sc_hd__decap_3
XFILLER_14_634 VGND VGND VPWR VPWR sky130_fd_sc_hd__decap_3
XFILLER_14_645 VGND VGND VPWR VPWR sky130_fd_sc_hd__decap_3
XFILLER_60_239 VGND VGND VPWR VPWR sky130_fd_sc_hd__decap_3
XFILLER_14_678 VGND VGND VPWR VPWR sky130_fd_sc_hd__decap_3
XTAP_TAPCELL_ROW_101_1462 VGND VPWR sky130_fd_sc_hd__tapvpwrvgnd_1
XFILLER_5_310 VGND VGND VPWR VPWR sky130_fd_sc_hd__decap_3
XTAP_TAPCELL_ROW_11_378 VGND VPWR sky130_fd_sc_hd__tapvpwrvgnd_1
XFILLER_3_12 VGND VGND VPWR VPWR sky130_fd_sc_hd__decap_3
XFILLER_3_45 VGND VGND VPWR VPWR sky130_fd_sc_hd__decap_3
XFILLER_96_637 VGND VGND VPWR VPWR sky130_fd_sc_hd__decap_3
XFILLER_1_593 VGND VGND VPWR VPWR sky130_fd_sc_hd__decap_3
XTAP_TAPCELL_ROW_112_1591 VGND VPWR sky130_fd_sc_hd__tapvpwrvgnd_1
XFILLER_95_169 VGND VGND VPWR VPWR sky130_fd_sc_hd__decap_3
XFILLER_36_203 VGND VGND VPWR VPWR sky130_fd_sc_hd__fill_1
XFILLER_36_225 VGND VGND VPWR VPWR sky130_fd_sc_hd__decap_3
XFILLER_64_512 VGND VGND VPWR VPWR sky130_fd_sc_hd__decap_3
XFILLER_17_461 VGND VGND VPWR VPWR sky130_fd_sc_hd__fill_2
XFILLER_17_483 VGND VGND VPWR VPWR sky130_fd_sc_hd__decap_3
XFILLER_64_589 VGND VGND VPWR VPWR sky130_fd_sc_hd__decap_3
XFILLER_91_386 VGND VGND VPWR VPWR sky130_fd_sc_hd__decap_3
XTAP_TAPCELL_ROW_19_478 VGND VPWR sky130_fd_sc_hd__tapvpwrvgnd_1
X_4960_ _4994_/A1 _4976_/A2 _4976_/B1 _4960_/B2 VGND VGND VPWR VPWR _5988_/D sky130_fd_sc_hd__a22o_2
XFILLER_44_291 VGND VGND VPWR VPWR sky130_fd_sc_hd__fill_1
X_4891_ _4891_/A1 _4902_/A2 wire139/X _4891_/B2 VGND VGND VPWR VPWR _5923_/D sky130_fd_sc_hd__a22o_2
X_3911_ _5718_/Q _5686_/Q _5654_/Q _5622_/Q _3913_/S _3917_/S1 VGND VGND VPWR VPWR
+ _3912_/B sky130_fd_sc_hd__mux4_2
XFILLER_32_475 VGND VGND VPWR VPWR sky130_fd_sc_hd__fill_1
X_3842_ _3842_/A1 _3840_/X _3841_/X _3239_/Y VGND VGND VPWR VPWR _3842_/X sky130_fd_sc_hd__o22a_2
XFILLER_20_648 VGND VGND VPWR VPWR sky130_fd_sc_hd__fill_1
XFILLER_32_486 VGND VGND VPWR VPWR sky130_fd_sc_hd__decap_3
XTAP_TAPCELL_ROW_30_610 VGND VPWR sky130_fd_sc_hd__tapvpwrvgnd_1
XFILLER_9_671 VGND VGND VPWR VPWR sky130_fd_sc_hd__fill_1
X_5512_ _6024_/CLK _5512_/D VGND VGND VPWR VPWR _5512_/Q sky130_fd_sc_hd__dfxtp_2
X_3773_ _5584_/Q _5552_/Q _3785_/S VGND VGND VPWR VPWR _3773_/X sky130_fd_sc_hd__mux2_1
XFILLER_8_170 VGND VGND VPWR VPWR sky130_fd_sc_hd__fill_2
XFILLER_9_682 VGND VGND VPWR VPWR sky130_fd_sc_hd__decap_3
X_2724_ _5377_/Q _5345_/Q _5313_/Q _5281_/Q _2724_/S0 _2973_/S1 VGND VGND VPWR VPWR
+ _2724_/X sky130_fd_sc_hd__mux4_2
XFILLER_8_192 VGND VGND VPWR VPWR sky130_fd_sc_hd__decap_3
X_5443_ _6051_/CLK _5443_/D VGND VGND VPWR VPWR _5443_/Q sky130_fd_sc_hd__dfxtp_2
X_2655_ _5246_/Q _5214_/Q _2738_/S VGND VGND VPWR VPWR _2655_/X sky130_fd_sc_hd__mux2_1
X_5374_ _5800_/CLK _5374_/D VGND VGND VPWR VPWR _5374_/Q sky130_fd_sc_hd__dfxtp_2
XFILLER_99_442 VGND VGND VPWR VPWR sky130_fd_sc_hd__decap_3
X_4325_ _5007_/A1 _4331_/A2 _4331_/B1 _4325_/B2 VGND VGND VPWR VPWR _5393_/D sky130_fd_sc_hd__a22o_2
X_2586_ _5371_/Q _5339_/Q _5307_/Q _5275_/Q _2589_/S wire760/X VGND VGND VPWR VPWR
+ _2587_/B sky130_fd_sc_hd__mux4_2
XFILLER_86_114 VGND VGND VPWR VPWR sky130_fd_sc_hd__decap_3
XFILLER_87_615 VGND VGND VPWR VPWR sky130_fd_sc_hd__fill_1
XFILLER_99_497 VGND VGND VPWR VPWR sky130_fd_sc_hd__decap_3
Xfanout138 _4879_/Y VGND VGND VPWR VPWR wire139/A sky130_fd_sc_hd__clkdlybuf4s25_1
Xfanout116 _5015_/Y VGND VGND VPWR VPWR _5045_/B1 sky130_fd_sc_hd__clkdlybuf4s25_1
XFILLER_101_447 VGND VGND VPWR VPWR sky130_fd_sc_hd__fill_1
X_4256_ _5040_/A1 _4260_/A2 _4260_/B1 _4256_/B2 VGND VGND VPWR VPWR _5328_/D sky130_fd_sc_hd__a22o_2
XFILLER_74_309 VGND VGND VPWR VPWR sky130_fd_sc_hd__fill_1
X_4187_ _4530_/A1 _4162_/B _4191_/B1 _4187_/B2 VGND VGND VPWR VPWR _5264_/D sky130_fd_sc_hd__a22o_2
X_3207_ _3207_/A1 _3198_/X _3201_/X _3191_/X _3207_/B2 VGND VGND VPWR VPWR _3207_/X
+ sky130_fd_sc_hd__a32o_2
XFILLER_27_225 VGND VGND VPWR VPWR sky130_fd_sc_hd__fill_1
XFILLER_55_523 VGND VGND VPWR VPWR sky130_fd_sc_hd__fill_2
XFILLER_94_180 VGND VGND VPWR VPWR sky130_fd_sc_hd__decap_3
XFILLER_95_681 VGND VGND VPWR VPWR sky130_fd_sc_hd__decap_3
XTAP_TAPCELL_ROW_38_710 VGND VPWR sky130_fd_sc_hd__tapvpwrvgnd_1
X_3138_ _6067_/Q _5971_/Q _3170_/S VGND VGND VPWR VPWR _3138_/X sky130_fd_sc_hd__mux2_1
XFILLER_103_57 VGND VGND VPWR VPWR sky130_fd_sc_hd__fill_1
XFILLER_82_353 VGND VGND VPWR VPWR sky130_fd_sc_hd__decap_3
XFILLER_42_228 VGND VGND VPWR VPWR sky130_fd_sc_hd__decap_3
X_3069_ _5264_/Q _5232_/Q _3069_/S VGND VGND VPWR VPWR _3069_/X sky130_fd_sc_hd__mux2_1
XFILLER_23_475 VGND VGND VPWR VPWR sky130_fd_sc_hd__decap_3
XFILLER_7_608 VGND VGND VPWR VPWR sky130_fd_sc_hd__decap_3
XFILLER_109_525 VGND VGND VPWR VPWR sky130_fd_sc_hd__fill_1
XFILLER_10_169 VGND VGND VPWR VPWR sky130_fd_sc_hd__decap_3
XFILLER_12_32 VGND VGND VPWR VPWR sky130_fd_sc_hd__decap_3
XFILLER_109_569 VGND VGND VPWR VPWR sky130_fd_sc_hd__decap_3
XFILLER_12_65 VGND VGND VPWR VPWR sky130_fd_sc_hd__fill_1
XFILLER_88_58 VGND VGND VPWR VPWR sky130_fd_sc_hd__decap_3
XFILLER_78_637 VGND VGND VPWR VPWR sky130_fd_sc_hd__decap_3
XFILLER_78_648 VGND VGND VPWR VPWR sky130_fd_sc_hd__fill_2
Xfanout650 fanout656/X VGND VGND VPWR VPWR wire651/A sky130_fd_sc_hd__clkdlybuf4s25_1
XFILLER_77_158 VGND VGND VPWR VPWR sky130_fd_sc_hd__fill_1
XFILLER_77_169 VGND VGND VPWR VPWR sky130_fd_sc_hd__fill_2
Xfanout694 _3028_/A1 VGND VGND VPWR VPWR _2830_/A sky130_fd_sc_hd__dlymetal6s2s_1
XFILLER_100_480 VGND VGND VPWR VPWR sky130_fd_sc_hd__decap_3
XFILLER_86_681 VGND VGND VPWR VPWR sky130_fd_sc_hd__decap_3
XFILLER_92_128 VGND VGND VPWR VPWR sky130_fd_sc_hd__decap_3
XFILLER_92_139 VGND VGND VPWR VPWR sky130_fd_sc_hd__fill_1
XFILLER_46_578 VGND VGND VPWR VPWR sky130_fd_sc_hd__fill_1
XFILLER_61_559 VGND VGND VPWR VPWR sky130_fd_sc_hd__fill_1
XTAP_TAPCELL_ROW_16_437 VGND VPWR sky130_fd_sc_hd__tapvpwrvgnd_1
XTAP_TAPCELL_ROW_44_779 VGND VPWR sky130_fd_sc_hd__tapvpwrvgnd_1
XFILLER_14_486 VGND VGND VPWR VPWR sky130_fd_sc_hd__decap_3
XFILLER_6_630 VGND VGND VPWR VPWR sky130_fd_sc_hd__decap_3
XFILLER_6_663 VGND VGND VPWR VPWR sky130_fd_sc_hd__decap_3
XTAP_TAPCELL_ROW_114_1620 VGND VPWR sky130_fd_sc_hd__tapvpwrvgnd_1
XFILLER_69_615 VGND VGND VPWR VPWR sky130_fd_sc_hd__fill_1
XFILLER_96_412 VGND VGND VPWR VPWR sky130_fd_sc_hd__decap_3
XFILLER_110_200 VGND VGND VPWR VPWR sky130_fd_sc_hd__fill_1
XFILLER_69_637 VGND VGND VPWR VPWR sky130_fd_sc_hd__decap_3
Xhold1809 _5099_/Q VGND VGND VPWR VPWR _4008_/B2 sky130_fd_sc_hd__dlygate4sd3_1
X_5090_ _5815_/CLK _5090_/D VGND VGND VPWR VPWR _5090_/Q sky130_fd_sc_hd__dfxtp_2
X_4110_ _4658_/A1 wire516/X wire298/X _4110_/B2 VGND VGND VPWR VPWR _5191_/D sky130_fd_sc_hd__a22o_2
XFILLER_68_158 VGND VGND VPWR VPWR sky130_fd_sc_hd__fill_1
XFILLER_84_618 VGND VGND VPWR VPWR sky130_fd_sc_hd__decap_3
X_4041_ _5033_/A1 _4053_/A2 _4053_/B1 _4041_/B2 VGND VGND VPWR VPWR _5129_/D sky130_fd_sc_hd__a22o_2
XFILLER_110_299 VGND VGND VPWR VPWR sky130_fd_sc_hd__fill_1
XFILLER_37_523 VGND VGND VPWR VPWR sky130_fd_sc_hd__fill_1
XFILLER_49_361 VGND VGND VPWR VPWR sky130_fd_sc_hd__fill_1
XFILLER_37_556 VGND VGND VPWR VPWR sky130_fd_sc_hd__decap_3
XFILLER_64_353 VGND VGND VPWR VPWR sky130_fd_sc_hd__fill_2
XFILLER_92_640 VGND VGND VPWR VPWR sky130_fd_sc_hd__decap_3
XFILLER_91_172 VGND VGND VPWR VPWR sky130_fd_sc_hd__decap_3
X_5992_ _6024_/CLK _5992_/D VGND VGND VPWR VPWR _5992_/Q sky130_fd_sc_hd__dfxtp_2
XTAP_TAPCELL_ROW_65_1029 VGND VPWR sky130_fd_sc_hd__tapvpwrvgnd_1
X_4943_ _4943_/A1 _4943_/A2 _4943_/B1 _4943_/B2 VGND VGND VPWR VPWR _5973_/D sky130_fd_sc_hd__a22o_2
XFILLER_60_592 VGND VGND VPWR VPWR sky130_fd_sc_hd__decap_3
X_4874_ _4908_/A1 _4876_/A2 _4874_/B1 _4874_/B2 VGND VGND VPWR VPWR _5908_/D sky130_fd_sc_hd__a22o_2
XFILLER_20_456 VGND VGND VPWR VPWR sky130_fd_sc_hd__decap_3
X_3825_ _5938_/Q _5906_/Q _5874_/Q _5778_/Q _3326_/S _3826_/S1 VGND VGND VPWR VPWR
+ _3825_/X sky130_fd_sc_hd__mux4_2
Xclkbuf_4_12_0_clk clkbuf_0_clk/X VGND VGND VPWR VPWR clkbuf_4_12_0_clk/X sky130_fd_sc_hd__clkbuf_8
X_3756_ _5807_/Q _5743_/Q _3767_/S VGND VGND VPWR VPWR _3756_/X sky130_fd_sc_hd__mux2_1
X_2707_ _5408_/Q _5056_/Q _3015_/S VGND VGND VPWR VPWR _2707_/X sky130_fd_sc_hd__mux2_1
XTAP_TAPCELL_ROW_76_1158 VGND VPWR sky130_fd_sc_hd__tapvpwrvgnd_1
X_5426_ _5810_/CLK _5426_/D VGND VGND VPWR VPWR _5426_/Q sky130_fd_sc_hd__dfxtp_2
X_3687_ _3687_/A _3687_/B VGND VGND VPWR VPWR _3687_/X sky130_fd_sc_hd__or2_2
X_2638_ _5789_/Q _5725_/Q _2638_/S VGND VGND VPWR VPWR _2638_/X sky130_fd_sc_hd__mux2_1
X_5357_ _5502_/CLK _5357_/D VGND VGND VPWR VPWR _5357_/Q sky130_fd_sc_hd__dfxtp_2
X_2569_ _5818_/Q _5434_/Q _2578_/S VGND VGND VPWR VPWR _2569_/X sky130_fd_sc_hd__mux2_1
XFILLER_101_200 VGND VGND VPWR VPWR sky130_fd_sc_hd__decap_3
X_5288_ _6056_/CLK _5288_/D VGND VGND VPWR VPWR _5288_/Q sky130_fd_sc_hd__dfxtp_2
X_4308_ _4514_/A1 _4327_/A2 wire248/X _4308_/B2 VGND VGND VPWR VPWR _5376_/D sky130_fd_sc_hd__a22o_2
XFILLER_101_266 VGND VGND VPWR VPWR sky130_fd_sc_hd__decap_3
XFILLER_114_12 VGND VGND VPWR VPWR sky130_fd_sc_hd__decap_3
X_4239_ _4719_/A1 _4231_/B _4250_/B1 _4239_/B2 VGND VGND VPWR VPWR _5311_/D sky130_fd_sc_hd__a22o_2
XFILLER_114_56 VGND VGND VPWR VPWR sky130_fd_sc_hd__decap_3
XFILLER_68_681 VGND VGND VPWR VPWR sky130_fd_sc_hd__decap_3
XFILLER_28_545 VGND VGND VPWR VPWR sky130_fd_sc_hd__decap_3
XFILLER_28_589 VGND VGND VPWR VPWR sky130_fd_sc_hd__decap_3
XFILLER_83_662 VGND VGND VPWR VPWR sky130_fd_sc_hd__fill_1
XFILLER_83_684 VGND VGND VPWR VPWR sky130_fd_sc_hd__decap_3
XFILLER_15_228 VGND VGND VPWR VPWR sky130_fd_sc_hd__decap_3
XFILLER_43_559 VGND VGND VPWR VPWR sky130_fd_sc_hd__fill_1
XTAP_TAPCELL_ROW_87_1298 VGND VPWR sky130_fd_sc_hd__tapvpwrvgnd_1
XFILLER_90_15 VGND VGND VPWR VPWR sky130_fd_sc_hd__decap_3
XTAP_TAPCELL_ROW_13_407 VGND VPWR sky130_fd_sc_hd__tapvpwrvgnd_1
XTAP_TAPCELL_ROW_41_738 VGND VPWR sky130_fd_sc_hd__tapvpwrvgnd_1
XFILLER_7_405 VGND VGND VPWR VPWR sky130_fd_sc_hd__decap_3
XFILLER_7_427 VGND VGND VPWR VPWR sky130_fd_sc_hd__decap_3
XFILLER_7_449 VGND VGND VPWR VPWR sky130_fd_sc_hd__fill_2
Xwire325 wire325/A VGND VGND VPWR VPWR wire325/X sky130_fd_sc_hd__clkbuf_4
XFILLER_109_377 VGND VGND VPWR VPWR sky130_fd_sc_hd__decap_3
XFILLER_99_57 VGND VGND VPWR VPWR sky130_fd_sc_hd__decap_3
XFILLER_3_644 VGND VGND VPWR VPWR sky130_fd_sc_hd__decap_3
XFILLER_105_561 VGND VGND VPWR VPWR sky130_fd_sc_hd__decap_3
Xload_slew319 _4019_/B1 VGND VGND VPWR VPWR _4017_/B1 sky130_fd_sc_hd__buf_4
Xload_slew308 fanout307/X VGND VGND VPWR VPWR _4086_/B1 sky130_fd_sc_hd__clkbuf_4
XFILLER_38_309 VGND VGND VPWR VPWR sky130_fd_sc_hd__decap_3
XFILLER_66_607 VGND VGND VPWR VPWR sky130_fd_sc_hd__decap_3
XFILLER_93_404 VGND VGND VPWR VPWR sky130_fd_sc_hd__fill_1
XFILLER_48_94 VGND VGND VPWR VPWR sky130_fd_sc_hd__decap_3
XTAP_TAPCELL_ROW_49_838 VGND VPWR sky130_fd_sc_hd__tapvpwrvgnd_1
Xfanout480 _4264_/Y VGND VGND VPWR VPWR _4297_/A2 sky130_fd_sc_hd__clkdlybuf4s25_1
XFILLER_0_24 VGND VGND VPWR VPWR sky130_fd_sc_hd__decap_3
XFILLER_0_35 VGND VGND VPWR VPWR sky130_fd_sc_hd__decap_3
XFILLER_0_57 VGND VGND VPWR VPWR sky130_fd_sc_hd__decap_3
XFILLER_73_150 VGND VGND VPWR VPWR sky130_fd_sc_hd__decap_3
XFILLER_74_662 VGND VGND VPWR VPWR sky130_fd_sc_hd__decap_3
XFILLER_80_109 VGND VGND VPWR VPWR sky130_fd_sc_hd__decap_3
XFILLER_0_79 VGND VGND VPWR VPWR sky130_fd_sc_hd__decap_3
XTAP_TAPCELL_ROW_29_595 VGND VPWR sky130_fd_sc_hd__tapvpwrvgnd_1
XFILLER_14_250 VGND VGND VPWR VPWR sky130_fd_sc_hd__fill_2
XFILLER_14_261 VGND VGND VPWR VPWR sky130_fd_sc_hd__fill_1
XFILLER_14_283 VGND VGND VPWR VPWR sky130_fd_sc_hd__decap_3
XFILLER_42_592 VGND VGND VPWR VPWR sky130_fd_sc_hd__decap_3
XFILLER_9_33 VGND VGND VPWR VPWR sky130_fd_sc_hd__decap_3
XPHY_EDGE_ROW_104_Right_104 VGND VGND VPWR VPWR sky130_fd_sc_hd__decap_3
X_4590_ _4997_/A1 _4595_/A2 _4600_/B1 _4590_/B2 VGND VGND VPWR VPWR _5639_/D sky130_fd_sc_hd__a22o_2
X_3610_ _5192_/Q _5160_/Q _3841_/S VGND VGND VPWR VPWR _3610_/X sky130_fd_sc_hd__mux2_1
X_3541_ _5253_/Q _5221_/Q _3575_/S VGND VGND VPWR VPWR _3541_/X sky130_fd_sc_hd__mux2_1
XFILLER_50_3 VGND VGND VPWR VPWR sky130_fd_sc_hd__decap_3
X_3472_ _3781_/C1 _3470_/X _3471_/X VGND VGND VPWR VPWR _3484_/B sky130_fd_sc_hd__a21o_2
X_5211_ _5938_/CLK _5211_/D VGND VGND VPWR VPWR _5211_/Q sky130_fd_sc_hd__dfxtp_2
XFILLER_69_434 VGND VGND VPWR VPWR sky130_fd_sc_hd__decap_3
X_5142_ _6000_/CLK _5142_/D VGND VGND VPWR VPWR _5142_/Q sky130_fd_sc_hd__dfxtp_2
XFILLER_111_542 VGND VGND VPWR VPWR sky130_fd_sc_hd__fill_1
Xhold1606 _5699_/Q VGND VGND VPWR VPWR _4654_/B2 sky130_fd_sc_hd__dlygate4sd3_1
Xhold1617 _5148_/Q VGND VGND VPWR VPWR _4064_/B2 sky130_fd_sc_hd__dlygate4sd3_1
Xload_slew864 fanout863/X VGND VGND VPWR VPWR _3155_/S0 sky130_fd_sc_hd__clkbuf_4
Xload_slew853 _3093_/S VGND VGND VPWR VPWR _3083_/S sky130_fd_sc_hd__buf_4
XFILLER_111_575 VGND VGND VPWR VPWR sky130_fd_sc_hd__decap_3
XFILLER_57_629 VGND VGND VPWR VPWR sky130_fd_sc_hd__decap_3
XTAP_TAPCELL_ROW_71_1099 VGND VPWR sky130_fd_sc_hd__tapvpwrvgnd_1
Xhold1628 _5712_/Q VGND VGND VPWR VPWR _4667_/B2 sky130_fd_sc_hd__dlygate4sd3_1
Xhold1639 _5706_/Q VGND VGND VPWR VPWR _4661_/B2 sky130_fd_sc_hd__dlygate4sd3_1
X_5073_ _6053_/CLK _5073_/D VGND VGND VPWR VPWR _5073_/Q sky130_fd_sc_hd__dfxtp_2
X_4024_ _4506_/A1 _4052_/A2 _4052_/B1 _4024_/B2 VGND VGND VPWR VPWR _5112_/D sky130_fd_sc_hd__a22o_2
XFILLER_64_150 VGND VGND VPWR VPWR sky130_fd_sc_hd__decap_3
XFILLER_65_673 VGND VGND VPWR VPWR sky130_fd_sc_hd__decap_3
XFILLER_64_183 VGND VGND VPWR VPWR sky130_fd_sc_hd__decap_3
XFILLER_80_643 VGND VGND VPWR VPWR sky130_fd_sc_hd__fill_1
XFILLER_80_654 VGND VGND VPWR VPWR sky130_fd_sc_hd__fill_1
X_5975_ _6071_/CLK _5975_/D VGND VGND VPWR VPWR _5975_/Q sky130_fd_sc_hd__dfxtp_2
X_4926_ _4926_/A1 wire353/X wire136/X _4926_/B2 VGND VGND VPWR VPWR _5956_/D sky130_fd_sc_hd__a22o_2
XFILLER_20_231 VGND VGND VPWR VPWR sky130_fd_sc_hd__decap_3
X_4857_ _4891_/A1 _4868_/A2 wire146/X _4857_/B2 VGND VGND VPWR VPWR _5891_/D sky130_fd_sc_hd__a22o_2
XFILLER_20_253 VGND VGND VPWR VPWR sky130_fd_sc_hd__decap_3
XFILLER_60_29 VGND VGND VPWR VPWR sky130_fd_sc_hd__fill_1
X_3808_ _5137_/Q _5105_/Q _6033_/Q _6001_/Q _3810_/S _3808_/S1 VGND VGND VPWR VPWR
+ _3808_/X sky130_fd_sc_hd__mux4_2
XFILLER_109_12 VGND VGND VPWR VPWR sky130_fd_sc_hd__decap_3
X_4788_ _4807_/A_N _4788_/B VGND VGND VPWR VPWR _5826_/D sky130_fd_sc_hd__and2b_2
XFILLER_109_45 VGND VGND VPWR VPWR sky130_fd_sc_hd__decap_3
X_3739_ _5806_/Q _5742_/Q _3744_/S VGND VGND VPWR VPWR _3739_/X sky130_fd_sc_hd__mux2_1
XFILLER_109_78 VGND VGND VPWR VPWR sky130_fd_sc_hd__decap_3
X_5409_ _5804_/CLK _5409_/D VGND VGND VPWR VPWR _5409_/Q sky130_fd_sc_hd__dfxtp_2
XFILLER_0_669 VGND VGND VPWR VPWR sky130_fd_sc_hd__decap_3
XFILLER_102_564 VGND VGND VPWR VPWR sky130_fd_sc_hd__decap_3
XFILLER_48_607 VGND VGND VPWR VPWR sky130_fd_sc_hd__fill_1
XFILLER_75_404 VGND VGND VPWR VPWR sky130_fd_sc_hd__decap_3
XFILLER_47_117 VGND VGND VPWR VPWR sky130_fd_sc_hd__decap_3
XFILLER_48_629 VGND VGND VPWR VPWR sky130_fd_sc_hd__decap_3
XTAP_TAPCELL_ROW_89_1316 VGND VPWR sky130_fd_sc_hd__tapvpwrvgnd_1
XFILLER_18_20 VGND VGND VPWR VPWR sky130_fd_sc_hd__decap_3
XFILLER_56_651 VGND VGND VPWR VPWR sky130_fd_sc_hd__fill_1
XFILLER_56_662 VGND VGND VPWR VPWR sky130_fd_sc_hd__decap_3
XFILLER_90_418 VGND VGND VPWR VPWR sky130_fd_sc_hd__fill_2
XFILLER_31_529 VGND VGND VPWR VPWR sky130_fd_sc_hd__fill_2
XFILLER_43_389 VGND VGND VPWR VPWR sky130_fd_sc_hd__decap_3
XTAP_TAPCELL_ROW_26_565 VGND VPWR sky130_fd_sc_hd__tapvpwrvgnd_1
XTAP_TAPCELL_ROW_54_896 VGND VPWR sky130_fd_sc_hd__tapvpwrvgnd_1
XFILLER_24_592 VGND VGND VPWR VPWR sky130_fd_sc_hd__decap_3
XFILLER_34_74 VGND VGND VPWR VPWR sky130_fd_sc_hd__decap_3
XFILLER_34_85 VGND VGND VPWR VPWR sky130_fd_sc_hd__decap_3
XFILLER_109_141 VGND VGND VPWR VPWR sky130_fd_sc_hd__fill_1
Xwire133 wire133/A VGND VGND VPWR VPWR wire133/X sky130_fd_sc_hd__buf_4
Xwire144 wire144/A VGND VGND VPWR VPWR wire144/X sky130_fd_sc_hd__clkbuf_4
Xwire166 wire166/A VGND VGND VPWR VPWR wire166/X sky130_fd_sc_hd__clkbuf_4
Xload_slew127 _4964_/B1 VGND VGND VPWR VPWR _4977_/B1 sky130_fd_sc_hd__buf_4
Xload_slew149 _4861_/B1 VGND VGND VPWR VPWR _4874_/B1 sky130_fd_sc_hd__clkbuf_4
XFILLER_38_117 VGND VGND VPWR VPWR sky130_fd_sc_hd__fill_2
XFILLER_78_275 VGND VGND VPWR VPWR sky130_fd_sc_hd__fill_1
XFILLER_93_212 VGND VGND VPWR VPWR sky130_fd_sc_hd__decap_3
XFILLER_15_6 VGND VGND VPWR VPWR sky130_fd_sc_hd__decap_3
XFILLER_38_139 VGND VGND VPWR VPWR sky130_fd_sc_hd__fill_1
XFILLER_19_364 VGND VGND VPWR VPWR sky130_fd_sc_hd__fill_1
XFILLER_46_150 VGND VGND VPWR VPWR sky130_fd_sc_hd__fill_2
XFILLER_93_278 VGND VGND VPWR VPWR sky130_fd_sc_hd__fill_2
XTAP_TAPCELL_ROW_109_1552 VGND VPWR sky130_fd_sc_hd__tapvpwrvgnd_1
XTAP_TAPCELL_ROW_109_1563 VGND VPWR sky130_fd_sc_hd__tapvpwrvgnd_1
XFILLER_61_186 VGND VGND VPWR VPWR sky130_fd_sc_hd__fill_2
XFILLER_98_3 VGND VGND VPWR VPWR sky130_fd_sc_hd__decap_3
X_5760_ _6048_/CLK _5760_/D VGND VGND VPWR VPWR _5760_/Q sky130_fd_sc_hd__dfxtp_2
X_2972_ _2972_/A1 _2970_/X _2971_/X _3094_/A1 VGND VGND VPWR VPWR _2972_/X sky130_fd_sc_hd__o22a_2
X_5691_ _5691_/CLK _5691_/D VGND VGND VPWR VPWR _5691_/Q sky130_fd_sc_hd__dfxtp_2
X_4711_ _4913_/A _4711_/B VGND VGND VPWR VPWR _4711_/Y sky130_fd_sc_hd__nor2_2
X_4642_ _4913_/A _4642_/B VGND VGND VPWR VPWR _4642_/Y sky130_fd_sc_hd__nor2_2
X_4573_ _5014_/A _4641_/B VGND VGND VPWR VPWR _4573_/Y sky130_fd_sc_hd__nor2_2
XFILLER_115_100 VGND VGND VPWR VPWR sky130_fd_sc_hd__decap_3
X_3524_ _5508_/Q _5476_/Q _3857_/S VGND VGND VPWR VPWR _3524_/X sky130_fd_sc_hd__mux2_1
XFILLER_115_144 VGND VGND VPWR VPWR sky130_fd_sc_hd__decap_3
XTAP_TAPCELL_ROW_73_1128 VGND VPWR sky130_fd_sc_hd__tapvpwrvgnd_1
X_3455_ _5409_/Q _5057_/Q _3645_/S VGND VGND VPWR VPWR _3455_/X sky130_fd_sc_hd__mux2_1
Xhold2104 _5341_/Q VGND VGND VPWR VPWR _4271_/B2 sky130_fd_sc_hd__dlygate4sd3_1
Xhold2115 _5823_/Q VGND VGND VPWR VPWR _4785_/B sky130_fd_sc_hd__dlygate4sd3_1
Xhold2126 _5109_/Q VGND VGND VPWR VPWR _4018_/B2 sky130_fd_sc_hd__dlygate4sd3_1
X_3386_ _6046_/Q _5950_/Q _3609_/S VGND VGND VPWR VPWR _3386_/X sky130_fd_sc_hd__mux2_1
XFILLER_111_372 VGND VGND VPWR VPWR sky130_fd_sc_hd__decap_3
Xhold1403 _5307_/Q VGND VGND VPWR VPWR _4235_/B2 sky130_fd_sc_hd__dlygate4sd3_1
Xhold1414 _5707_/Q VGND VGND VPWR VPWR _4662_/B2 sky130_fd_sc_hd__dlygate4sd3_1
Xhold1425 _5332_/Q VGND VGND VPWR VPWR _4260_/B2 sky130_fd_sc_hd__dlygate4sd3_1
Xhold2137 _5494_/Q VGND VGND VPWR VPWR _4434_/B2 sky130_fd_sc_hd__dlygate4sd3_1
Xhold2148 _5816_/Q VGND VGND VPWR VPWR _4778_/B sky130_fd_sc_hd__dlygate4sd3_1
Xhold2159 _5821_/Q VGND VGND VPWR VPWR _4783_/B sky130_fd_sc_hd__dlygate4sd3_1
Xload_slew683 _2886_/A1 VGND VGND VPWR VPWR _2499_/A sky130_fd_sc_hd__buf_4
Xload_slew661 _2755_/B2 VGND VGND VPWR VPWR _2558_/A sky130_fd_sc_hd__clkbuf_4
X_5125_ _6033_/CLK _5125_/D VGND VGND VPWR VPWR _5125_/Q sky130_fd_sc_hd__dfxtp_2
Xhold1436 _5683_/Q VGND VGND VPWR VPWR _4636_/B2 sky130_fd_sc_hd__dlygate4sd3_1
Xhold1447 _5369_/Q VGND VGND VPWR VPWR _4301_/B2 sky130_fd_sc_hd__dlygate4sd3_1
Xhold1458 _5254_/Q VGND VGND VPWR VPWR _4177_/B2 sky130_fd_sc_hd__dlygate4sd3_1
X_5056_ _5571_/CLK _5056_/D VGND VGND VPWR VPWR _5056_/Q sky130_fd_sc_hd__dfxtp_2
XFILLER_37_150 VGND VGND VPWR VPWR sky130_fd_sc_hd__decap_3
Xhold1469 _5391_/Q VGND VGND VPWR VPWR _4323_/B2 sky130_fd_sc_hd__dlygate4sd3_1
X_4007_ _4695_/A1 wire540/X _4020_/B1 _4007_/B2 VGND VGND VPWR VPWR _5098_/D sky130_fd_sc_hd__a22o_2
XFILLER_111_24 VGND VGND VPWR VPWR sky130_fd_sc_hd__decap_3
XFILLER_25_367 VGND VGND VPWR VPWR sky130_fd_sc_hd__fill_1
XFILLER_52_153 VGND VGND VPWR VPWR sky130_fd_sc_hd__decap_3
XTAP_TAPCELL_ROW_84_1257 VGND VPWR sky130_fd_sc_hd__tapvpwrvgnd_1
XFILLER_111_57 VGND VGND VPWR VPWR sky130_fd_sc_hd__decap_3
XFILLER_13_529 VGND VGND VPWR VPWR sky130_fd_sc_hd__fill_2
XFILLER_40_326 VGND VGND VPWR VPWR sky130_fd_sc_hd__fill_2
XFILLER_52_175 VGND VGND VPWR VPWR sky130_fd_sc_hd__decap_3
XFILLER_53_687 VGND VGND VPWR VPWR sky130_fd_sc_hd__fill_1
X_5958_ _6061_/CLK _5958_/D VGND VGND VPWR VPWR _5958_/Q sky130_fd_sc_hd__dfxtp_2
XTAP_TAPCELL_ROW_23_524 VGND VPWR sky130_fd_sc_hd__tapvpwrvgnd_1
X_4909_ _4943_/A1 _4909_/A2 _4909_/B1 _4909_/B2 VGND VGND VPWR VPWR _5941_/D sky130_fd_sc_hd__a22o_2
XFILLER_21_573 VGND VGND VPWR VPWR sky130_fd_sc_hd__fill_2
XTAP_TAPCELL_ROW_51_866 VGND VPWR sky130_fd_sc_hd__tapvpwrvgnd_1
X_5889_ _6049_/CLK _5889_/D VGND VGND VPWR VPWR _5889_/Q sky130_fd_sc_hd__dfxtp_2
XFILLER_106_133 VGND VGND VPWR VPWR sky130_fd_sc_hd__decap_3
XFILLER_107_645 VGND VGND VPWR VPWR sky130_fd_sc_hd__decap_3
XFILLER_106_144 VGND VGND VPWR VPWR sky130_fd_sc_hd__decap_3
XTAP_TAPCELL_ROW_95_1386 VGND VPWR sky130_fd_sc_hd__tapvpwrvgnd_1
XFILLER_106_177 VGND VGND VPWR VPWR sky130_fd_sc_hd__fill_2
XFILLER_96_58 VGND VGND VPWR VPWR sky130_fd_sc_hd__decap_3
XFILLER_29_63 VGND VGND VPWR VPWR sky130_fd_sc_hd__fill_2
XFILLER_29_640 VGND VGND VPWR VPWR sky130_fd_sc_hd__fill_2
XTAP_TAPCELL_ROW_59_955 VGND VPWR sky130_fd_sc_hd__tapvpwrvgnd_1
XFILLER_29_673 VGND VGND VPWR VPWR sky130_fd_sc_hd__decap_3
Xhold1970 _5729_/Q VGND VGND VPWR VPWR _4686_/B2 sky130_fd_sc_hd__dlygate4sd3_1
Xhold1981 _5348_/Q VGND VGND VPWR VPWR _4278_/B2 sky130_fd_sc_hd__dlygate4sd3_1
XFILLER_16_312 VGND VGND VPWR VPWR sky130_fd_sc_hd__decap_3
XTAP_TAPCELL_ROW_3_282 VGND VPWR sky130_fd_sc_hd__tapvpwrvgnd_1
Xhold1992 _5967_/Q VGND VGND VPWR VPWR _4937_/B2 sky130_fd_sc_hd__dlygate4sd3_1
XFILLER_28_194 VGND VGND VPWR VPWR sky130_fd_sc_hd__fill_2
XFILLER_45_51 VGND VGND VPWR VPWR sky130_fd_sc_hd__decap_3
XFILLER_45_84 VGND VGND VPWR VPWR sky130_fd_sc_hd__decap_3
XTAP_TAPCELL_ROW_104_1493 VGND VPWR sky130_fd_sc_hd__tapvpwrvgnd_1
XFILLER_61_83 VGND VGND VPWR VPWR sky130_fd_sc_hd__decap_3
XFILLER_6_12 VGND VGND VPWR VPWR sky130_fd_sc_hd__decap_3
XANTENNA_5 _3253_/X VGND VGND VPWR VPWR sky130_fd_sc_hd__diode_2
XFILLER_6_56 VGND VGND VPWR VPWR sky130_fd_sc_hd__decap_3
XFILLER_8_599 VGND VGND VPWR VPWR sky130_fd_sc_hd__decap_3
XFILLER_113_626 VGND VGND VPWR VPWR sky130_fd_sc_hd__decap_3
XFILLER_113_659 VGND VGND VPWR VPWR sky130_fd_sc_hd__decap_3
X_3240_ _6040_/Q _5944_/Q _3774_/S VGND VGND VPWR VPWR _3240_/X sky130_fd_sc_hd__mux2_1
XFILLER_100_309 VGND VGND VPWR VPWR sky130_fd_sc_hd__decap_3
XFILLER_39_404 VGND VGND VPWR VPWR sky130_fd_sc_hd__decap_3
X_3171_ _5845_/Q _5461_/Q _3182_/S VGND VGND VPWR VPWR _3171_/X sky130_fd_sc_hd__mux2_1
XFILLER_13_3 VGND VGND VPWR VPWR sky130_fd_sc_hd__decap_3
Xfanout1083 _3818_/S VGND VGND VPWR VPWR _3712_/S sky130_fd_sc_hd__dlymetal6s4s_1
Xfanout1072 _3880_/S VGND VGND VPWR VPWR _3427_/S sky130_fd_sc_hd__clkbuf_2
Xfanout1050 _3805_/S1 VGND VGND VPWR VPWR _3799_/S1 sky130_fd_sc_hd__clkdlybuf4s25_1
Xfanout1094 input11/X VGND VGND VPWR VPWR fanout1094/X sky130_fd_sc_hd__clkdlybuf4s25_1
XFILLER_19_161 VGND VGND VPWR VPWR sky130_fd_sc_hd__decap_3
XFILLER_35_632 VGND VGND VPWR VPWR sky130_fd_sc_hd__decap_3
XFILLER_35_676 VGND VGND VPWR VPWR sky130_fd_sc_hd__decap_3
XFILLER_50_624 VGND VGND VPWR VPWR sky130_fd_sc_hd__decap_3
X_5812_ _5812_/CLK _5812_/D VGND VGND VPWR VPWR _5812_/Q sky130_fd_sc_hd__dfxtp_2
XFILLER_34_197 VGND VGND VPWR VPWR sky130_fd_sc_hd__decap_3
X_5743_ _5871_/CLK _5743_/D VGND VGND VPWR VPWR _5743_/Q sky130_fd_sc_hd__dfxtp_2
X_2955_ _3179_/A1 _2946_/X _2949_/X _2954_/X VGND VGND VPWR VPWR _2955_/X sky130_fd_sc_hd__a31o_2
X_5674_ _5804_/CLK _5674_/D VGND VGND VPWR VPWR _5674_/Q sky130_fd_sc_hd__dfxtp_2
X_2886_ _2886_/A1 _2884_/X _2885_/X _2949_/B2 VGND VGND VPWR VPWR _2886_/X sky130_fd_sc_hd__o22a_2
X_4625_ _4659_/A1 _4625_/A2 _4625_/B1 _4625_/B2 VGND VGND VPWR VPWR _5672_/D sky130_fd_sc_hd__a22o_2
X_4556_ _4658_/A1 _4540_/B _4566_/B1 _4556_/B2 VGND VGND VPWR VPWR _5607_/D sky130_fd_sc_hd__a22o_2
X_3507_ _5188_/Q _5156_/Q _3508_/S VGND VGND VPWR VPWR _3507_/X sky130_fd_sc_hd__mux2_1
X_4487_ _4727_/A1 _4503_/A2 _4503_/B1 _4487_/B2 VGND VGND VPWR VPWR _5543_/D sky130_fd_sc_hd__a22o_2
XFILLER_103_125 VGND VGND VPWR VPWR sky130_fd_sc_hd__fill_2
XFILLER_106_24 VGND VGND VPWR VPWR sky130_fd_sc_hd__decap_3
XFILLER_106_35 VGND VGND VPWR VPWR sky130_fd_sc_hd__decap_3
X_3438_ _5792_/Q _5728_/Q _3727_/S VGND VGND VPWR VPWR _3438_/X sky130_fd_sc_hd__mux2_1
XFILLER_103_169 VGND VGND VPWR VPWR sky130_fd_sc_hd__decap_3
XFILLER_106_68 VGND VGND VPWR VPWR sky130_fd_sc_hd__decap_3
XFILLER_112_681 VGND VGND VPWR VPWR sky130_fd_sc_hd__decap_3
XFILLER_57_201 VGND VGND VPWR VPWR sky130_fd_sc_hd__decap_3
Xhold1200 _6063_/Q VGND VGND VPWR VPWR _5039_/B2 sky130_fd_sc_hd__dlygate4sd3_1
X_3369_ _3470_/S _3366_/X _3368_/X _3823_/B2 VGND VGND VPWR VPWR _3369_/X sky130_fd_sc_hd__o22a_2
XFILLER_57_245 VGND VGND VPWR VPWR sky130_fd_sc_hd__decap_3
XFILLER_97_381 VGND VGND VPWR VPWR sky130_fd_sc_hd__decap_3
Xhold1211 _5202_/Q VGND VGND VPWR VPWR _4121_/B2 sky130_fd_sc_hd__dlygate4sd3_1
Xhold1222 _5763_/Q VGND VGND VPWR VPWR _4723_/B2 sky130_fd_sc_hd__dlygate4sd3_1
Xhold1233 _6023_/Q VGND VGND VPWR VPWR _4997_/B2 sky130_fd_sc_hd__dlygate4sd3_1
Xload_slew491 _4227_/A2 VGND VGND VPWR VPWR _4224_/A2 sky130_fd_sc_hd__buf_2
X_5108_ _6036_/CLK _5108_/D VGND VGND VPWR VPWR _5108_/Q sky130_fd_sc_hd__dfxtp_2
Xhold1244 _5873_/Q VGND VGND VPWR VPWR _4837_/B2 sky130_fd_sc_hd__dlygate4sd3_1
Xhold1255 _5644_/Q VGND VGND VPWR VPWR _4595_/B2 sky130_fd_sc_hd__dlygate4sd3_1
Xhold1266 _5206_/Q VGND VGND VPWR VPWR _4125_/B2 sky130_fd_sc_hd__dlygate4sd3_1
XFILLER_38_470 VGND VGND VPWR VPWR sky130_fd_sc_hd__decap_3
XTAP_TAPCELL_ROW_56_925 VGND VPWR sky130_fd_sc_hd__tapvpwrvgnd_1
Xhold1277 _5249_/Q VGND VGND VPWR VPWR _4172_/B2 sky130_fd_sc_hd__dlygate4sd3_1
Xhold1288 _5511_/Q VGND VGND VPWR VPWR _4453_/B2 sky130_fd_sc_hd__dlygate4sd3_1
Xhold1299 _5140_/Q VGND VGND VPWR VPWR _4052_/B2 sky130_fd_sc_hd__dlygate4sd3_1
X_5039_ _5039_/A1 wire332/X wire118/X _5039_/B2 VGND VGND VPWR VPWR _6063_/D sky130_fd_sc_hd__a22o_2
XFILLER_82_27 VGND VGND VPWR VPWR sky130_fd_sc_hd__fill_1
XTAP_TAPCELL_ROW_0_241 VGND VPWR sky130_fd_sc_hd__tapvpwrvgnd_1
XTAP_TAPCELL_ROW_0_252 VGND VPWR sky130_fd_sc_hd__tapvpwrvgnd_1
XFILLER_26_687 VGND VGND VPWR VPWR sky130_fd_sc_hd__fill_1
XFILLER_41_602 VGND VGND VPWR VPWR sky130_fd_sc_hd__decap_3
XFILLER_82_49 VGND VGND VPWR VPWR sky130_fd_sc_hd__decap_3
XFILLER_13_337 VGND VGND VPWR VPWR sky130_fd_sc_hd__decap_3
XFILLER_41_635 VGND VGND VPWR VPWR sky130_fd_sc_hd__decap_3
XTAP_TAPCELL_ROW_36_682 VGND VPWR sky130_fd_sc_hd__tapvpwrvgnd_1
XFILLER_15_87 VGND VGND VPWR VPWR sky130_fd_sc_hd__decap_3
XTAP_TAPCELL_ROW_97_1415 VGND VPWR sky130_fd_sc_hd__tapvpwrvgnd_1
XFILLER_5_503 VGND VGND VPWR VPWR sky130_fd_sc_hd__fill_1
XFILLER_107_431 VGND VGND VPWR VPWR sky130_fd_sc_hd__decap_3
XFILLER_5_525 VGND VGND VPWR VPWR sky130_fd_sc_hd__fill_1
XFILLER_107_475 VGND VGND VPWR VPWR sky130_fd_sc_hd__decap_3
XFILLER_110_607 VGND VGND VPWR VPWR sky130_fd_sc_hd__decap_3
Xoutput75 _2597_/X VGND VGND VPWR VPWR rd1[3] sky130_fd_sc_hd__clkbuf_2
Xoutput64 _3030_/X VGND VGND VPWR VPWR rd1[22] sky130_fd_sc_hd__clkdlybuf4s25_1
Xoutput53 _2804_/X VGND VGND VPWR VPWR rd1[12] sky130_fd_sc_hd__clkbuf_2
XTAP_TAPCELL_ROW_8_341 VGND VPWR sky130_fd_sc_hd__tapvpwrvgnd_1
XFILLER_103_670 VGND VGND VPWR VPWR sky130_fd_sc_hd__fill_2
XFILLER_110_629 VGND VGND VPWR VPWR sky130_fd_sc_hd__decap_3
Xoutput97 _3771_/X VGND VGND VPWR VPWR rd2[23] sky130_fd_sc_hd__clkbuf_2
Xoutput86 _3550_/X VGND VGND VPWR VPWR rd2[13] sky130_fd_sc_hd__dlymetal6s4s_1
XFILLER_91_513 VGND VGND VPWR VPWR sky130_fd_sc_hd__fill_1
XFILLER_17_643 VGND VGND VPWR VPWR sky130_fd_sc_hd__decap_3
XFILLER_56_94 VGND VGND VPWR VPWR sky130_fd_sc_hd__decap_3
XTAP_TAPCELL_ROW_106_1522 VGND VPWR sky130_fd_sc_hd__tapvpwrvgnd_1
XFILLER_16_153 VGND VGND VPWR VPWR sky130_fd_sc_hd__fill_1
XFILLER_17_687 VGND VGND VPWR VPWR sky130_fd_sc_hd__fill_1
XFILLER_71_281 VGND VGND VPWR VPWR sky130_fd_sc_hd__decap_3
X_2740_ _2830_/A _2737_/X _2739_/X VGND VGND VPWR VPWR _2740_/X sky130_fd_sc_hd__a21o_2
X_2671_ _5695_/Q _5663_/Q _5631_/Q _5599_/Q _2924_/S _3086_/S1 VGND VGND VPWR VPWR
+ _2671_/X sky130_fd_sc_hd__mux4_2
XFILLER_8_374 VGND VGND VPWR VPWR sky130_fd_sc_hd__decap_3
X_4410_ _5022_/A1 _4433_/A2 _4433_/B1 _4410_/B2 VGND VGND VPWR VPWR _5470_/D sky130_fd_sc_hd__a22o_2
X_5390_ _5838_/CLK _5390_/D VGND VGND VPWR VPWR _5390_/Q sky130_fd_sc_hd__dfxtp_2
XFILLER_98_112 VGND VGND VPWR VPWR sky130_fd_sc_hd__decap_3
X_4341_ _4989_/A1 _4333_/B _4360_/B1 _4341_/B2 VGND VGND VPWR VPWR _5407_/D sky130_fd_sc_hd__a22o_2
XFILLER_98_134 VGND VGND VPWR VPWR sky130_fd_sc_hd__decap_3
XFILLER_99_657 VGND VGND VPWR VPWR sky130_fd_sc_hd__decap_3
Xfanout309 _4023_/Y VGND VGND VPWR VPWR _4040_/B1 sky130_fd_sc_hd__clkdlybuf4s25_1
X_4272_ _4886_/A1 _4292_/A2 _4295_/B1 _4272_/B2 VGND VGND VPWR VPWR _5342_/D sky130_fd_sc_hd__a22o_2
XFILLER_100_106 VGND VGND VPWR VPWR sky130_fd_sc_hd__fill_2
X_6011_ _6042_/CLK _6011_/D VGND VGND VPWR VPWR _6011_/Q sky130_fd_sc_hd__dfxtp_2
X_3223_ _3081_/A _3219_/X _3222_/X _3223_/C1 VGND VGND VPWR VPWR _3223_/X sky130_fd_sc_hd__o211a_2
XFILLER_94_340 VGND VGND VPWR VPWR sky130_fd_sc_hd__decap_3
XFILLER_94_362 VGND VGND VPWR VPWR sky130_fd_sc_hd__fill_2
X_3154_ _3198_/A _3154_/B VGND VGND VPWR VPWR _3154_/X sky130_fd_sc_hd__or2_2
XFILLER_94_384 VGND VGND VPWR VPWR sky130_fd_sc_hd__decap_3
X_3085_ _3230_/B2 _3081_/X _3084_/X _3079_/X VGND VGND VPWR VPWR _3085_/X sky130_fd_sc_hd__a31o_2
XFILLER_82_568 VGND VGND VPWR VPWR sky130_fd_sc_hd__decap_3
XTAP_TAPCELL_ROW_81_1216 VGND VPWR sky130_fd_sc_hd__tapvpwrvgnd_1
XTAP_TAPCELL_ROW_81_1227 VGND VPWR sky130_fd_sc_hd__tapvpwrvgnd_1
XFILLER_22_156 VGND VGND VPWR VPWR sky130_fd_sc_hd__decap_3
XFILLER_23_679 VGND VGND VPWR VPWR sky130_fd_sc_hd__decap_3
XTAP_TAPCELL_ROW_33_641 VGND VPWR sky130_fd_sc_hd__tapvpwrvgnd_1
X_3987_ _4844_/A _4980_/A VGND VGND VPWR VPWR _3987_/Y sky130_fd_sc_hd__nor2_2
XTAP_TAPCELL_ROW_61_983 VGND VPWR sky130_fd_sc_hd__tapvpwrvgnd_1
X_5726_ _5790_/CLK _5726_/D VGND VGND VPWR VPWR _5726_/Q sky130_fd_sc_hd__dfxtp_2
X_2938_ _3230_/B2 _2929_/X _2932_/X _2922_/X _3223_/C1 VGND VGND VPWR VPWR _2938_/X
+ sky130_fd_sc_hd__a32o_2
X_5657_ _5785_/CLK _5657_/D VGND VGND VPWR VPWR _5657_/Q sky130_fd_sc_hd__dfxtp_2
X_2869_ _3215_/A _2865_/X _2868_/X _3224_/A1 VGND VGND VPWR VPWR _2869_/X sky130_fd_sc_hd__o211a_2
X_5588_ _5956_/CLK _5588_/D VGND VGND VPWR VPWR _5588_/Q sky130_fd_sc_hd__dfxtp_2
X_4608_ _4879_/A _4608_/B VGND VGND VPWR VPWR _4608_/Y sky130_fd_sc_hd__nor2_2
XFILLER_89_101 VGND VGND VPWR VPWR sky130_fd_sc_hd__decap_3
X_4539_ _4946_/B _4641_/B VGND VGND VPWR VPWR _4539_/Y sky130_fd_sc_hd__nor2_2
XTAP_TAPCELL_ROW_92_1356 VGND VPWR sky130_fd_sc_hd__tapvpwrvgnd_1
XTAP_TAPCELL_ROW_5_311 VGND VPWR sky130_fd_sc_hd__tapvpwrvgnd_1
Xfanout810 fanout820/X VGND VGND VPWR VPWR _3104_/S sky130_fd_sc_hd__dlymetal6s2s_1
XFILLER_58_521 VGND VGND VPWR VPWR sky130_fd_sc_hd__decap_3
Xfanout876 input46/X VGND VGND VPWR VPWR _4753_/A1 sky130_fd_sc_hd__clkdlybuf4s25_1
Xfanout865 input48/X VGND VGND VPWR VPWR _4515_/A1 sky130_fd_sc_hd__clkdlybuf4s25_1
Xfanout854 _2971_/S VGND VGND VPWR VPWR _3077_/S sky130_fd_sc_hd__clkbuf_2
XFILLER_100_640 VGND VGND VPWR VPWR sky130_fd_sc_hd__decap_3
XFILLER_85_340 VGND VGND VPWR VPWR sky130_fd_sc_hd__decap_3
XFILLER_93_15 VGND VGND VPWR VPWR sky130_fd_sc_hd__decap_3
Xfanout898 _4468_/A1 VGND VGND VPWR VPWR _4776_/A1 sky130_fd_sc_hd__clkdlybuf4s25_1
Xfanout887 input43/X VGND VGND VPWR VPWR _4750_/A1 sky130_fd_sc_hd__clkdlybuf4s25_1
XFILLER_18_429 VGND VGND VPWR VPWR sky130_fd_sc_hd__decap_3
XFILLER_13_101 VGND VGND VPWR VPWR sky130_fd_sc_hd__decap_3
XFILLER_14_657 VGND VGND VPWR VPWR sky130_fd_sc_hd__decap_3
XFILLER_26_97 VGND VGND VPWR VPWR sky130_fd_sc_hd__fill_2
XFILLER_41_410 VGND VGND VPWR VPWR sky130_fd_sc_hd__decap_3
XFILLER_53_281 VGND VGND VPWR VPWR sky130_fd_sc_hd__decap_3
XFILLER_13_134 VGND VGND VPWR VPWR sky130_fd_sc_hd__decap_3
XFILLER_42_52 VGND VGND VPWR VPWR sky130_fd_sc_hd__decap_3
XFILLER_9_138 VGND VGND VPWR VPWR sky130_fd_sc_hd__decap_3
XTAP_TAPCELL_ROW_101_1463 VGND VPWR sky130_fd_sc_hd__tapvpwrvgnd_1
XTAP_TAPCELL_ROW_11_379 VGND VPWR sky130_fd_sc_hd__tapvpwrvgnd_1
XFILLER_5_333 VGND VGND VPWR VPWR sky130_fd_sc_hd__decap_3
XPHY_EDGE_ROW_39_Left_155 VGND VGND VPWR VPWR sky130_fd_sc_hd__decap_3
XFILLER_3_24 VGND VGND VPWR VPWR sky130_fd_sc_hd__decap_3
XFILLER_96_616 VGND VGND VPWR VPWR sky130_fd_sc_hd__fill_1
XFILLER_1_572 VGND VGND VPWR VPWR sky130_fd_sc_hd__decap_3
XFILLER_3_57 VGND VGND VPWR VPWR sky130_fd_sc_hd__decap_3
XFILLER_67_60 VGND VGND VPWR VPWR sky130_fd_sc_hd__decap_3
XTAP_TAPCELL_ROW_112_1592 VGND VPWR sky130_fd_sc_hd__tapvpwrvgnd_1
XFILLER_67_71 VGND VGND VPWR VPWR sky130_fd_sc_hd__fill_2
XFILLER_64_557 VGND VGND VPWR VPWR sky130_fd_sc_hd__decap_3
XFILLER_91_343 VGND VGND VPWR VPWR sky130_fd_sc_hd__fill_2
XPHY_EDGE_ROW_48_Left_164 VGND VGND VPWR VPWR sky130_fd_sc_hd__decap_3
XTAP_TAPCELL_ROW_19_479 VGND VPWR sky130_fd_sc_hd__tapvpwrvgnd_1
Xload_slew1071 _3841_/S VGND VGND VPWR VPWR _3487_/S sky130_fd_sc_hd__clkbuf_4
Xload_slew1082 _3721_/S VGND VGND VPWR VPWR _3558_/S sky130_fd_sc_hd__buf_4
Xload_slew1093 _3830_/S VGND VGND VPWR VPWR _3375_/S sky130_fd_sc_hd__clkbuf_4
XFILLER_17_495 VGND VGND VPWR VPWR sky130_fd_sc_hd__decap_3
XFILLER_83_92 VGND VGND VPWR VPWR sky130_fd_sc_hd__decap_3
X_4890_ _5026_/A1 _4909_/A2 _4909_/B1 _4890_/B2 VGND VGND VPWR VPWR _5922_/D sky130_fd_sc_hd__a22o_2
X_3910_ _3916_/A1 _3907_/X _3909_/X _3906_/X VGND VGND VPWR VPWR _3910_/X sky130_fd_sc_hd__o211a_2
XFILLER_20_616 VGND VGND VPWR VPWR sky130_fd_sc_hd__fill_2
X_3841_ _5523_/Q _5491_/Q _3841_/S VGND VGND VPWR VPWR _3841_/X sky130_fd_sc_hd__mux2_1
XFILLER_80_3 VGND VGND VPWR VPWR sky130_fd_sc_hd__fill_1
XTAP_TAPCELL_ROW_30_611 VGND VPWR sky130_fd_sc_hd__tapvpwrvgnd_1
X_3772_ _5392_/Q _5360_/Q _5328_/Q _5296_/Q _3785_/S _3772_/S1 VGND VGND VPWR VPWR
+ _3772_/X sky130_fd_sc_hd__mux4_2
X_5511_ _5514_/CLK _5511_/D VGND VGND VPWR VPWR _5511_/Q sky130_fd_sc_hd__dfxtp_2
X_2723_ _3230_/A1 _2719_/X _2722_/X _2717_/X VGND VGND VPWR VPWR _2723_/X sky130_fd_sc_hd__a31o_2
XPHY_EDGE_ROW_57_Left_173 VGND VGND VPWR VPWR sky130_fd_sc_hd__decap_3
X_5442_ _6050_/CLK _5442_/D VGND VGND VPWR VPWR _5442_/Q sky130_fd_sc_hd__dfxtp_2
X_2654_ _5182_/Q _5150_/Q _2738_/S VGND VGND VPWR VPWR _2654_/X sky130_fd_sc_hd__mux2_1
X_5373_ _5922_/CLK _5373_/D VGND VGND VPWR VPWR _5373_/Q sky130_fd_sc_hd__dfxtp_2
X_2585_ _2572_/A _2576_/X _2579_/X _2584_/X VGND VGND VPWR VPWR _2585_/X sky130_fd_sc_hd__a31o_2
X_4324_ _5040_/A1 _4299_/B _4328_/B1 _4324_/B2 VGND VGND VPWR VPWR _5392_/D sky130_fd_sc_hd__a22o_2
XFILLER_99_476 VGND VGND VPWR VPWR sky130_fd_sc_hd__decap_3
Xfanout128 _4947_/Y VGND VGND VPWR VPWR _4974_/B1 sky130_fd_sc_hd__clkdlybuf4s25_1
Xfanout117 _5015_/Y VGND VGND VPWR VPWR wire118/A sky130_fd_sc_hd__clkdlybuf4s25_1
X_4255_ _4529_/A1 _4260_/A2 _4260_/B1 _4255_/B2 VGND VGND VPWR VPWR _5327_/D sky130_fd_sc_hd__a22o_2
XFILLER_86_159 VGND VGND VPWR VPWR sky130_fd_sc_hd__decap_3
X_4186_ _5005_/A1 _4188_/A2 _4191_/B1 _4186_/B2 VGND VGND VPWR VPWR _5263_/D sky130_fd_sc_hd__a22o_2
X_3206_ _3206_/A1 _3202_/X _3205_/X _3206_/C1 VGND VGND VPWR VPWR _3206_/X sky130_fd_sc_hd__o211a_2
XPHY_EDGE_ROW_66_Left_182 VGND VGND VPWR VPWR sky130_fd_sc_hd__decap_3
XTAP_TAPCELL_ROW_38_700 VGND VPWR sky130_fd_sc_hd__tapvpwrvgnd_1
XTAP_TAPCELL_ROW_38_711 VGND VPWR sky130_fd_sc_hd__tapvpwrvgnd_1
X_3137_ _5843_/Q _5459_/Q _3170_/S VGND VGND VPWR VPWR _3137_/X sky130_fd_sc_hd__mux2_1
XFILLER_82_365 VGND VGND VPWR VPWR sky130_fd_sc_hd__fill_1
X_3068_ _5136_/Q _5104_/Q _6032_/Q _6000_/Q _3069_/S wire772/X VGND VGND VPWR VPWR
+ _3068_/X sky130_fd_sc_hd__mux4_2
XFILLER_35_281 VGND VGND VPWR VPWR sky130_fd_sc_hd__decap_3
XFILLER_23_465 VGND VGND VPWR VPWR sky130_fd_sc_hd__fill_1
XFILLER_50_273 VGND VGND VPWR VPWR sky130_fd_sc_hd__fill_2
XFILLER_10_148 VGND VGND VPWR VPWR sky130_fd_sc_hd__decap_3
XPHY_EDGE_ROW_75_Left_191 VGND VGND VPWR VPWR sky130_fd_sc_hd__decap_3
Xwire518 wire518/A VGND VGND VPWR VPWR wire518/X sky130_fd_sc_hd__clkbuf_4
XFILLER_109_537 VGND VGND VPWR VPWR sky130_fd_sc_hd__fill_1
XFILLER_6_119 VGND VGND VPWR VPWR sky130_fd_sc_hd__decap_3
X_5709_ _6034_/CLK _5709_/D VGND VGND VPWR VPWR _5709_/Q sky130_fd_sc_hd__dfxtp_2
XFILLER_12_88 VGND VGND VPWR VPWR sky130_fd_sc_hd__decap_3
XFILLER_2_303 VGND VGND VPWR VPWR sky130_fd_sc_hd__decap_3
XFILLER_104_253 VGND VGND VPWR VPWR sky130_fd_sc_hd__decap_3
XFILLER_77_104 VGND VGND VPWR VPWR sky130_fd_sc_hd__decap_3
Xfanout640 wire647/A VGND VGND VPWR VPWR wire641/A sky130_fd_sc_hd__clkdlybuf4s25_1
Xfanout684 _3205_/B2 VGND VGND VPWR VPWR wire685/A sky130_fd_sc_hd__dlymetal6s2s_1
Xfanout662 _2502_/X VGND VGND VPWR VPWR _3027_/B2 sky130_fd_sc_hd__clkbuf_2
XFILLER_37_41 VGND VGND VPWR VPWR sky130_fd_sc_hd__decap_3
XFILLER_18_226 VGND VGND VPWR VPWR sky130_fd_sc_hd__fill_1
XFILLER_37_85 VGND VGND VPWR VPWR sky130_fd_sc_hd__fill_1
XFILLER_14_421 VGND VGND VPWR VPWR sky130_fd_sc_hd__decap_3
XFILLER_26_270 VGND VGND VPWR VPWR sky130_fd_sc_hd__fill_1
XTAP_TAPCELL_ROW_16_438 VGND VPWR sky130_fd_sc_hd__tapvpwrvgnd_1
XFILLER_10_682 VGND VGND VPWR VPWR sky130_fd_sc_hd__decap_3
XFILLER_108_570 VGND VGND VPWR VPWR sky130_fd_sc_hd__fill_2
XFILLER_6_675 VGND VGND VPWR VPWR sky130_fd_sc_hd__decap_3
XTAP_TAPCELL_ROW_114_1621 VGND VPWR sky130_fd_sc_hd__tapvpwrvgnd_1
XFILLER_45_6 VGND VGND VPWR VPWR sky130_fd_sc_hd__decap_3
XFILLER_96_424 VGND VGND VPWR VPWR sky130_fd_sc_hd__decap_3
X_4040_ _4998_/A1 _4040_/A2 _4040_/B1 _4040_/B2 VGND VGND VPWR VPWR _5128_/D sky130_fd_sc_hd__a22o_2
XFILLER_77_671 VGND VGND VPWR VPWR sky130_fd_sc_hd__fill_1
XFILLER_24_218 VGND VGND VPWR VPWR sky130_fd_sc_hd__fill_1
XFILLER_52_516 VGND VGND VPWR VPWR sky130_fd_sc_hd__decap_3
X_5991_ _6023_/CLK _5991_/D VGND VGND VPWR VPWR _5991_/Q sky130_fd_sc_hd__dfxtp_2
X_4942_ _5044_/A1 wire353/X wire136/X _4942_/B2 VGND VGND VPWR VPWR _5972_/D sky130_fd_sc_hd__a22o_2
X_4873_ _5043_/A1 _4873_/A2 wire146/X _4873_/B2 VGND VGND VPWR VPWR _5907_/D sky130_fd_sc_hd__a22o_2
X_3824_ _3831_/A1 _3821_/X _3823_/X VGND VGND VPWR VPWR _3824_/X sky130_fd_sc_hd__o21a_2
X_3755_ _5423_/Q _5071_/Q _3767_/S VGND VGND VPWR VPWR _3755_/X sky130_fd_sc_hd__mux2_1
X_3686_ _5388_/Q _5356_/Q _5324_/Q _5292_/Q _3689_/S _3686_/S1 VGND VGND VPWR VPWR
+ _3687_/B sky130_fd_sc_hd__mux4_2
X_2706_ _5696_/Q _5664_/Q _5632_/Q _5600_/Q _2708_/S _3013_/S1 VGND VGND VPWR VPWR
+ _2706_/X sky130_fd_sc_hd__mux4_2
XFILLER_106_518 VGND VGND VPWR VPWR sky130_fd_sc_hd__decap_3
XPHY_EDGE_ROW_12_Right_12 VGND VGND VPWR VPWR sky130_fd_sc_hd__decap_3
X_5425_ _6053_/CLK _5425_/D VGND VGND VPWR VPWR _5425_/Q sky130_fd_sc_hd__dfxtp_2
X_2637_ _5405_/Q _5053_/Q _2638_/S VGND VGND VPWR VPWR _2637_/X sky130_fd_sc_hd__mux2_1
XTAP_TAPCELL_ROW_76_1159 VGND VPWR sky130_fd_sc_hd__tapvpwrvgnd_1
XFILLER_114_562 VGND VGND VPWR VPWR sky130_fd_sc_hd__decap_3
XFILLER_99_251 VGND VGND VPWR VPWR sky130_fd_sc_hd__decap_3
X_5356_ _6017_/CLK _5356_/D VGND VGND VPWR VPWR _5356_/Q sky130_fd_sc_hd__dfxtp_2
X_2568_ _5914_/Q _5882_/Q _5850_/Q _5754_/Q _2578_/S wire760/A VGND VGND VPWR VPWR
+ _2568_/X sky130_fd_sc_hd__mux4_2
XFILLER_114_595 VGND VGND VPWR VPWR sky130_fd_sc_hd__decap_3
XFILLER_99_273 VGND VGND VPWR VPWR sky130_fd_sc_hd__decap_3
XFILLER_99_284 VGND VGND VPWR VPWR sky130_fd_sc_hd__decap_3
X_5287_ _5832_/CLK _5287_/D VGND VGND VPWR VPWR _5287_/Q sky130_fd_sc_hd__dfxtp_2
X_4307_ _4719_/A1 _4299_/B _4318_/B1 _4307_/B2 VGND VGND VPWR VPWR _5375_/D sky130_fd_sc_hd__a22o_2
X_2499_ _2499_/A _2885_/S _3073_/A1 VGND VGND VPWR VPWR _2499_/X sky130_fd_sc_hd__or3b_4
XFILLER_114_24 VGND VGND VPWR VPWR sky130_fd_sc_hd__decap_3
XFILLER_59_148 VGND VGND VPWR VPWR sky130_fd_sc_hd__decap_3
X_4238_ _4886_/A1 _4258_/A2 _4261_/B1 _4238_/B2 VGND VGND VPWR VPWR _5310_/D sky130_fd_sc_hd__a22o_2
XFILLER_101_278 VGND VGND VPWR VPWR sky130_fd_sc_hd__fill_2
XFILLER_114_35 VGND VGND VPWR VPWR sky130_fd_sc_hd__decap_3
XFILLER_74_107 VGND VGND VPWR VPWR sky130_fd_sc_hd__decap_3
XFILLER_114_68 VGND VGND VPWR VPWR sky130_fd_sc_hd__decap_3
XFILLER_83_641 VGND VGND VPWR VPWR sky130_fd_sc_hd__decap_3
Xclkbuf_leaf_94_clk clkload0/A VGND VGND VPWR VPWR _5813_/CLK sky130_fd_sc_hd__clkbuf_8
X_4169_ _4988_/A1 _4189_/A2 wire283/X _4169_/B2 VGND VGND VPWR VPWR _5246_/D sky130_fd_sc_hd__a22o_2
XPHY_EDGE_ROW_21_Right_21 VGND VGND VPWR VPWR sky130_fd_sc_hd__decap_3
XTAP_TAPCELL_ROW_87_1299 VGND VPWR sky130_fd_sc_hd__tapvpwrvgnd_1
XTAP_TAPCELL_ROW_87_1288 VGND VPWR sky130_fd_sc_hd__tapvpwrvgnd_1
XFILLER_51_582 VGND VGND VPWR VPWR sky130_fd_sc_hd__decap_3
XTAP_TAPCELL_ROW_13_408 VGND VPWR sky130_fd_sc_hd__tapvpwrvgnd_1
XTAP_TAPCELL_ROW_41_739 VGND VPWR sky130_fd_sc_hd__tapvpwrvgnd_1
XFILLER_11_457 VGND VGND VPWR VPWR sky130_fd_sc_hd__decap_3
XFILLER_23_65 VGND VGND VPWR VPWR sky130_fd_sc_hd__fill_1
XFILLER_7_417 VGND VGND VPWR VPWR sky130_fd_sc_hd__decap_3
XPHY_EDGE_ROW_30_Right_30 VGND VGND VPWR VPWR sky130_fd_sc_hd__decap_3
XTAP_TAPCELL_ROW_21_496 VGND VPWR sky130_fd_sc_hd__tapvpwrvgnd_1
XFILLER_109_389 VGND VGND VPWR VPWR sky130_fd_sc_hd__decap_3
XFILLER_3_601 VGND VGND VPWR VPWR sky130_fd_sc_hd__decap_3
XFILLER_3_623 VGND VGND VPWR VPWR sky130_fd_sc_hd__decap_3
XFILLER_3_656 VGND VGND VPWR VPWR sky130_fd_sc_hd__decap_3
XFILLER_78_402 VGND VGND VPWR VPWR sky130_fd_sc_hd__fill_1
XFILLER_59_682 VGND VGND VPWR VPWR sky130_fd_sc_hd__decap_3
XTAP_TAPCELL_ROW_49_839 VGND VPWR sky130_fd_sc_hd__tapvpwrvgnd_1
Xfanout492 _4196_/Y VGND VGND VPWR VPWR _4226_/A2 sky130_fd_sc_hd__clkdlybuf4s25_1
Xfanout481 _4230_/Y VGND VGND VPWR VPWR wire482/A sky130_fd_sc_hd__clkdlybuf4s25_1
Xfanout470 _4298_/Y VGND VGND VPWR VPWR _4328_/A2 sky130_fd_sc_hd__clkdlybuf4s25_1
XFILLER_58_192 VGND VGND VPWR VPWR sky130_fd_sc_hd__decap_3
XFILLER_74_641 VGND VGND VPWR VPWR sky130_fd_sc_hd__decap_3
Xclkbuf_leaf_85_clk clkbuf_4_4_0_clk/X VGND VGND VPWR VPWR _5659_/CLK sky130_fd_sc_hd__clkbuf_8
XFILLER_0_47 VGND VGND VPWR VPWR sky130_fd_sc_hd__decap_3
XFILLER_34_516 VGND VGND VPWR VPWR sky130_fd_sc_hd__decap_3
XFILLER_46_365 VGND VGND VPWR VPWR sky130_fd_sc_hd__fill_1
XFILLER_64_50 VGND VGND VPWR VPWR sky130_fd_sc_hd__decap_3
XTAP_TAPCELL_ROW_29_596 VGND VPWR sky130_fd_sc_hd__tapvpwrvgnd_1
XFILLER_64_83 VGND VGND VPWR VPWR sky130_fd_sc_hd__fill_1
XFILLER_9_12 VGND VGND VPWR VPWR sky130_fd_sc_hd__decap_3
XFILLER_9_45 VGND VGND VPWR VPWR sky130_fd_sc_hd__decap_3
XFILLER_14_295 VGND VGND VPWR VPWR sky130_fd_sc_hd__decap_3
XFILLER_80_60 VGND VGND VPWR VPWR sky130_fd_sc_hd__fill_2
XFILLER_80_82 VGND VGND VPWR VPWR sky130_fd_sc_hd__fill_2
X_3540_ _3906_/A _3540_/B VGND VGND VPWR VPWR _3540_/X sky130_fd_sc_hd__or2_2
XFILLER_10_490 VGND VGND VPWR VPWR sky130_fd_sc_hd__decap_3
XFILLER_6_472 VGND VGND VPWR VPWR sky130_fd_sc_hd__decap_3
X_5210_ _6042_/CLK _5210_/D VGND VGND VPWR VPWR _5210_/Q sky130_fd_sc_hd__dfxtp_2
X_3471_ _3612_/C1 _3467_/X _3471_/B1 VGND VGND VPWR VPWR _3471_/X sky130_fd_sc_hd__a21o_2
XFILLER_43_3 VGND VGND VPWR VPWR sky130_fd_sc_hd__decap_3
Xload_slew832 _3194_/S VGND VGND VPWR VPWR _3070_/S sky130_fd_sc_hd__buf_4
Xload_slew821 fanout820/X VGND VGND VPWR VPWR _2736_/S0 sky130_fd_sc_hd__buf_2
X_5141_ _6037_/CLK _5141_/D VGND VGND VPWR VPWR _5141_/Q sky130_fd_sc_hd__dfxtp_2
Xhold1607 _5489_/Q VGND VGND VPWR VPWR _4429_/B2 sky130_fd_sc_hd__dlygate4sd3_1
Xload_slew843 _2919_/S VGND VGND VPWR VPWR _2856_/S sky130_fd_sc_hd__clkbuf_4
X_5072_ _6059_/CLK _5072_/D VGND VGND VPWR VPWR _5072_/Q sky130_fd_sc_hd__dfxtp_2
XFILLER_111_587 VGND VGND VPWR VPWR sky130_fd_sc_hd__decap_3
XFILLER_84_438 VGND VGND VPWR VPWR sky130_fd_sc_hd__decap_3
XFILLER_96_287 VGND VGND VPWR VPWR sky130_fd_sc_hd__decap_3
Xhold1618 _5670_/Q VGND VGND VPWR VPWR _4623_/B2 sky130_fd_sc_hd__dlygate4sd3_1
Xhold1629 _5269_/Q VGND VGND VPWR VPWR _4192_/B2 sky130_fd_sc_hd__dlygate4sd3_1
X_4023_ _4981_/A _4023_/B VGND VGND VPWR VPWR _4023_/Y sky130_fd_sc_hd__nor2_2
Xclkbuf_leaf_76_clk clkload2/A VGND VGND VPWR VPWR _6029_/CLK sky130_fd_sc_hd__clkbuf_8
XFILLER_25_505 VGND VGND VPWR VPWR sky130_fd_sc_hd__fill_1
XFILLER_25_549 VGND VGND VPWR VPWR sky130_fd_sc_hd__fill_1
XFILLER_64_162 VGND VGND VPWR VPWR sky130_fd_sc_hd__decap_3
XFILLER_64_195 VGND VGND VPWR VPWR sky130_fd_sc_hd__fill_1
X_5974_ _6070_/CLK _5974_/D VGND VGND VPWR VPWR _5974_/Q sky130_fd_sc_hd__dfxtp_2
XFILLER_100_15 VGND VGND VPWR VPWR sky130_fd_sc_hd__decap_3
X_4925_ _5027_/A1 _4936_/A2 wire133/X _4925_/B2 VGND VGND VPWR VPWR _5955_/D sky130_fd_sc_hd__a22o_2
XFILLER_20_210 VGND VGND VPWR VPWR sky130_fd_sc_hd__fill_2
X_4856_ _5026_/A1 _4875_/A2 _4875_/B1 _4856_/B2 VGND VGND VPWR VPWR _5890_/D sky130_fd_sc_hd__a22o_2
XFILLER_20_265 VGND VGND VPWR VPWR sky130_fd_sc_hd__decap_3
X_3807_ _3800_/A _3804_/X _3806_/X _3939_/A1 VGND VGND VPWR VPWR _3807_/X sky130_fd_sc_hd__o211a_2
X_4787_ wire1003/X _4787_/B VGND VGND VPWR VPWR _5825_/D sky130_fd_sc_hd__and2b_2
XFILLER_106_315 VGND VGND VPWR VPWR sky130_fd_sc_hd__decap_3
XFILLER_109_24 VGND VGND VPWR VPWR sky130_fd_sc_hd__decap_3
XFILLER_114_9 VGND VGND VPWR VPWR sky130_fd_sc_hd__decap_3
X_3738_ _3738_/A _3738_/B VGND VGND VPWR VPWR _3738_/X sky130_fd_sc_hd__and2_2
XFILLER_109_57 VGND VGND VPWR VPWR sky130_fd_sc_hd__decap_3
X_3669_ _5419_/Q _5067_/Q _3790_/S VGND VGND VPWR VPWR _3670_/B sky130_fd_sc_hd__mux2_1
XFILLER_0_604 VGND VGND VPWR VPWR sky130_fd_sc_hd__fill_1
X_5408_ _5571_/CLK _5408_/D VGND VGND VPWR VPWR _5408_/Q sky130_fd_sc_hd__dfxtp_2
XFILLER_0_615 VGND VGND VPWR VPWR sky130_fd_sc_hd__fill_1
XFILLER_0_637 VGND VGND VPWR VPWR sky130_fd_sc_hd__decap_3
XFILLER_102_521 VGND VGND VPWR VPWR sky130_fd_sc_hd__decap_3
X_5339_ _5502_/CLK _5339_/D VGND VGND VPWR VPWR _5339_/Q sky130_fd_sc_hd__dfxtp_2
XFILLER_0_648 VGND VGND VPWR VPWR sky130_fd_sc_hd__decap_3
XFILLER_102_587 VGND VGND VPWR VPWR sky130_fd_sc_hd__fill_1
XFILLER_102_598 VGND VGND VPWR VPWR sky130_fd_sc_hd__fill_2
XTAP_TAPCELL_ROW_89_1317 VGND VPWR sky130_fd_sc_hd__tapvpwrvgnd_1
XFILLER_18_32 VGND VGND VPWR VPWR sky130_fd_sc_hd__fill_1
XFILLER_56_641 VGND VGND VPWR VPWR sky130_fd_sc_hd__decap_3
Xclkbuf_leaf_67_clk clkload3/A VGND VGND VPWR VPWR _6045_/CLK sky130_fd_sc_hd__clkbuf_8
XFILLER_18_54 VGND VGND VPWR VPWR sky130_fd_sc_hd__decap_3
XFILLER_28_354 VGND VGND VPWR VPWR sky130_fd_sc_hd__fill_2
XFILLER_56_685 VGND VGND VPWR VPWR sky130_fd_sc_hd__decap_3
XFILLER_34_20 VGND VGND VPWR VPWR sky130_fd_sc_hd__decap_3
XFILLER_43_346 VGND VGND VPWR VPWR sky130_fd_sc_hd__fill_1
XFILLER_34_42 VGND VGND VPWR VPWR sky130_fd_sc_hd__decap_3
XFILLER_43_379 VGND VGND VPWR VPWR sky130_fd_sc_hd__fill_2
XFILLER_70_176 VGND VGND VPWR VPWR sky130_fd_sc_hd__fill_2
XTAP_TAPCELL_ROW_26_566 VGND VPWR sky130_fd_sc_hd__tapvpwrvgnd_1
XTAP_TAPCELL_ROW_54_897 VGND VPWR sky130_fd_sc_hd__tapvpwrvgnd_1
XFILLER_7_236 VGND VGND VPWR VPWR sky130_fd_sc_hd__decap_3
Xwire156 wire156/A VGND VGND VPWR VPWR wire156/X sky130_fd_sc_hd__clkbuf_4
XFILLER_50_52 VGND VGND VPWR VPWR sky130_fd_sc_hd__decap_3
XFILLER_50_85 VGND VGND VPWR VPWR sky130_fd_sc_hd__decap_3
XFILLER_7_258 VGND VGND VPWR VPWR sky130_fd_sc_hd__fill_2
XFILLER_109_197 VGND VGND VPWR VPWR sky130_fd_sc_hd__decap_3
XFILLER_78_221 VGND VGND VPWR VPWR sky130_fd_sc_hd__decap_3
XFILLER_59_490 VGND VGND VPWR VPWR sky130_fd_sc_hd__decap_3
Xclkbuf_leaf_58_clk clkload6/A VGND VGND VPWR VPWR _6071_/CLK sky130_fd_sc_hd__clkbuf_8
XFILLER_19_343 VGND VGND VPWR VPWR sky130_fd_sc_hd__decap_3
XTAP_TAPCELL_ROW_109_1553 VGND VPWR sky130_fd_sc_hd__tapvpwrvgnd_1
Xclkbuf_4_11_0_clk clkbuf_0_clk/X VGND VGND VPWR VPWR clkload5/A sky130_fd_sc_hd__clkbuf_8
XFILLER_19_376 VGND VGND VPWR VPWR sky130_fd_sc_hd__decap_3
XFILLER_61_110 VGND VGND VPWR VPWR sky130_fd_sc_hd__fill_2
XFILLER_34_368 VGND VGND VPWR VPWR sky130_fd_sc_hd__fill_2
XFILLER_22_519 VGND VGND VPWR VPWR sky130_fd_sc_hd__decap_3
X_2971_ _6060_/Q _5964_/Q _2971_/S VGND VGND VPWR VPWR _2971_/X sky130_fd_sc_hd__mux2_1
X_5690_ _5691_/CLK _5690_/D VGND VGND VPWR VPWR _5690_/Q sky130_fd_sc_hd__dfxtp_2
X_4710_ _4946_/B _4878_/B VGND VGND VPWR VPWR _4710_/Y sky130_fd_sc_hd__nor2_2
X_4641_ _4878_/A _4641_/B VGND VGND VPWR VPWR _4641_/Y sky130_fd_sc_hd__nor2_2
X_4572_ _5013_/A1 _4572_/A2 _4572_/B1 _4572_/B2 VGND VGND VPWR VPWR _5623_/D sky130_fd_sc_hd__a22o_2
X_3523_ _5572_/Q _5540_/Q _3873_/S VGND VGND VPWR VPWR _3523_/X sky130_fd_sc_hd__mux2_1
XFILLER_115_167 VGND VGND VPWR VPWR sky130_fd_sc_hd__fill_1
XFILLER_6_291 VGND VGND VPWR VPWR sky130_fd_sc_hd__fill_2
XTAP_TAPCELL_ROW_73_1129 VGND VPWR sky130_fd_sc_hd__tapvpwrvgnd_1
X_3454_ _3454_/A _3454_/B VGND VGND VPWR VPWR _3454_/X sky130_fd_sc_hd__or2_2
XFILLER_111_340 VGND VGND VPWR VPWR sky130_fd_sc_hd__fill_1
Xhold2105 _5830_/Q VGND VGND VPWR VPWR _4792_/B sky130_fd_sc_hd__dlygate4sd3_1
Xhold2116 _5067_/Q VGND VGND VPWR VPWR _3971_/B2 sky130_fd_sc_hd__dlygate4sd3_1
Xhold2127 _5938_/Q VGND VGND VPWR VPWR _4906_/B2 sky130_fd_sc_hd__dlygate4sd3_1
X_3385_ _3385_/A _3385_/B VGND VGND VPWR VPWR _3385_/X sky130_fd_sc_hd__and2_2
Xhold1404 _5524_/Q VGND VGND VPWR VPWR _4466_/B2 sky130_fd_sc_hd__dlygate4sd3_1
Xhold1415 _5515_/Q VGND VGND VPWR VPWR _4457_/B2 sky130_fd_sc_hd__dlygate4sd3_1
Xhold2138 _5836_/Q VGND VGND VPWR VPWR _4798_/B sky130_fd_sc_hd__dlygate4sd3_1
Xhold2149 _5831_/Q VGND VGND VPWR VPWR _4793_/B sky130_fd_sc_hd__dlygate4sd3_1
X_5124_ _6031_/CLK _5124_/D VGND VGND VPWR VPWR _5124_/Q sky130_fd_sc_hd__dfxtp_2
Xhold1426 _5142_/Q VGND VGND VPWR VPWR _4054_/B2 sky130_fd_sc_hd__dlygate4sd3_1
Xhold1437 _5246_/Q VGND VGND VPWR VPWR _4169_/B2 sky130_fd_sc_hd__dlygate4sd3_1
Xhold1448 _5869_/Q VGND VGND VPWR VPWR _4833_/B2 sky130_fd_sc_hd__dlygate4sd3_1
Xhold1459 _5189_/Q VGND VGND VPWR VPWR _4108_/B2 sky130_fd_sc_hd__dlygate4sd3_1
Xload_slew695 _2830_/A VGND VGND VPWR VPWR _3184_/A1 sky130_fd_sc_hd__buf_4
Xclkbuf_leaf_49_clk clkload7/A VGND VGND VPWR VPWR _6049_/CLK sky130_fd_sc_hd__clkbuf_8
X_5055_ _5802_/CLK _5055_/D VGND VGND VPWR VPWR _5055_/Q sky130_fd_sc_hd__dfxtp_2
X_4006_ _5033_/A1 _4018_/A2 _4018_/B1 _4006_/B2 VGND VGND VPWR VPWR _5097_/D sky130_fd_sc_hd__a22o_2
XFILLER_38_685 VGND VGND VPWR VPWR sky130_fd_sc_hd__decap_3
XFILLER_111_36 VGND VGND VPWR VPWR sky130_fd_sc_hd__decap_3
XFILLER_25_346 VGND VGND VPWR VPWR sky130_fd_sc_hd__decap_3
XFILLER_53_644 VGND VGND VPWR VPWR sky130_fd_sc_hd__decap_3
XTAP_TAPCELL_ROW_84_1258 VGND VPWR sky130_fd_sc_hd__tapvpwrvgnd_1
XFILLER_111_69 VGND VGND VPWR VPWR sky130_fd_sc_hd__decap_3
XFILLER_13_508 VGND VGND VPWR VPWR sky130_fd_sc_hd__decap_3
XFILLER_80_474 VGND VGND VPWR VPWR sky130_fd_sc_hd__fill_2
X_5957_ _6053_/CLK _5957_/D VGND VGND VPWR VPWR _5957_/Q sky130_fd_sc_hd__dfxtp_2
XTAP_TAPCELL_ROW_23_525 VGND VPWR sky130_fd_sc_hd__tapvpwrvgnd_1
XTAP_TAPCELL_ROW_51_856 VGND VPWR sky130_fd_sc_hd__tapvpwrvgnd_1
X_4908_ _4908_/A1 _4910_/A2 _4908_/B1 _4908_/B2 VGND VGND VPWR VPWR _5940_/D sky130_fd_sc_hd__a22o_2
XTAP_TAPCELL_ROW_51_867 VGND VPWR sky130_fd_sc_hd__tapvpwrvgnd_1
X_5888_ _6048_/CLK _5888_/D VGND VGND VPWR VPWR _5888_/Q sky130_fd_sc_hd__dfxtp_2
X_4839_ _5043_/A1 wire371/X wire153/X _4839_/B2 VGND VGND VPWR VPWR _5875_/D sky130_fd_sc_hd__a22o_2
XFILLER_107_657 VGND VGND VPWR VPWR sky130_fd_sc_hd__decap_3
XFILLER_107_679 VGND VGND VPWR VPWR sky130_fd_sc_hd__decap_3
XFILLER_20_55 VGND VGND VPWR VPWR sky130_fd_sc_hd__decap_3
XTAP_TAPCELL_ROW_95_1387 VGND VPWR sky130_fd_sc_hd__tapvpwrvgnd_1
XFILLER_20_88 VGND VGND VPWR VPWR sky130_fd_sc_hd__fill_1
XFILLER_0_445 VGND VGND VPWR VPWR sky130_fd_sc_hd__decap_3
XFILLER_88_530 VGND VGND VPWR VPWR sky130_fd_sc_hd__fill_2
XFILLER_88_541 VGND VGND VPWR VPWR sky130_fd_sc_hd__decap_3
XFILLER_102_351 VGND VGND VPWR VPWR sky130_fd_sc_hd__decap_3
XFILLER_88_585 VGND VGND VPWR VPWR sky130_fd_sc_hd__decap_3
XTAP_TAPCELL_ROW_59_956 VGND VPWR sky130_fd_sc_hd__tapvpwrvgnd_1
XFILLER_75_268 VGND VGND VPWR VPWR sky130_fd_sc_hd__fill_1
Xhold1960 _5061_/Q VGND VGND VPWR VPWR _3965_/B2 sky130_fd_sc_hd__dlygate4sd3_1
Xhold1971 _5535_/Q VGND VGND VPWR VPWR _4479_/B2 sky130_fd_sc_hd__dlygate4sd3_1
XFILLER_56_493 VGND VGND VPWR VPWR sky130_fd_sc_hd__fill_1
XFILLER_90_216 VGND VGND VPWR VPWR sky130_fd_sc_hd__decap_3
XPHY_EDGE_ROW_11_Left_127 VGND VGND VPWR VPWR sky130_fd_sc_hd__decap_3
XTAP_TAPCELL_ROW_3_283 VGND VPWR sky130_fd_sc_hd__tapvpwrvgnd_1
Xhold1982 _5727_/Q VGND VGND VPWR VPWR _4684_/B2 sky130_fd_sc_hd__dlygate4sd3_1
Xhold1993 _5872_/Q VGND VGND VPWR VPWR _4836_/B2 sky130_fd_sc_hd__dlygate4sd3_1
XFILLER_16_368 VGND VGND VPWR VPWR sky130_fd_sc_hd__decap_3
XFILLER_31_305 VGND VGND VPWR VPWR sky130_fd_sc_hd__decap_3
XFILLER_31_316 VGND VGND VPWR VPWR sky130_fd_sc_hd__decap_3
XFILLER_71_485 VGND VGND VPWR VPWR sky130_fd_sc_hd__decap_3
XTAP_TAPCELL_ROW_104_1494 VGND VPWR sky130_fd_sc_hd__tapvpwrvgnd_1
XFILLER_61_73 VGND VGND VPWR VPWR sky130_fd_sc_hd__fill_2
XFILLER_6_24 VGND VGND VPWR VPWR sky130_fd_sc_hd__decap_3
XFILLER_8_556 VGND VGND VPWR VPWR sky130_fd_sc_hd__decap_3
XFILLER_8_589 VGND VGND VPWR VPWR sky130_fd_sc_hd__fill_2
XANTENNA_6 _4332_/Y VGND VGND VPWR VPWR sky130_fd_sc_hd__diode_2
XFILLER_6_35 VGND VGND VPWR VPWR sky130_fd_sc_hd__decap_3
XPHY_EDGE_ROW_20_Left_136 VGND VGND VPWR VPWR sky130_fd_sc_hd__decap_3
XFILLER_113_605 VGND VGND VPWR VPWR sky130_fd_sc_hd__decap_3
XFILLER_113_638 VGND VGND VPWR VPWR sky130_fd_sc_hd__decap_3
XFILLER_79_541 VGND VGND VPWR VPWR sky130_fd_sc_hd__decap_3
XFILLER_39_416 VGND VGND VPWR VPWR sky130_fd_sc_hd__decap_3
XFILLER_79_585 VGND VGND VPWR VPWR sky130_fd_sc_hd__decap_3
X_3170_ _6069_/Q _5973_/Q _3170_/S VGND VGND VPWR VPWR _3170_/X sky130_fd_sc_hd__mux2_1
XFILLER_39_449 VGND VGND VPWR VPWR sky130_fd_sc_hd__decap_3
XFILLER_94_544 VGND VGND VPWR VPWR sky130_fd_sc_hd__decap_3
Xfanout1062 _3895_/S VGND VGND VPWR VPWR _3277_/S sky130_fd_sc_hd__clkbuf_2
XFILLER_34_110 VGND VGND VPWR VPWR sky130_fd_sc_hd__decap_3
XFILLER_35_644 VGND VGND VPWR VPWR sky130_fd_sc_hd__decap_3
XFILLER_50_603 VGND VGND VPWR VPWR sky130_fd_sc_hd__decap_3
X_5811_ _5813_/CLK _5811_/D VGND VGND VPWR VPWR _5811_/Q sky130_fd_sc_hd__dfxtp_2
XFILLER_50_636 VGND VGND VPWR VPWR sky130_fd_sc_hd__decap_3
X_5742_ _6062_/CLK _5742_/D VGND VGND VPWR VPWR _5742_/Q sky130_fd_sc_hd__dfxtp_2
X_2954_ _3058_/A _2950_/X _2953_/X _3207_/A1 VGND VGND VPWR VPWR _2954_/X sky130_fd_sc_hd__o211a_2
X_5673_ _5785_/CLK _5673_/D VGND VGND VPWR VPWR _5673_/Q sky130_fd_sc_hd__dfxtp_2
X_2885_ _6056_/Q _5960_/Q _2885_/S VGND VGND VPWR VPWR _2885_/X sky130_fd_sc_hd__mux2_1
XPHY_EDGE_ROW_6_Right_6 VGND VGND VPWR VPWR sky130_fd_sc_hd__decap_3
X_4624_ _4658_/A1 _4608_/B _4634_/B1 _4624_/B2 VGND VGND VPWR VPWR _5671_/D sky130_fd_sc_hd__a22o_2
X_4555_ _4760_/A1 _4572_/A2 _4572_/B1 _4555_/B2 VGND VGND VPWR VPWR _5606_/D sky130_fd_sc_hd__a22o_2
X_3506_ _5124_/Q _5092_/Q _6020_/Q _5988_/Q _3508_/S _3772_/S1 VGND VGND VPWR VPWR
+ _3506_/X sky130_fd_sc_hd__mux4_2
XFILLER_104_627 VGND VGND VPWR VPWR sky130_fd_sc_hd__decap_3
X_4486_ _4520_/A1 _4498_/A2 _4498_/B1 _4486_/B2 VGND VGND VPWR VPWR _5542_/D sky130_fd_sc_hd__a22o_2
X_3437_ _5408_/Q _5056_/Q _3727_/S VGND VGND VPWR VPWR _3437_/X sky130_fd_sc_hd__mux2_1
XFILLER_112_660 VGND VGND VPWR VPWR sky130_fd_sc_hd__decap_3
XFILLER_85_500 VGND VGND VPWR VPWR sky130_fd_sc_hd__decap_3
X_3368_ _5501_/Q _5469_/Q _3379_/S VGND VGND VPWR VPWR _3368_/X sky130_fd_sc_hd__mux2_1
XFILLER_85_522 VGND VGND VPWR VPWR sky130_fd_sc_hd__decap_3
XFILLER_97_393 VGND VGND VPWR VPWR sky130_fd_sc_hd__fill_2
Xhold1201 _6015_/Q VGND VGND VPWR VPWR _4989_/B2 sky130_fd_sc_hd__dlygate4sd3_1
Xhold1212 _5503_/Q VGND VGND VPWR VPWR _4445_/B2 sky130_fd_sc_hd__dlygate4sd3_1
Xhold1223 _6050_/Q VGND VGND VPWR VPWR _5026_/B2 sky130_fd_sc_hd__dlygate4sd3_1
Xhold1234 _6014_/Q VGND VGND VPWR VPWR _4988_/B2 sky130_fd_sc_hd__dlygate4sd3_1
X_5107_ _6035_/CLK _5107_/D VGND VGND VPWR VPWR _5107_/Q sky130_fd_sc_hd__dfxtp_2
Xhold1245 _5861_/Q VGND VGND VPWR VPWR _4825_/B2 sky130_fd_sc_hd__dlygate4sd3_1
Xhold1256 _5892_/Q VGND VGND VPWR VPWR _4858_/B2 sky130_fd_sc_hd__dlygate4sd3_1
Xhold1267 _5504_/Q VGND VGND VPWR VPWR _4446_/B2 sky130_fd_sc_hd__dlygate4sd3_1
X_3299_ _5242_/Q _5210_/Q _3300_/S VGND VGND VPWR VPWR _3299_/X sky130_fd_sc_hd__mux2_1
XFILLER_72_216 VGND VGND VPWR VPWR sky130_fd_sc_hd__decap_3
XFILLER_85_588 VGND VGND VPWR VPWR sky130_fd_sc_hd__decap_3
XTAP_TAPCELL_ROW_56_926 VGND VPWR sky130_fd_sc_hd__tapvpwrvgnd_1
Xhold1278 _5611_/Q VGND VGND VPWR VPWR _4560_/B2 sky130_fd_sc_hd__dlygate4sd3_1
Xhold1289 _6071_/Q VGND VGND VPWR VPWR _5047_/B2 sky130_fd_sc_hd__dlygate4sd3_1
X_5038_ _5038_/A1 _5038_/A2 wire115/X _5038_/B2 VGND VGND VPWR VPWR _6062_/D sky130_fd_sc_hd__a22o_2
XFILLER_26_633 VGND VGND VPWR VPWR sky130_fd_sc_hd__decap_3
XTAP_TAPCELL_ROW_0_242 VGND VPWR sky130_fd_sc_hd__tapvpwrvgnd_1
XTAP_TAPCELL_ROW_0_253 VGND VPWR sky130_fd_sc_hd__tapvpwrvgnd_1
XFILLER_41_614 VGND VGND VPWR VPWR sky130_fd_sc_hd__fill_2
XFILLER_15_55 VGND VGND VPWR VPWR sky130_fd_sc_hd__fill_1
XTAP_TAPCELL_ROW_36_683 VGND VPWR sky130_fd_sc_hd__tapvpwrvgnd_1
XFILLER_15_99 VGND VGND VPWR VPWR sky130_fd_sc_hd__decap_3
XFILLER_9_309 VGND VGND VPWR VPWR sky130_fd_sc_hd__decap_3
XTAP_TAPCELL_ROW_97_1416 VGND VPWR sky130_fd_sc_hd__tapvpwrvgnd_1
XFILLER_110_3 VGND VGND VPWR VPWR sky130_fd_sc_hd__decap_3
Xoutput76 _2619_/X VGND VGND VPWR VPWR rd1[4] sky130_fd_sc_hd__clkbuf_4
Xoutput65 _3051_/X VGND VGND VPWR VPWR rd1[23] sky130_fd_sc_hd__clkbuf_2
Xoutput54 _2826_/X VGND VGND VPWR VPWR rd1[13] sky130_fd_sc_hd__dlygate4sd1_1
XTAP_TAPCELL_ROW_8_342 VGND VPWR sky130_fd_sc_hd__tapvpwrvgnd_1
XFILLER_0_253 VGND VGND VPWR VPWR sky130_fd_sc_hd__fill_1
XFILLER_110_619 VGND VGND VPWR VPWR sky130_fd_sc_hd__fill_2
Xoutput98 _3794_/X VGND VGND VPWR VPWR rd2[24] sky130_fd_sc_hd__clkbuf_2
Xoutput87 _3572_/X VGND VGND VPWR VPWR rd2[14] sky130_fd_sc_hd__clkbuf_2
XFILLER_102_181 VGND VGND VPWR VPWR sky130_fd_sc_hd__decap_3
XFILLER_103_682 VGND VGND VPWR VPWR sky130_fd_sc_hd__decap_3
XFILLER_88_382 VGND VGND VPWR VPWR sky130_fd_sc_hd__fill_2
XFILLER_16_110 VGND VGND VPWR VPWR sky130_fd_sc_hd__decap_3
XTAP_TAPCELL_ROW_106_1523 VGND VPWR sky130_fd_sc_hd__tapvpwrvgnd_1
Xhold1790 _5216_/Q VGND VGND VPWR VPWR _4137_/B2 sky130_fd_sc_hd__dlygate4sd3_1
XFILLER_44_474 VGND VGND VPWR VPWR sky130_fd_sc_hd__fill_2
XFILLER_72_83 VGND VGND VPWR VPWR sky130_fd_sc_hd__fill_1
XFILLER_72_94 VGND VGND VPWR VPWR sky130_fd_sc_hd__fill_2
XPHY_EDGE_ROW_59_Right_59 VGND VGND VPWR VPWR sky130_fd_sc_hd__decap_3
XFILLER_75_6 VGND VGND VPWR VPWR sky130_fd_sc_hd__fill_1
X_2670_ _3191_/A1 _2667_/X _2669_/X VGND VGND VPWR VPWR _2670_/X sky130_fd_sc_hd__a21o_2
XFILLER_99_625 VGND VGND VPWR VPWR sky130_fd_sc_hd__decap_3
X_4340_ _4752_/A1 wire465/X _4350_/B1 _4340_/B2 VGND VGND VPWR VPWR _5406_/D sky130_fd_sc_hd__a22o_2
XFILLER_99_647 VGND VGND VPWR VPWR sky130_fd_sc_hd__fill_1
X_4271_ _4885_/A1 _4292_/A2 _4287_/B1 _4271_/B2 VGND VGND VPWR VPWR _5341_/D sky130_fd_sc_hd__a22o_2
XFILLER_86_319 VGND VGND VPWR VPWR sky130_fd_sc_hd__decap_3
XFILLER_98_168 VGND VGND VPWR VPWR sky130_fd_sc_hd__decap_3
X_6010_ _6010_/CLK _6010_/D VGND VGND VPWR VPWR _6010_/Q sky130_fd_sc_hd__dfxtp_2
X_3222_ _3222_/A1 _3220_/X _3221_/X _3222_/B2 VGND VGND VPWR VPWR _3222_/X sky130_fd_sc_hd__o22a_2
XFILLER_79_393 VGND VGND VPWR VPWR sky130_fd_sc_hd__fill_2
XPHY_EDGE_ROW_68_Right_68 VGND VGND VPWR VPWR sky130_fd_sc_hd__decap_3
X_3153_ _5940_/Q _5908_/Q _5876_/Q _5780_/Q _2794_/S _3153_/S1 VGND VGND VPWR VPWR
+ _3154_/B sky130_fd_sc_hd__mux4_2
XFILLER_67_555 VGND VGND VPWR VPWR sky130_fd_sc_hd__decap_3
XFILLER_94_352 VGND VGND VPWR VPWR sky130_fd_sc_hd__fill_2
XFILLER_39_279 VGND VGND VPWR VPWR sky130_fd_sc_hd__fill_1
X_3084_ _3094_/A1 _3082_/X _3083_/X _3094_/B2 VGND VGND VPWR VPWR _3084_/X sky130_fd_sc_hd__o22a_2
XFILLER_35_485 VGND VGND VPWR VPWR sky130_fd_sc_hd__fill_2
XTAP_TAPCELL_ROW_81_1217 VGND VPWR sky130_fd_sc_hd__tapvpwrvgnd_1
XPHY_EDGE_ROW_77_Right_77 VGND VGND VPWR VPWR sky130_fd_sc_hd__decap_3
XTAP_TAPCELL_ROW_33_642 VGND VPWR sky130_fd_sc_hd__tapvpwrvgnd_1
X_3986_ _4709_/C _4057_/B VGND VGND VPWR VPWR _4980_/A sky130_fd_sc_hd__or2_2
XFILLER_22_168 VGND VGND VPWR VPWR sky130_fd_sc_hd__decap_3
XTAP_TAPCELL_ROW_61_984 VGND VPWR sky130_fd_sc_hd__tapvpwrvgnd_1
X_5725_ _5794_/CLK _5725_/D VGND VGND VPWR VPWR _5725_/Q sky130_fd_sc_hd__dfxtp_2
X_2937_ _2937_/A1 _2933_/X _2936_/X _3230_/A1 VGND VGND VPWR VPWR _2937_/X sky130_fd_sc_hd__o211a_2
X_5656_ _6040_/CLK _5656_/D VGND VGND VPWR VPWR _5656_/Q sky130_fd_sc_hd__dfxtp_2
X_4607_ _4844_/A _4641_/B VGND VGND VPWR VPWR _4607_/Y sky130_fd_sc_hd__nor2_2
X_2868_ _3218_/B2 _2866_/X _2867_/X _3218_/A1 VGND VGND VPWR VPWR _2868_/X sky130_fd_sc_hd__o22a_2
X_5587_ _5589_/CLK _5587_/D VGND VGND VPWR VPWR _5587_/Q sky130_fd_sc_hd__dfxtp_2
X_2799_ _5572_/Q _5540_/Q _3145_/S VGND VGND VPWR VPWR _2799_/X sky130_fd_sc_hd__mux2_1
X_4538_ _4709_/C input5/X input4/X VGND VGND VPWR VPWR _4641_/B sky130_fd_sc_hd__or3b_2
XFILLER_7_9 VGND VGND VPWR VPWR sky130_fd_sc_hd__decap_3
Xfanout800 fanout822/X VGND VGND VPWR VPWR _3166_/S sky130_fd_sc_hd__clkbuf_2
X_4469_ _4843_/A1 _4469_/A2 _4469_/B1 _4469_/B2 VGND VGND VPWR VPWR _5527_/D sky130_fd_sc_hd__a22o_2
XTAP_TAPCELL_ROW_92_1357 VGND VPWR sky130_fd_sc_hd__tapvpwrvgnd_1
XPHY_EDGE_ROW_86_Right_86 VGND VGND VPWR VPWR sky130_fd_sc_hd__decap_3
XTAP_TAPCELL_ROW_5_312 VGND VPWR sky130_fd_sc_hd__tapvpwrvgnd_1
Xfanout833 _3159_/S VGND VGND VPWR VPWR _2800_/S sky130_fd_sc_hd__clkbuf_2
Xfanout822 input6/X VGND VGND VPWR VPWR fanout822/X sky130_fd_sc_hd__buf_6
Xfanout811 _2736_/S0 VGND VGND VPWR VPWR _2660_/S sky130_fd_sc_hd__clkbuf_2
Xfanout866 input48/X VGND VGND VPWR VPWR _4991_/A1 sky130_fd_sc_hd__clkdlybuf4s25_1
Xfanout844 _2981_/S VGND VGND VPWR VPWR _3209_/S0 sky130_fd_sc_hd__clkbuf_2
XFILLER_58_566 VGND VGND VPWR VPWR sky130_fd_sc_hd__decap_3
Xfanout899 _4468_/A1 VGND VGND VPWR VPWR _5046_/A1 sky130_fd_sc_hd__clkdlybuf4s25_1
Xfanout888 input43/X VGND VGND VPWR VPWR _4510_/A1 sky130_fd_sc_hd__clkdlybuf4s25_1
Xfanout877 _5022_/A1 VGND VGND VPWR VPWR _4886_/A1 sky130_fd_sc_hd__clkdlybuf4s25_1
XFILLER_18_419 VGND VGND VPWR VPWR sky130_fd_sc_hd__fill_1
XFILLER_13_113 VGND VGND VPWR VPWR sky130_fd_sc_hd__decap_3
XFILLER_14_625 VGND VGND VPWR VPWR sky130_fd_sc_hd__decap_3
XFILLER_26_496 VGND VGND VPWR VPWR sky130_fd_sc_hd__decap_3
XFILLER_41_433 VGND VGND VPWR VPWR sky130_fd_sc_hd__fill_1
XPHY_EDGE_ROW_95_Right_95 VGND VGND VPWR VPWR sky130_fd_sc_hd__decap_3
XFILLER_13_146 VGND VGND VPWR VPWR sky130_fd_sc_hd__decap_3
XFILLER_13_157 VGND VGND VPWR VPWR sky130_fd_sc_hd__decap_3
XFILLER_14_669 VGND VGND VPWR VPWR sky130_fd_sc_hd__decap_3
XFILLER_41_455 VGND VGND VPWR VPWR sky130_fd_sc_hd__decap_3
XTAP_TAPCELL_ROW_101_1464 VGND VPWR sky130_fd_sc_hd__tapvpwrvgnd_1
XFILLER_5_301 VGND VGND VPWR VPWR sky130_fd_sc_hd__fill_1
XFILLER_5_345 VGND VGND VPWR VPWR sky130_fd_sc_hd__decap_3
XFILLER_107_273 VGND VGND VPWR VPWR sky130_fd_sc_hd__decap_3
XFILLER_107_284 VGND VGND VPWR VPWR sky130_fd_sc_hd__fill_1
XFILLER_1_540 VGND VGND VPWR VPWR sky130_fd_sc_hd__decap_3
XFILLER_3_36 VGND VGND VPWR VPWR sky130_fd_sc_hd__decap_3
XFILLER_96_628 VGND VGND VPWR VPWR sky130_fd_sc_hd__decap_3
XFILLER_107_90 VGND VGND VPWR VPWR sky130_fd_sc_hd__decap_3
XFILLER_1_584 VGND VGND VPWR VPWR sky130_fd_sc_hd__decap_3
XFILLER_3_69 VGND VGND VPWR VPWR sky130_fd_sc_hd__decap_3
XFILLER_95_116 VGND VGND VPWR VPWR sky130_fd_sc_hd__fill_1
XTAP_TAPCELL_ROW_112_1593 VGND VPWR sky130_fd_sc_hd__tapvpwrvgnd_1
XFILLER_67_94 VGND VGND VPWR VPWR sky130_fd_sc_hd__decap_3
XFILLER_17_474 VGND VGND VPWR VPWR sky130_fd_sc_hd__decap_3
XFILLER_83_60 VGND VGND VPWR VPWR sky130_fd_sc_hd__fill_1
XTAP_TAPCELL_ROW_67_1050 VGND VPWR sky130_fd_sc_hd__tapvpwrvgnd_1
XFILLER_32_400 VGND VGND VPWR VPWR sky130_fd_sc_hd__decap_3
XFILLER_91_399 VGND VGND VPWR VPWR sky130_fd_sc_hd__fill_1
XFILLER_32_466 VGND VGND VPWR VPWR sky130_fd_sc_hd__decap_3
X_3840_ _5587_/Q _5555_/Q _3841_/S VGND VGND VPWR VPWR _3840_/X sky130_fd_sc_hd__mux2_1
XFILLER_32_477 VGND VGND VPWR VPWR sky130_fd_sc_hd__fill_1
XTAP_TAPCELL_ROW_30_612 VGND VPWR sky130_fd_sc_hd__tapvpwrvgnd_1
X_3771_ _3758_/X _3769_/X _3770_/X wire553/X VGND VGND VPWR VPWR _3771_/X sky130_fd_sc_hd__o31a_2
X_5510_ _5659_/CLK _5510_/D VGND VGND VPWR VPWR _5510_/Q sky130_fd_sc_hd__dfxtp_2
X_2722_ _3094_/A1 _2720_/X _2721_/X _2972_/A1 VGND VGND VPWR VPWR _2722_/X sky130_fd_sc_hd__o22a_2
XFILLER_73_3 VGND VGND VPWR VPWR sky130_fd_sc_hd__fill_2
XFILLER_8_161 VGND VGND VPWR VPWR sky130_fd_sc_hd__decap_3
XFILLER_9_673 VGND VGND VPWR VPWR sky130_fd_sc_hd__decap_3
XFILLER_8_183 VGND VGND VPWR VPWR sky130_fd_sc_hd__decap_3
X_5441_ _6049_/CLK _5441_/D VGND VGND VPWR VPWR _5441_/Q sky130_fd_sc_hd__dfxtp_2
X_2653_ _5118_/Q _5086_/Q _6014_/Q _5982_/Q _2738_/S _3107_/S1 VGND VGND VPWR VPWR
+ _2653_/X sky130_fd_sc_hd__mux4_2
XTAP_TAPCELL_ROW_78_1190 VGND VPWR sky130_fd_sc_hd__tapvpwrvgnd_1
X_5372_ _5500_/CLK _5372_/D VGND VGND VPWR VPWR _5372_/Q sky130_fd_sc_hd__dfxtp_2
X_2584_ _2987_/A _2580_/X _2583_/X wire559/A VGND VGND VPWR VPWR _2584_/X sky130_fd_sc_hd__o211a_2
X_4323_ _5005_/A1 _4328_/A2 _4328_/B1 _4323_/B2 VGND VGND VPWR VPWR _5391_/D sky130_fd_sc_hd__a22o_2
XFILLER_113_243 VGND VGND VPWR VPWR sky130_fd_sc_hd__decap_3
XFILLER_86_105 VGND VGND VPWR VPWR sky130_fd_sc_hd__decap_3
XFILLER_99_488 VGND VGND VPWR VPWR sky130_fd_sc_hd__decap_3
Xfanout129 _4947_/Y VGND VGND VPWR VPWR _4978_/B1 sky130_fd_sc_hd__clkdlybuf4s25_1
X_4254_ _4528_/A1 wire482/A wire262/X _4254_/B2 VGND VGND VPWR VPWR _5326_/D sky130_fd_sc_hd__a22o_2
XFILLER_67_352 VGND VGND VPWR VPWR sky130_fd_sc_hd__decap_3
X_4185_ _5004_/A1 _4162_/B _4185_/B1 _4185_/B2 VGND VGND VPWR VPWR _5262_/D sky130_fd_sc_hd__a22o_2
X_3205_ wire651/X _3203_/X _3204_/X _3205_/B2 VGND VGND VPWR VPWR _3205_/X sky130_fd_sc_hd__o22a_2
XFILLER_103_15 VGND VGND VPWR VPWR sky130_fd_sc_hd__decap_3
XFILLER_67_385 VGND VGND VPWR VPWR sky130_fd_sc_hd__fill_1
XFILLER_94_171 VGND VGND VPWR VPWR sky130_fd_sc_hd__decap_3
XTAP_TAPCELL_ROW_38_701 VGND VPWR sky130_fd_sc_hd__tapvpwrvgnd_1
X_3136_ _5939_/Q _5907_/Q _5875_/Q _5779_/Q _2897_/S _3180_/S1 VGND VGND VPWR VPWR
+ _3136_/X sky130_fd_sc_hd__mux4_2
X_3067_ _3207_/A1 _3058_/X _3061_/X _3066_/X VGND VGND VPWR VPWR _3067_/X sky130_fd_sc_hd__a31o_2
XFILLER_23_499 VGND VGND VPWR VPWR sky130_fd_sc_hd__decap_3
XFILLER_109_505 VGND VGND VPWR VPWR sky130_fd_sc_hd__decap_3
XFILLER_12_12 VGND VGND VPWR VPWR sky130_fd_sc_hd__decap_3
Xwire508 wire508/A VGND VGND VPWR VPWR wire508/X sky130_fd_sc_hd__clkbuf_4
X_5708_ _6049_/CLK _5708_/D VGND VGND VPWR VPWR _5708_/Q sky130_fd_sc_hd__dfxtp_2
X_3969_ _4999_/A1 _3981_/A2 wire322/X _3969_/B2 VGND VGND VPWR VPWR _5065_/D sky130_fd_sc_hd__a22o_2
XFILLER_109_516 VGND VGND VPWR VPWR sky130_fd_sc_hd__decap_3
XFILLER_12_56 VGND VGND VPWR VPWR sky130_fd_sc_hd__decap_3
X_5639_ _5815_/CLK _5639_/D VGND VGND VPWR VPWR _5639_/Q sky130_fd_sc_hd__dfxtp_2
XFILLER_2_348 VGND VGND VPWR VPWR sky130_fd_sc_hd__decap_3
XFILLER_5_6 VGND VGND VPWR VPWR sky130_fd_sc_hd__decap_3
XFILLER_104_287 VGND VGND VPWR VPWR sky130_fd_sc_hd__decap_3
XFILLER_77_116 VGND VGND VPWR VPWR sky130_fd_sc_hd__fill_1
XFILLER_77_149 VGND VGND VPWR VPWR sky130_fd_sc_hd__decap_3
Xfanout663 _2502_/X VGND VGND VPWR VPWR _3071_/B2 sky130_fd_sc_hd__clkdlybuf4s25_1
Xfanout652 _3222_/A1 VGND VGND VPWR VPWR _2727_/A1 sky130_fd_sc_hd__buf_2
Xfanout696 _2496_/Y VGND VGND VPWR VPWR _3028_/A1 sky130_fd_sc_hd__clkdlybuf4s25_1
XFILLER_46_536 VGND VGND VPWR VPWR sky130_fd_sc_hd__decap_3
XFILLER_73_355 VGND VGND VPWR VPWR sky130_fd_sc_hd__decap_3
XFILLER_33_219 VGND VGND VPWR VPWR sky130_fd_sc_hd__decap_3
XTAP_TAPCELL_ROW_16_439 VGND VPWR sky130_fd_sc_hd__tapvpwrvgnd_1
XFILLER_53_30 VGND VGND VPWR VPWR sky130_fd_sc_hd__fill_2
XFILLER_6_621 VGND VGND VPWR VPWR sky130_fd_sc_hd__decap_3
XFILLER_6_654 VGND VGND VPWR VPWR sky130_fd_sc_hd__decap_3
XFILLER_115_519 VGND VGND VPWR VPWR sky130_fd_sc_hd__decap_3
XFILLER_6_687 VGND VGND VPWR VPWR sky130_fd_sc_hd__fill_1
XTAP_TAPCELL_ROW_114_1622 VGND VPWR sky130_fd_sc_hd__tapvpwrvgnd_1
XFILLER_5_175 VGND VGND VPWR VPWR sky130_fd_sc_hd__decap_3
XFILLER_78_82 VGND VGND VPWR VPWR sky130_fd_sc_hd__fill_2
XFILLER_96_436 VGND VGND VPWR VPWR sky130_fd_sc_hd__decap_3
XFILLER_37_503 VGND VGND VPWR VPWR sky130_fd_sc_hd__fill_1
XFILLER_77_661 VGND VGND VPWR VPWR sky130_fd_sc_hd__fill_1
XFILLER_77_683 VGND VGND VPWR VPWR sky130_fd_sc_hd__decap_3
XPHY_EDGE_ROW_3_Left_119 VGND VGND VPWR VPWR sky130_fd_sc_hd__decap_3
X_5990_ _6061_/CLK _5990_/D VGND VGND VPWR VPWR _5990_/Q sky130_fd_sc_hd__dfxtp_2
XFILLER_17_271 VGND VGND VPWR VPWR sky130_fd_sc_hd__fill_1
XFILLER_52_539 VGND VGND VPWR VPWR sky130_fd_sc_hd__decap_3
XFILLER_64_399 VGND VGND VPWR VPWR sky130_fd_sc_hd__decap_3
X_4941_ _5043_/A1 _4941_/A2 wire133/X _4941_/B2 VGND VGND VPWR VPWR _5971_/D sky130_fd_sc_hd__a22o_2
XFILLER_32_241 VGND VGND VPWR VPWR sky130_fd_sc_hd__decap_3
X_4872_ _5042_/A1 _4875_/A2 _4875_/B1 _4872_/B2 VGND VGND VPWR VPWR _5906_/D sky130_fd_sc_hd__a22o_2
XTAP_TAPCELL_ROW_43_770 VGND VPWR sky130_fd_sc_hd__tapvpwrvgnd_1
X_3823_ _3597_/S _3820_/X _3822_/X _3823_/B2 _3843_/C1 VGND VGND VPWR VPWR _3823_/X
+ sky130_fd_sc_hd__o221a_2
X_3754_ _5711_/Q _5679_/Q _5647_/Q _5615_/Q _3767_/S _3870_/S1 VGND VGND VPWR VPWR
+ _3754_/X sky130_fd_sc_hd__mux4_2
X_3685_ _3928_/A1 _3682_/X _3684_/X VGND VGND VPWR VPWR _3685_/X sky130_fd_sc_hd__a21o_2
X_2705_ wire676/X _2702_/X _2704_/X VGND VGND VPWR VPWR _2705_/Y sky130_fd_sc_hd__o21ai_2
X_5424_ _5963_/CLK _5424_/D VGND VGND VPWR VPWR _5424_/Q sky130_fd_sc_hd__dfxtp_2
X_2636_ _2649_/A _2636_/B VGND VGND VPWR VPWR _2636_/X sky130_fd_sc_hd__or2_2
XFILLER_99_241 VGND VGND VPWR VPWR sky130_fd_sc_hd__fill_2
X_5355_ _6059_/CLK _5355_/D VGND VGND VPWR VPWR _5355_/Q sky130_fd_sc_hd__dfxtp_2
X_2567_ _6042_/Q _5946_/Q _2578_/S VGND VGND VPWR VPWR _2567_/X sky130_fd_sc_hd__mux2_1
XFILLER_114_574 VGND VGND VPWR VPWR sky130_fd_sc_hd__decap_3
XFILLER_99_296 VGND VGND VPWR VPWR sky130_fd_sc_hd__fill_1
X_5286_ _5659_/CLK _5286_/D VGND VGND VPWR VPWR _5286_/Q sky130_fd_sc_hd__dfxtp_2
X_4306_ _4886_/A1 _4329_/A2 _4329_/B1 _4306_/B2 VGND VGND VPWR VPWR _5374_/D sky130_fd_sc_hd__a22o_2
X_2498_ _2608_/A input9/X VGND VGND VPWR VPWR _2498_/Y sky130_fd_sc_hd__nor2_2
XFILLER_101_235 VGND VGND VPWR VPWR sky130_fd_sc_hd__decap_3
X_4237_ _4885_/A1 _4258_/A2 _4253_/B1 _4237_/B2 VGND VGND VPWR VPWR _5309_/D sky130_fd_sc_hd__a22o_2
XFILLER_114_47 VGND VGND VPWR VPWR sky130_fd_sc_hd__decap_3
XFILLER_28_536 VGND VGND VPWR VPWR sky130_fd_sc_hd__decap_3
XFILLER_74_29 VGND VGND VPWR VPWR sky130_fd_sc_hd__decap_3
X_4168_ _4751_/A1 _4179_/A2 _4168_/B1 _4168_/B2 VGND VGND VPWR VPWR _5245_/D sky130_fd_sc_hd__a22o_2
XFILLER_82_141 VGND VGND VPWR VPWR sky130_fd_sc_hd__decap_3
X_4099_ _4986_/A1 _4124_/A2 _4112_/B1 _4099_/B2 VGND VGND VPWR VPWR _5180_/D sky130_fd_sc_hd__a22o_2
X_3119_ _3112_/X _3118_/X _3119_/B1 VGND VGND VPWR VPWR _3119_/X sky130_fd_sc_hd__o21a_2
XFILLER_15_219 VGND VGND VPWR VPWR sky130_fd_sc_hd__decap_3
XFILLER_82_185 VGND VGND VPWR VPWR sky130_fd_sc_hd__decap_3
XTAP_TAPCELL_ROW_87_1289 VGND VPWR sky130_fd_sc_hd__tapvpwrvgnd_1
XFILLER_51_550 VGND VGND VPWR VPWR sky130_fd_sc_hd__fill_1
XFILLER_51_572 VGND VGND VPWR VPWR sky130_fd_sc_hd__fill_1
XTAP_TAPCELL_ROW_13_409 VGND VPWR sky130_fd_sc_hd__tapvpwrvgnd_1
XFILLER_23_55 VGND VGND VPWR VPWR sky130_fd_sc_hd__fill_1
Xwire327 wire327/A VGND VGND VPWR VPWR wire327/X sky130_fd_sc_hd__buf_4
XFILLER_99_15 VGND VGND VPWR VPWR sky130_fd_sc_hd__decap_3
XFILLER_99_37 VGND VGND VPWR VPWR sky130_fd_sc_hd__decap_3
XTAP_TAPCELL_ROW_21_497 VGND VPWR sky130_fd_sc_hd__tapvpwrvgnd_1
XFILLER_3_613 VGND VGND VPWR VPWR sky130_fd_sc_hd__decap_3
XFILLER_3_635 VGND VGND VPWR VPWR sky130_fd_sc_hd__decap_3
XFILLER_3_3 VGND VGND VPWR VPWR sky130_fd_sc_hd__decap_3
XFILLER_3_668 VGND VGND VPWR VPWR sky130_fd_sc_hd__decap_3
XFILLER_3_679 VGND VGND VPWR VPWR sky130_fd_sc_hd__decap_3
XFILLER_48_85 VGND VGND VPWR VPWR sky130_fd_sc_hd__decap_3
XFILLER_0_15 VGND VGND VPWR VPWR sky130_fd_sc_hd__decap_3
XFILLER_100_290 VGND VGND VPWR VPWR sky130_fd_sc_hd__fill_1
XFILLER_104_80 VGND VGND VPWR VPWR sky130_fd_sc_hd__decap_3
XFILLER_19_558 VGND VGND VPWR VPWR sky130_fd_sc_hd__fill_2
XFILLER_19_569 VGND VGND VPWR VPWR sky130_fd_sc_hd__decap_3
XFILLER_73_141 VGND VGND VPWR VPWR sky130_fd_sc_hd__decap_3
XFILLER_64_62 VGND VGND VPWR VPWR sky130_fd_sc_hd__fill_1
XFILLER_74_686 VGND VGND VPWR VPWR sky130_fd_sc_hd__fill_2
XTAP_TAPCELL_ROW_29_597 VGND VPWR sky130_fd_sc_hd__tapvpwrvgnd_1
XTAP_TAPCELL_ROW_64_1020 VGND VPWR sky130_fd_sc_hd__tapvpwrvgnd_1
XFILLER_14_241 VGND VGND VPWR VPWR sky130_fd_sc_hd__decap_3
XFILLER_9_24 VGND VGND VPWR VPWR sky130_fd_sc_hd__decap_3
XFILLER_9_57 VGND VGND VPWR VPWR sky130_fd_sc_hd__decap_3
XFILLER_10_480 VGND VGND VPWR VPWR sky130_fd_sc_hd__fill_2
X_3470_ _3468_/X _3469_/X _3470_/S VGND VGND VPWR VPWR _3470_/X sky130_fd_sc_hd__mux2_1
XFILLER_89_81 VGND VGND VPWR VPWR sky130_fd_sc_hd__decap_3
XFILLER_69_425 VGND VGND VPWR VPWR sky130_fd_sc_hd__decap_3
X_5140_ _6031_/CLK _5140_/D VGND VGND VPWR VPWR _5140_/Q sky130_fd_sc_hd__dfxtp_2
XFILLER_96_222 VGND VGND VPWR VPWR sky130_fd_sc_hd__fill_1
Xhold1608 _5920_/Q VGND VGND VPWR VPWR _4888_/B2 sky130_fd_sc_hd__dlygate4sd3_1
Xload_slew855 _3077_/S VGND VGND VPWR VPWR _3088_/S sky130_fd_sc_hd__buf_4
X_5071_ _5871_/CLK _5071_/D VGND VGND VPWR VPWR _5071_/Q sky130_fd_sc_hd__dfxtp_2
Xhold1619 _5116_/Q VGND VGND VPWR VPWR _4028_/B2 sky130_fd_sc_hd__dlygate4sd3_1
X_4022_ _4980_/A _4878_/A VGND VGND VPWR VPWR _4022_/Y sky130_fd_sc_hd__nor2_2
XFILLER_111_599 VGND VGND VPWR VPWR sky130_fd_sc_hd__decap_3
XFILLER_65_642 VGND VGND VPWR VPWR sky130_fd_sc_hd__fill_2
XFILLER_92_461 VGND VGND VPWR VPWR sky130_fd_sc_hd__decap_3
XFILLER_25_517 VGND VGND VPWR VPWR sky130_fd_sc_hd__decap_3
XFILLER_37_399 VGND VGND VPWR VPWR sky130_fd_sc_hd__decap_3
XFILLER_80_634 VGND VGND VPWR VPWR sky130_fd_sc_hd__decap_3
XFILLER_92_494 VGND VGND VPWR VPWR sky130_fd_sc_hd__decap_3
X_5973_ _6069_/CLK _5973_/D VGND VGND VPWR VPWR _5973_/Q sky130_fd_sc_hd__dfxtp_2
XFILLER_52_347 VGND VGND VPWR VPWR sky130_fd_sc_hd__fill_1
XFILLER_80_645 VGND VGND VPWR VPWR sky130_fd_sc_hd__decap_3
XFILLER_80_667 VGND VGND VPWR VPWR sky130_fd_sc_hd__fill_1
X_4924_ _5026_/A1 _4943_/A2 _4943_/B1 _4924_/B2 VGND VGND VPWR VPWR _5954_/D sky130_fd_sc_hd__a22o_2
X_4855_ _5025_/A1 wire367/X _4861_/B1 _4855_/B2 VGND VGND VPWR VPWR _5889_/D sky130_fd_sc_hd__a22o_2
X_4786_ _4795_/A_N _4786_/B VGND VGND VPWR VPWR _5824_/D sky130_fd_sc_hd__and2b_2
X_3806_ _3806_/A _3806_/B VGND VGND VPWR VPWR _3806_/X sky130_fd_sc_hd__or2_2
X_3737_ _5422_/Q _5070_/Q _3744_/S VGND VGND VPWR VPWR _3738_/B sky130_fd_sc_hd__mux2_1
XFILLER_109_36 VGND VGND VPWR VPWR sky130_fd_sc_hd__decap_3
XFILLER_106_327 VGND VGND VPWR VPWR sky130_fd_sc_hd__fill_1
XFILLER_107_9 VGND VGND VPWR VPWR sky130_fd_sc_hd__decap_3
XFILLER_109_69 VGND VGND VPWR VPWR sky130_fd_sc_hd__decap_3
X_3668_ _5707_/Q _5675_/Q _5643_/Q _5611_/Q _3676_/S _3788_/S1 VGND VGND VPWR VPWR
+ _3668_/X sky130_fd_sc_hd__mux4_2
X_5407_ _5802_/CLK _5407_/D VGND VGND VPWR VPWR _5407_/Q sky130_fd_sc_hd__dfxtp_2
X_3599_ _5832_/Q _5448_/Q _6056_/Q _5960_/Q _3779_/S _3239_/B VGND VGND VPWR VPWR
+ _3599_/X sky130_fd_sc_hd__mux4_2
X_2619_ _2619_/A _2619_/B _2619_/C VGND VGND VPWR VPWR _2619_/X sky130_fd_sc_hd__and3_2
X_5338_ _5800_/CLK _5338_/D VGND VGND VPWR VPWR _5338_/Q sky130_fd_sc_hd__dfxtp_2
X_5269_ _5914_/CLK _5269_/D VGND VGND VPWR VPWR _5269_/Q sky130_fd_sc_hd__dfxtp_2
XTAP_TAPCELL_ROW_89_1318 VGND VPWR sky130_fd_sc_hd__tapvpwrvgnd_1
XFILLER_18_11 VGND VGND VPWR VPWR sky130_fd_sc_hd__decap_3
XFILLER_56_631 VGND VGND VPWR VPWR sky130_fd_sc_hd__decap_3
XFILLER_55_141 VGND VGND VPWR VPWR sky130_fd_sc_hd__decap_3
XFILLER_16_528 VGND VGND VPWR VPWR sky130_fd_sc_hd__decap_3
XFILLER_18_88 VGND VGND VPWR VPWR sky130_fd_sc_hd__fill_1
XFILLER_43_325 VGND VGND VPWR VPWR sky130_fd_sc_hd__decap_3
XFILLER_83_483 VGND VGND VPWR VPWR sky130_fd_sc_hd__decap_3
XFILLER_70_122 VGND VGND VPWR VPWR sky130_fd_sc_hd__decap_3
XFILLER_70_133 VGND VGND VPWR VPWR sky130_fd_sc_hd__fill_1
XFILLER_24_550 VGND VGND VPWR VPWR sky130_fd_sc_hd__decap_3
XTAP_TAPCELL_ROW_26_556 VGND VPWR sky130_fd_sc_hd__tapvpwrvgnd_1
XTAP_TAPCELL_ROW_26_567 VGND VPWR sky130_fd_sc_hd__tapvpwrvgnd_1
XTAP_TAPCELL_ROW_54_898 VGND VPWR sky130_fd_sc_hd__tapvpwrvgnd_1
XFILLER_24_583 VGND VGND VPWR VPWR sky130_fd_sc_hd__decap_3
XFILLER_109_132 VGND VGND VPWR VPWR sky130_fd_sc_hd__decap_3
Xwire146 wire146/A VGND VGND VPWR VPWR wire146/X sky130_fd_sc_hd__clkbuf_4
XFILLER_50_64 VGND VGND VPWR VPWR sky130_fd_sc_hd__decap_3
Xwire179 wire179/A VGND VGND VPWR VPWR wire179/X sky130_fd_sc_hd__clkbuf_4
XFILLER_109_187 VGND VGND VPWR VPWR sky130_fd_sc_hd__fill_2
XFILLER_105_371 VGND VGND VPWR VPWR sky130_fd_sc_hd__decap_3
XFILLER_59_73 VGND VGND VPWR VPWR sky130_fd_sc_hd__decap_3
XFILLER_93_203 VGND VGND VPWR VPWR sky130_fd_sc_hd__decap_3
XFILLER_93_225 VGND VGND VPWR VPWR sky130_fd_sc_hd__decap_3
XTAP_TAPCELL_ROW_70_1090 VGND VPWR sky130_fd_sc_hd__tapvpwrvgnd_1
XFILLER_19_355 VGND VGND VPWR VPWR sky130_fd_sc_hd__decap_3
XFILLER_46_141 VGND VGND VPWR VPWR sky130_fd_sc_hd__decap_3
XTAP_TAPCELL_ROW_109_1554 VGND VPWR sky130_fd_sc_hd__tapvpwrvgnd_1
XFILLER_74_494 VGND VGND VPWR VPWR sky130_fd_sc_hd__decap_3
XPHY_EDGE_ROW_93_Left_209 VGND VGND VPWR VPWR sky130_fd_sc_hd__decap_3
XFILLER_34_358 VGND VGND VPWR VPWR sky130_fd_sc_hd__decap_3
XFILLER_62_645 VGND VGND VPWR VPWR sky130_fd_sc_hd__decap_3
XFILLER_15_561 VGND VGND VPWR VPWR sky130_fd_sc_hd__decap_3
X_2970_ _5836_/Q _5452_/Q _2971_/S VGND VGND VPWR VPWR _2970_/X sky130_fd_sc_hd__mux2_1
XFILLER_15_594 VGND VGND VPWR VPWR sky130_fd_sc_hd__decap_3
XFILLER_30_542 VGND VGND VPWR VPWR sky130_fd_sc_hd__decap_3
X_4640_ _4777_/A1 _4640_/A2 _4640_/B1 _4640_/B2 VGND VGND VPWR VPWR _5687_/D sky130_fd_sc_hd__a22o_2
XFILLER_30_597 VGND VGND VPWR VPWR sky130_fd_sc_hd__fill_1
X_4571_ _4776_/A1 _4571_/A2 _4571_/B1 _4571_/B2 VGND VGND VPWR VPWR _5622_/D sky130_fd_sc_hd__a22o_2
XFILLER_115_113 VGND VGND VPWR VPWR sky130_fd_sc_hd__decap_3
XFILLER_115_124 VGND VGND VPWR VPWR sky130_fd_sc_hd__decap_3
X_3522_ _3867_/A _3522_/B VGND VGND VPWR VPWR _3522_/X sky130_fd_sc_hd__or2_2
X_3453_ _5697_/Q _5665_/Q _5633_/Q _5601_/Q _3644_/S _3698_/S1 VGND VGND VPWR VPWR
+ _3454_/B sky130_fd_sc_hd__mux4_2
XFILLER_115_179 VGND VGND VPWR VPWR sky130_fd_sc_hd__decap_3
Xhold2106 _5066_/Q VGND VGND VPWR VPWR _3970_/B2 sky130_fd_sc_hd__dlygate4sd3_1
Xhold2117 _5450_/Q VGND VGND VPWR VPWR _4387_/B2 sky130_fd_sc_hd__dlygate4sd3_1
X_5123_ _6019_/CLK _5123_/D VGND VGND VPWR VPWR _5123_/Q sky130_fd_sc_hd__dfxtp_2
X_3384_ _5822_/Q _5438_/Q _3609_/S VGND VGND VPWR VPWR _3385_/B sky130_fd_sc_hd__mux2_1
XFILLER_84_203 VGND VGND VPWR VPWR sky130_fd_sc_hd__fill_1
XFILLER_97_586 VGND VGND VPWR VPWR sky130_fd_sc_hd__decap_3
Xhold1405 _5790_/Q VGND VGND VPWR VPWR _4752_/B2 sky130_fd_sc_hd__dlygate4sd3_1
Xhold1416 _6026_/Q VGND VGND VPWR VPWR _5000_/B2 sky130_fd_sc_hd__dlygate4sd3_1
Xhold2128 _5839_/Q VGND VGND VPWR VPWR _4801_/B sky130_fd_sc_hd__dlygate4sd3_1
Xhold2139 _5227_/Q VGND VGND VPWR VPWR _4148_/B2 sky130_fd_sc_hd__dlygate4sd3_1
Xload_slew674 wire676/A VGND VGND VPWR VPWR _2904_/A1 sky130_fd_sc_hd__buf_2
XFILLER_111_396 VGND VGND VPWR VPWR sky130_fd_sc_hd__decap_3
Xhold1427 _5584_/Q VGND VGND VPWR VPWR _4530_/B2 sky130_fd_sc_hd__dlygate4sd3_1
Xhold1438 _5428_/Q VGND VGND VPWR VPWR _4362_/B2 sky130_fd_sc_hd__dlygate4sd3_1
Xhold1449 _6042_/Q VGND VGND VPWR VPWR _5018_/B2 sky130_fd_sc_hd__dlygate4sd3_1
X_5054_ _6045_/CLK _5054_/D VGND VGND VPWR VPWR _5054_/Q sky130_fd_sc_hd__dfxtp_2
X_4005_ _4998_/A1 _4005_/A2 _4005_/B1 _4005_/B2 VGND VGND VPWR VPWR _5096_/D sky130_fd_sc_hd__a22o_2
XFILLER_1_91 VGND VGND VPWR VPWR sky130_fd_sc_hd__decap_3
XFILLER_53_612 VGND VGND VPWR VPWR sky130_fd_sc_hd__decap_3
XFILLER_65_483 VGND VGND VPWR VPWR sky130_fd_sc_hd__decap_3
XFILLER_111_15 VGND VGND VPWR VPWR sky130_fd_sc_hd__decap_3
XFILLER_25_358 VGND VGND VPWR VPWR sky130_fd_sc_hd__decap_3
XFILLER_37_185 VGND VGND VPWR VPWR sky130_fd_sc_hd__decap_3
XFILLER_37_196 VGND VGND VPWR VPWR sky130_fd_sc_hd__fill_1
XTAP_TAPCELL_ROW_84_1259 VGND VPWR sky130_fd_sc_hd__tapvpwrvgnd_1
XFILLER_111_48 VGND VGND VPWR VPWR sky130_fd_sc_hd__decap_3
XFILLER_80_486 VGND VGND VPWR VPWR sky130_fd_sc_hd__decap_3
X_5956_ _5956_/CLK _5956_/D VGND VGND VPWR VPWR _5956_/Q sky130_fd_sc_hd__dfxtp_2
XTAP_TAPCELL_ROW_23_526 VGND VPWR sky130_fd_sc_hd__tapvpwrvgnd_1
X_5887_ _5932_/CLK _5887_/D VGND VGND VPWR VPWR _5887_/Q sky130_fd_sc_hd__dfxtp_2
X_4907_ _5043_/A1 _4907_/A2 wire139/X _4907_/B2 VGND VGND VPWR VPWR _5939_/D sky130_fd_sc_hd__a22o_2
XTAP_TAPCELL_ROW_51_857 VGND VPWR sky130_fd_sc_hd__tapvpwrvgnd_1
X_4838_ _5042_/A1 _4841_/A2 _4841_/B1 _4838_/B2 VGND VGND VPWR VPWR _5874_/D sky130_fd_sc_hd__a22o_2
XFILLER_107_614 VGND VGND VPWR VPWR sky130_fd_sc_hd__fill_2
X_4769_ _4903_/A1 _4776_/A2 _4776_/B1 _4769_/B2 VGND VGND VPWR VPWR _5807_/D sky130_fd_sc_hd__a22o_2
XFILLER_112_7 VGND VGND VPWR VPWR sky130_fd_sc_hd__decap_3
XFILLER_105_6 VGND VGND VPWR VPWR sky130_fd_sc_hd__decap_3
XFILLER_107_669 VGND VGND VPWR VPWR sky130_fd_sc_hd__decap_3
XTAP_TAPCELL_ROW_95_1388 VGND VPWR sky130_fd_sc_hd__tapvpwrvgnd_1
XFILLER_106_168 VGND VGND VPWR VPWR sky130_fd_sc_hd__decap_3
XFILLER_102_363 VGND VGND VPWR VPWR sky130_fd_sc_hd__fill_1
XFILLER_29_21 VGND VGND VPWR VPWR sky130_fd_sc_hd__decap_3
XFILLER_29_54 VGND VGND VPWR VPWR sky130_fd_sc_hd__fill_2
XFILLER_29_620 VGND VGND VPWR VPWR sky130_fd_sc_hd__decap_3
XFILLER_75_225 VGND VGND VPWR VPWR sky130_fd_sc_hd__decap_3
XFILLER_28_141 VGND VGND VPWR VPWR sky130_fd_sc_hd__fill_2
XTAP_TAPCELL_ROW_59_957 VGND VPWR sky130_fd_sc_hd__tapvpwrvgnd_1
Xhold1950 _5914_/Q VGND VGND VPWR VPWR _4882_/B2 sky130_fd_sc_hd__dlygate4sd3_1
Xhold1961 _5103_/Q VGND VGND VPWR VPWR _4012_/B2 sky130_fd_sc_hd__dlygate4sd3_1
Xhold1972 _5733_/Q VGND VGND VPWR VPWR _4690_/B2 sky130_fd_sc_hd__dlygate4sd3_1
XTAP_TAPCELL_ROW_3_284 VGND VPWR sky130_fd_sc_hd__tapvpwrvgnd_1
Xhold1983 _5364_/Q VGND VGND VPWR VPWR _4294_/B2 sky130_fd_sc_hd__dlygate4sd3_1
Xhold1994 _5112_/Q VGND VGND VPWR VPWR _4024_/B2 sky130_fd_sc_hd__dlygate4sd3_1
XFILLER_44_645 VGND VGND VPWR VPWR sky130_fd_sc_hd__decap_3
XFILLER_45_64 VGND VGND VPWR VPWR sky130_fd_sc_hd__decap_3
XFILLER_45_75 VGND VGND VPWR VPWR sky130_fd_sc_hd__decap_3
XFILLER_71_497 VGND VGND VPWR VPWR sky130_fd_sc_hd__decap_3
XFILLER_101_92 VGND VGND VPWR VPWR sky130_fd_sc_hd__fill_1
XFILLER_8_513 VGND VGND VPWR VPWR sky130_fd_sc_hd__fill_2
XTAP_TAPCELL_ROW_104_1495 VGND VPWR sky130_fd_sc_hd__tapvpwrvgnd_1
XFILLER_61_63 VGND VGND VPWR VPWR sky130_fd_sc_hd__fill_2
XFILLER_8_568 VGND VGND VPWR VPWR sky130_fd_sc_hd__decap_3
XANTENNA_7 _4332_/Y VGND VGND VPWR VPWR sky130_fd_sc_hd__diode_2
XFILLER_6_47 VGND VGND VPWR VPWR sky130_fd_sc_hd__decap_3
XFILLER_113_617 VGND VGND VPWR VPWR sky130_fd_sc_hd__decap_3
XFILLER_98_317 VGND VGND VPWR VPWR sky130_fd_sc_hd__fill_1
XFILLER_112_138 VGND VGND VPWR VPWR sky130_fd_sc_hd__fill_2
XFILLER_79_520 VGND VGND VPWR VPWR sky130_fd_sc_hd__decap_3
XFILLER_20_6 VGND VGND VPWR VPWR sky130_fd_sc_hd__fill_1
XFILLER_79_553 VGND VGND VPWR VPWR sky130_fd_sc_hd__decap_3
XFILLER_66_203 VGND VGND VPWR VPWR sky130_fd_sc_hd__fill_1
Xfanout1074 _3339_/S VGND VGND VPWR VPWR _3880_/S sky130_fd_sc_hd__clkbuf_2
Xfanout1052 _3919_/S1 VGND VGND VPWR VPWR _3805_/S1 sky130_fd_sc_hd__clkdlybuf4s25_1
Xfanout1041 _3940_/S1 VGND VGND VPWR VPWR _3905_/S1 sky130_fd_sc_hd__clkdlybuf4s25_1
XFILLER_94_556 VGND VGND VPWR VPWR sky130_fd_sc_hd__fill_1
Xfanout1096 _3785_/S VGND VGND VPWR VPWR _3790_/S sky130_fd_sc_hd__clkbuf_4
Xfanout1085 input11/X VGND VGND VPWR VPWR _3818_/S sky130_fd_sc_hd__dlymetal6s4s_1
XFILLER_35_601 VGND VGND VPWR VPWR sky130_fd_sc_hd__decap_3
XFILLER_35_623 VGND VGND VPWR VPWR sky130_fd_sc_hd__decap_3
XFILLER_94_589 VGND VGND VPWR VPWR sky130_fd_sc_hd__decap_3
XFILLER_62_475 VGND VGND VPWR VPWR sky130_fd_sc_hd__fill_1
X_5810_ _5810_/CLK _5810_/D VGND VGND VPWR VPWR _5810_/Q sky130_fd_sc_hd__dfxtp_2
XFILLER_22_328 VGND VGND VPWR VPWR sky130_fd_sc_hd__fill_2
X_5741_ _5805_/CLK _5741_/D VGND VGND VPWR VPWR _5741_/Q sky130_fd_sc_hd__dfxtp_2
X_2953_ _3195_/A1 _2951_/X _2952_/X _2499_/A VGND VGND VPWR VPWR _2953_/X sky130_fd_sc_hd__o22a_2
XFILLER_30_350 VGND VGND VPWR VPWR sky130_fd_sc_hd__decap_3
X_5672_ _5704_/CLK _5672_/D VGND VGND VPWR VPWR _5672_/Q sky130_fd_sc_hd__dfxtp_2
X_2884_ _5832_/Q _5448_/Q _3221_/S VGND VGND VPWR VPWR _2884_/X sky130_fd_sc_hd__mux2_1
X_4623_ _4760_/A1 _4640_/A2 _4640_/B1 _4623_/B2 VGND VGND VPWR VPWR _5670_/D sky130_fd_sc_hd__a22o_2
X_4554_ _4927_/A1 _4566_/A2 _4566_/B1 _4554_/B2 VGND VGND VPWR VPWR _5605_/D sky130_fd_sc_hd__a22o_2
X_3505_ _3494_/X _3503_/X _3504_/X _3855_/B1 VGND VGND VPWR VPWR _3505_/X sky130_fd_sc_hd__o31a_2
XFILLER_104_606 VGND VGND VPWR VPWR sky130_fd_sc_hd__decap_3
XFILLER_104_639 VGND VGND VPWR VPWR sky130_fd_sc_hd__decap_3
X_4485_ _4519_/A1 _4503_/A2 _4496_/B1 _4485_/B2 VGND VGND VPWR VPWR _5541_/D sky130_fd_sc_hd__a22o_2
XFILLER_103_116 VGND VGND VPWR VPWR sky130_fd_sc_hd__decap_3
XFILLER_106_15 VGND VGND VPWR VPWR sky130_fd_sc_hd__decap_3
X_3436_ _3496_/A _3436_/B VGND VGND VPWR VPWR _3436_/X sky130_fd_sc_hd__or2_2
XFILLER_106_59 VGND VGND VPWR VPWR sky130_fd_sc_hd__decap_3
XFILLER_112_672 VGND VGND VPWR VPWR sky130_fd_sc_hd__decap_3
X_3367_ _5565_/Q _5533_/Q _3375_/S VGND VGND VPWR VPWR _3367_/X sky130_fd_sc_hd__mux2_1
XFILLER_85_534 VGND VGND VPWR VPWR sky130_fd_sc_hd__decap_3
Xhold1202 _5866_/Q VGND VGND VPWR VPWR _4830_/B2 sky130_fd_sc_hd__dlygate4sd3_1
Xhold1213 _5946_/Q VGND VGND VPWR VPWR _4916_/B2 sky130_fd_sc_hd__dlygate4sd3_1
Xhold1224 _5654_/Q VGND VGND VPWR VPWR _4605_/B2 sky130_fd_sc_hd__dlygate4sd3_1
Xload_slew471 _4328_/A2 VGND VGND VPWR VPWR _4299_/B sky130_fd_sc_hd__buf_4
X_5106_ _5805_/CLK _5106_/D VGND VGND VPWR VPWR _5106_/Q sky130_fd_sc_hd__dfxtp_2
Xhold1235 _5324_/Q VGND VGND VPWR VPWR _4252_/B2 sky130_fd_sc_hd__dlygate4sd3_1
Xhold1246 _6017_/Q VGND VGND VPWR VPWR _4991_/B2 sky130_fd_sc_hd__dlygate4sd3_1
Xhold1257 _6066_/Q VGND VGND VPWR VPWR _5042_/B2 sky130_fd_sc_hd__dlygate4sd3_1
Xload_slew493 _4226_/A2 VGND VGND VPWR VPWR _4197_/B sky130_fd_sc_hd__buf_4
X_5037_ _5037_/A1 _5045_/A2 _5045_/B1 _5037_/B2 VGND VGND VPWR VPWR _6061_/D sky130_fd_sc_hd__a22o_2
X_3298_ _5114_/Q _5082_/Q _6010_/Q _5978_/Q _3300_/S _3304_/S1 VGND VGND VPWR VPWR
+ _3298_/X sky130_fd_sc_hd__mux4_2
XFILLER_38_450 VGND VGND VPWR VPWR sky130_fd_sc_hd__decap_3
XFILLER_72_228 VGND VGND VPWR VPWR sky130_fd_sc_hd__decap_3
XTAP_TAPCELL_ROW_56_916 VGND VPWR sky130_fd_sc_hd__tapvpwrvgnd_1
XTAP_TAPCELL_ROW_56_927 VGND VPWR sky130_fd_sc_hd__tapvpwrvgnd_1
Xhold1268 _5998_/Q VGND VGND VPWR VPWR _4970_/B2 sky130_fd_sc_hd__dlygate4sd3_1
Xhold1279 _5799_/Q VGND VGND VPWR VPWR _4761_/B2 sky130_fd_sc_hd__dlygate4sd3_1
XFILLER_25_111 VGND VGND VPWR VPWR sky130_fd_sc_hd__fill_1
XFILLER_26_645 VGND VGND VPWR VPWR sky130_fd_sc_hd__fill_2
XFILLER_82_29 VGND VGND VPWR VPWR sky130_fd_sc_hd__fill_2
XTAP_TAPCELL_ROW_0_232 VGND VPWR sky130_fd_sc_hd__tapvpwrvgnd_1
XTAP_TAPCELL_ROW_0_243 VGND VPWR sky130_fd_sc_hd__tapvpwrvgnd_1
XTAP_TAPCELL_ROW_0_254 VGND VPWR sky130_fd_sc_hd__tapvpwrvgnd_1
XFILLER_15_12 VGND VGND VPWR VPWR sky130_fd_sc_hd__decap_3
XFILLER_26_678 VGND VGND VPWR VPWR sky130_fd_sc_hd__decap_3
XFILLER_40_103 VGND VGND VPWR VPWR sky130_fd_sc_hd__fill_1
XFILLER_41_626 VGND VGND VPWR VPWR sky130_fd_sc_hd__decap_3
XTAP_TAPCELL_ROW_36_684 VGND VPWR sky130_fd_sc_hd__tapvpwrvgnd_1
XFILLER_15_67 VGND VGND VPWR VPWR sky130_fd_sc_hd__decap_3
XFILLER_15_78 VGND VGND VPWR VPWR sky130_fd_sc_hd__decap_3
XFILLER_41_659 VGND VGND VPWR VPWR sky130_fd_sc_hd__fill_1
X_5939_ _6067_/CLK _5939_/D VGND VGND VPWR VPWR _5939_/Q sky130_fd_sc_hd__dfxtp_2
XTAP_TAPCELL_ROW_97_1417 VGND VPWR sky130_fd_sc_hd__tapvpwrvgnd_1
Xclkbuf_4_10_0_clk clkbuf_0_clk/X VGND VGND VPWR VPWR clkbuf_4_10_0_clk/X sky130_fd_sc_hd__clkbuf_8
XFILLER_103_3 VGND VGND VPWR VPWR sky130_fd_sc_hd__decap_3
Xoutput66 _3074_/X VGND VGND VPWR VPWR rd1[24] sky130_fd_sc_hd__clkbuf_2
Xoutput55 _2849_/X VGND VGND VPWR VPWR rd1[14] sky130_fd_sc_hd__clkbuf_2
XTAP_TAPCELL_ROW_8_343 VGND VPWR sky130_fd_sc_hd__tapvpwrvgnd_1
Xoutput99 _3814_/X VGND VGND VPWR VPWR rd2[25] sky130_fd_sc_hd__clkbuf_2
Xoutput88 _3594_/X VGND VGND VPWR VPWR rd2[15] sky130_fd_sc_hd__dlymetal6s2s_1
Xoutput77 _2642_/X VGND VGND VPWR VPWR rd1[5] sky130_fd_sc_hd__dlygate4sd1_1
XFILLER_102_160 VGND VGND VPWR VPWR sky130_fd_sc_hd__decap_3
XFILLER_48_203 VGND VGND VPWR VPWR sky130_fd_sc_hd__fill_2
XFILLER_48_225 VGND VGND VPWR VPWR sky130_fd_sc_hd__fill_1
XFILLER_17_612 VGND VGND VPWR VPWR sky130_fd_sc_hd__decap_3
XFILLER_76_589 VGND VGND VPWR VPWR sky130_fd_sc_hd__decap_3
Xhold1780 _5463_/Q VGND VGND VPWR VPWR _4400_/B2 sky130_fd_sc_hd__dlygate4sd3_1
XFILLER_56_85 VGND VGND VPWR VPWR sky130_fd_sc_hd__decap_3
XFILLER_91_548 VGND VGND VPWR VPWR sky130_fd_sc_hd__decap_3
XFILLER_91_559 VGND VGND VPWR VPWR sky130_fd_sc_hd__fill_1
XTAP_TAPCELL_ROW_106_1524 VGND VPWR sky130_fd_sc_hd__tapvpwrvgnd_1
Xhold1791 _5470_/Q VGND VGND VPWR VPWR _4410_/B2 sky130_fd_sc_hd__dlygate4sd3_1
XFILLER_17_667 VGND VGND VPWR VPWR sky130_fd_sc_hd__decap_3
XFILLER_112_80 VGND VGND VPWR VPWR sky130_fd_sc_hd__decap_3
XFILLER_112_91 VGND VGND VPWR VPWR sky130_fd_sc_hd__decap_3
XFILLER_16_177 VGND VGND VPWR VPWR sky130_fd_sc_hd__decap_3
XFILLER_31_147 VGND VGND VPWR VPWR sky130_fd_sc_hd__decap_3
XFILLER_68_6 VGND VGND VPWR VPWR sky130_fd_sc_hd__decap_3
XFILLER_8_365 VGND VGND VPWR VPWR sky130_fd_sc_hd__decap_3
XFILLER_8_398 VGND VGND VPWR VPWR sky130_fd_sc_hd__decap_3
XFILLER_98_147 VGND VGND VPWR VPWR sky130_fd_sc_hd__fill_1
X_4270_ _4510_/A1 wire475/X wire255/X _4270_/B2 VGND VGND VPWR VPWR _5340_/D sky130_fd_sc_hd__a22o_2
XFILLER_113_469 VGND VGND VPWR VPWR sky130_fd_sc_hd__fill_2
XFILLER_79_361 VGND VGND VPWR VPWR sky130_fd_sc_hd__fill_2
XFILLER_86_309 VGND VGND VPWR VPWR sky130_fd_sc_hd__fill_2
X_3221_ _5591_/Q _5559_/Q _3221_/S VGND VGND VPWR VPWR _3221_/X sky130_fd_sc_hd__mux2_1
XFILLER_67_523 VGND VGND VPWR VPWR sky130_fd_sc_hd__decap_3
X_3152_ _3198_/A _3148_/X _3151_/X _3207_/A1 VGND VGND VPWR VPWR _3152_/X sky130_fd_sc_hd__o211a_2
X_3083_ _5265_/Q _5233_/Q _3083_/S VGND VGND VPWR VPWR _3083_/X sky130_fd_sc_hd__mux2_1
XFILLER_23_615 VGND VGND VPWR VPWR sky130_fd_sc_hd__fill_1
XFILLER_22_103 VGND VGND VPWR VPWR sky130_fd_sc_hd__fill_1
XFILLER_50_401 VGND VGND VPWR VPWR sky130_fd_sc_hd__fill_1
XFILLER_62_283 VGND VGND VPWR VPWR sky130_fd_sc_hd__fill_1
XFILLER_90_592 VGND VGND VPWR VPWR sky130_fd_sc_hd__decap_3
XTAP_TAPCELL_ROW_81_1218 VGND VPWR sky130_fd_sc_hd__tapvpwrvgnd_1
XFILLER_22_147 VGND VGND VPWR VPWR sky130_fd_sc_hd__decap_3
XTAP_TAPCELL_ROW_33_643 VGND VPWR sky130_fd_sc_hd__tapvpwrvgnd_1
X_3985_ input5/X input4/X VGND VGND VPWR VPWR _4057_/B sky130_fd_sc_hd__nand2_2
XFILLER_10_309 VGND VGND VPWR VPWR sky130_fd_sc_hd__decap_3
XTAP_TAPCELL_ROW_61_985 VGND VPWR sky130_fd_sc_hd__tapvpwrvgnd_1
X_5724_ _6035_/CLK _5724_/D VGND VGND VPWR VPWR _5724_/Q sky130_fd_sc_hd__dfxtp_2
X_2936_ _2936_/A1 _2934_/X _2935_/X _3222_/B2 VGND VGND VPWR VPWR _2936_/X sky130_fd_sc_hd__o22a_2
X_5655_ _6071_/CLK _5655_/D VGND VGND VPWR VPWR _5655_/Q sky130_fd_sc_hd__dfxtp_2
X_2867_ _5415_/Q _5063_/Q _3217_/S VGND VGND VPWR VPWR _2867_/X sky130_fd_sc_hd__mux2_1
XFILLER_108_208 VGND VGND VPWR VPWR sky130_fd_sc_hd__decap_3
X_4606_ _4777_/A1 _4606_/A2 _4606_/B1 _4606_/B2 VGND VGND VPWR VPWR _5655_/D sky130_fd_sc_hd__a22o_2
X_5586_ _6045_/CLK _5586_/D VGND VGND VPWR VPWR _5586_/Q sky130_fd_sc_hd__dfxtp_2
X_2798_ _5380_/Q _5348_/Q _5316_/Q _5284_/Q _2800_/S _3157_/S1 VGND VGND VPWR VPWR
+ _2798_/X sky130_fd_sc_hd__mux4_2
X_4537_ _4843_/A1 _4537_/A2 _4537_/B1 _4537_/B2 VGND VGND VPWR VPWR _5591_/D sky130_fd_sc_hd__a22o_2
X_4468_ _4468_/A1 _4468_/A2 _4468_/B1 _4468_/B2 VGND VGND VPWR VPWR _5526_/D sky130_fd_sc_hd__a22o_2
XTAP_TAPCELL_ROW_92_1358 VGND VPWR sky130_fd_sc_hd__tapvpwrvgnd_1
XFILLER_77_29 VGND VGND VPWR VPWR sky130_fd_sc_hd__fill_1
XFILLER_89_169 VGND VGND VPWR VPWR sky130_fd_sc_hd__decap_3
XTAP_TAPCELL_ROW_5_313 VGND VPWR sky130_fd_sc_hd__tapvpwrvgnd_1
Xfanout823 _3070_/S VGND VGND VPWR VPWR _3060_/S sky130_fd_sc_hd__clkbuf_4
Xfanout801 _2593_/S VGND VGND VPWR VPWR _2578_/S sky130_fd_sc_hd__dlymetal6s2s_1
X_3419_ _3417_/X _3418_/X wire553/A VGND VGND VPWR VPWR _3419_/X sky130_fd_sc_hd__o21a_2
Xfanout867 input48/X VGND VGND VPWR VPWR _5025_/A1 sky130_fd_sc_hd__clkdlybuf4s25_1
Xfanout856 _3155_/S0 VGND VGND VPWR VPWR _2724_/S0 sky130_fd_sc_hd__clkdlybuf4s25_1
X_4399_ _4776_/A1 _4399_/A2 wire238/X _4399_/B2 VGND VGND VPWR VPWR _5462_/D sky130_fd_sc_hd__a22o_2
Xfanout889 input42/X VGND VGND VPWR VPWR _5019_/A1 sky130_fd_sc_hd__clkdlybuf4s25_1
Xfanout878 input45/X VGND VGND VPWR VPWR _5022_/A1 sky130_fd_sc_hd__clkdlybuf4s25_1
XFILLER_58_589 VGND VGND VPWR VPWR sky130_fd_sc_hd__fill_2
X_6069_ _6069_/CLK _6069_/D VGND VGND VPWR VPWR _6069_/Q sky130_fd_sc_hd__dfxtp_2
XFILLER_26_22 VGND VGND VPWR VPWR sky130_fd_sc_hd__decap_3
XFILLER_38_280 VGND VGND VPWR VPWR sky130_fd_sc_hd__decap_3
XFILLER_73_559 VGND VGND VPWR VPWR sky130_fd_sc_hd__fill_1
XFILLER_26_55 VGND VGND VPWR VPWR sky130_fd_sc_hd__decap_3
XFILLER_26_66 VGND VGND VPWR VPWR sky130_fd_sc_hd__fill_2
XFILLER_14_637 VGND VGND VPWR VPWR sky130_fd_sc_hd__decap_3
XFILLER_14_648 VGND VGND VPWR VPWR sky130_fd_sc_hd__decap_3
XFILLER_26_475 VGND VGND VPWR VPWR sky130_fd_sc_hd__fill_1
XFILLER_26_486 VGND VGND VPWR VPWR sky130_fd_sc_hd__fill_2
XFILLER_22_670 VGND VGND VPWR VPWR sky130_fd_sc_hd__decap_3
XTAP_TAPCELL_ROW_101_1465 VGND VPWR sky130_fd_sc_hd__tapvpwrvgnd_1
XFILLER_5_313 VGND VGND VPWR VPWR sky130_fd_sc_hd__fill_1
XFILLER_5_379 VGND VGND VPWR VPWR sky130_fd_sc_hd__decap_3
XFILLER_107_296 VGND VGND VPWR VPWR sky130_fd_sc_hd__fill_2
XFILLER_3_15 VGND VGND VPWR VPWR sky130_fd_sc_hd__decap_3
XFILLER_1_596 VGND VGND VPWR VPWR sky130_fd_sc_hd__decap_3
XFILLER_3_48 VGND VGND VPWR VPWR sky130_fd_sc_hd__decap_3
XFILLER_67_51 VGND VGND VPWR VPWR sky130_fd_sc_hd__decap_3
XTAP_TAPCELL_ROW_112_1594 VGND VPWR sky130_fd_sc_hd__tapvpwrvgnd_1
XFILLER_103_480 VGND VGND VPWR VPWR sky130_fd_sc_hd__fill_2
XFILLER_64_515 VGND VGND VPWR VPWR sky130_fd_sc_hd__fill_1
XFILLER_17_420 VGND VGND VPWR VPWR sky130_fd_sc_hd__decap_3
XFILLER_36_228 VGND VGND VPWR VPWR sky130_fd_sc_hd__fill_1
XFILLER_76_397 VGND VGND VPWR VPWR sky130_fd_sc_hd__decap_3
XFILLER_91_334 VGND VGND VPWR VPWR sky130_fd_sc_hd__fill_2
Xload_slew1040 _3788_/S1 VGND VGND VPWR VPWR _3772_/S1 sky130_fd_sc_hd__buf_4
Xload_slew1051 _3799_/S1 VGND VGND VPWR VPWR _3808_/S1 sky130_fd_sc_hd__buf_4
XTAP_TAPCELL_ROW_67_1051 VGND VPWR sky130_fd_sc_hd__tapvpwrvgnd_1
Xload_slew1073 _3427_/S VGND VGND VPWR VPWR _3733_/S sky130_fd_sc_hd__buf_4
Xload_slew1084 _3712_/S VGND VGND VPWR VPWR _3568_/S sky130_fd_sc_hd__buf_2
Xload_slew1095 fanout1094/X VGND VGND VPWR VPWR _3469_/S0 sky130_fd_sc_hd__clkbuf_4
XFILLER_17_486 VGND VGND VPWR VPWR sky130_fd_sc_hd__decap_3
XFILLER_72_570 VGND VGND VPWR VPWR sky130_fd_sc_hd__fill_1
XFILLER_72_592 VGND VGND VPWR VPWR sky130_fd_sc_hd__decap_3
XFILLER_91_389 VGND VGND VPWR VPWR sky130_fd_sc_hd__decap_3
XFILLER_13_670 VGND VGND VPWR VPWR sky130_fd_sc_hd__fill_2
XFILLER_32_489 VGND VGND VPWR VPWR sky130_fd_sc_hd__decap_3
XTAP_TAPCELL_ROW_30_613 VGND VPWR sky130_fd_sc_hd__tapvpwrvgnd_1
X_3770_ _3922_/B1 _3753_/X _3760_/X _3764_/X VGND VGND VPWR VPWR _3770_/X sky130_fd_sc_hd__a22o_2
X_2721_ _5825_/Q _5441_/Q _2732_/S VGND VGND VPWR VPWR _2721_/X sky130_fd_sc_hd__mux2_1
XFILLER_9_685 VGND VGND VPWR VPWR sky130_fd_sc_hd__decap_3
X_5440_ _5824_/CLK _5440_/D VGND VGND VPWR VPWR _5440_/Q sky130_fd_sc_hd__dfxtp_2
XFILLER_8_195 VGND VGND VPWR VPWR sky130_fd_sc_hd__fill_1
XTAP_TAPCELL_ROW_10_370 VGND VPWR sky130_fd_sc_hd__tapvpwrvgnd_1
X_2652_ _3105_/A1 _2650_/X _2651_/X _3105_/B2 VGND VGND VPWR VPWR _2652_/X sky130_fd_sc_hd__o22a_2
XTAP_TAPCELL_ROW_78_1180 VGND VPWR sky130_fd_sc_hd__tapvpwrvgnd_1
X_5371_ _5658_/CLK _5371_/D VGND VGND VPWR VPWR _5371_/Q sky130_fd_sc_hd__dfxtp_2
X_2583_ wire643/X _2581_/X _2582_/X _3004_/B2 VGND VGND VPWR VPWR _2583_/X sky130_fd_sc_hd__o22a_2
XFILLER_99_445 VGND VGND VPWR VPWR sky130_fd_sc_hd__decap_3
XTAP_TAPCELL_ROW_78_1191 VGND VPWR sky130_fd_sc_hd__tapvpwrvgnd_1
X_4322_ _4528_/A1 _4327_/A2 wire248/X _4322_/B2 VGND VGND VPWR VPWR _5390_/D sky130_fd_sc_hd__a22o_2
Xfanout119 _5015_/Y VGND VGND VPWR VPWR _5047_/B1 sky130_fd_sc_hd__clkdlybuf4s25_1
X_4253_ _4527_/A1 _4258_/A2 _4253_/B1 _4253_/B2 VGND VGND VPWR VPWR _5325_/D sky130_fd_sc_hd__a22o_2
XFILLER_86_117 VGND VGND VPWR VPWR sky130_fd_sc_hd__decap_3
X_3204_ _5846_/Q _5462_/Q _3204_/S VGND VGND VPWR VPWR _3204_/X sky130_fd_sc_hd__mux2_1
XFILLER_86_139 VGND VGND VPWR VPWR sky130_fd_sc_hd__fill_1
X_4184_ _5003_/A1 _4189_/A2 wire283/X _4184_/B2 VGND VGND VPWR VPWR _5261_/D sky130_fd_sc_hd__a22o_2
XFILLER_95_684 VGND VGND VPWR VPWR sky130_fd_sc_hd__decap_3
XTAP_TAPCELL_ROW_38_702 VGND VPWR sky130_fd_sc_hd__tapvpwrvgnd_1
X_3135_ _3185_/A1 _3131_/X _3134_/X _3129_/X VGND VGND VPWR VPWR _3135_/X sky130_fd_sc_hd__a31o_2
XFILLER_94_183 VGND VGND VPWR VPWR sky130_fd_sc_hd__fill_1
X_3066_ _3058_/A _3062_/X _3065_/X _3207_/B2 VGND VGND VPWR VPWR _3066_/X sky130_fd_sc_hd__o211a_2
XFILLER_82_356 VGND VGND VPWR VPWR sky130_fd_sc_hd__decap_3
XTAP_TAPCELL_ROW_18_470 VGND VPWR sky130_fd_sc_hd__tapvpwrvgnd_1
XFILLER_23_478 VGND VGND VPWR VPWR sky130_fd_sc_hd__decap_3
X_3968_ _4998_/A1 _3974_/A2 wire322/A _3968_/B2 VGND VGND VPWR VPWR _5064_/D sky130_fd_sc_hd__a22o_2
X_5707_ _5867_/CLK _5707_/D VGND VGND VPWR VPWR _5707_/Q sky130_fd_sc_hd__dfxtp_2
X_2919_ _5578_/Q _5546_/Q _2919_/S VGND VGND VPWR VPWR _2919_/X sky130_fd_sc_hd__mux2_1
XFILLER_12_35 VGND VGND VPWR VPWR sky130_fd_sc_hd__fill_1
X_3899_ _3887_/X _3897_/X _3898_/X _3899_/B1 VGND VGND VPWR VPWR _3899_/X sky130_fd_sc_hd__o31a_2
X_5638_ _5790_/CLK _5638_/D VGND VGND VPWR VPWR _5638_/Q sky130_fd_sc_hd__dfxtp_2
X_5569_ _6058_/CLK _5569_/D VGND VGND VPWR VPWR _5569_/Q sky130_fd_sc_hd__dfxtp_2
Xfanout642 _3004_/A1 VGND VGND VPWR VPWR wire643/A sky130_fd_sc_hd__clkdlybuf4s25_1
Xfanout631 _3833_/B2 VGND VGND VPWR VPWR _3939_/A1 sky130_fd_sc_hd__clkdlybuf4s25_1
XFILLER_58_331 VGND VGND VPWR VPWR sky130_fd_sc_hd__fill_1
Xfanout675 _3111_/B2 VGND VGND VPWR VPWR wire676/A sky130_fd_sc_hd__clkbuf_2
XFILLER_86_684 VGND VGND VPWR VPWR sky130_fd_sc_hd__decap_3
Xfanout697 _2496_/Y VGND VGND VPWR VPWR _3191_/A1 sky130_fd_sc_hd__clkdlybuf4s25_1
Xfanout686 _3222_/B2 VGND VGND VPWR VPWR _3094_/B2 sky130_fd_sc_hd__clkbuf_2
XFILLER_100_483 VGND VGND VPWR VPWR sky130_fd_sc_hd__decap_3
XFILLER_46_526 VGND VGND VPWR VPWR sky130_fd_sc_hd__decap_3
XFILLER_85_172 VGND VGND VPWR VPWR sky130_fd_sc_hd__fill_1
XFILLER_41_231 VGND VGND VPWR VPWR sky130_fd_sc_hd__decap_3
XFILLER_53_53 VGND VGND VPWR VPWR sky130_fd_sc_hd__decap_3
XFILLER_14_489 VGND VGND VPWR VPWR sky130_fd_sc_hd__decap_3
XFILLER_10_673 VGND VGND VPWR VPWR sky130_fd_sc_hd__decap_3
XFILLER_6_633 VGND VGND VPWR VPWR sky130_fd_sc_hd__decap_3
XFILLER_108_561 VGND VGND VPWR VPWR sky130_fd_sc_hd__decap_3
XFILLER_6_666 VGND VGND VPWR VPWR sky130_fd_sc_hd__decap_3
XTAP_TAPCELL_ROW_114_1612 VGND VPWR sky130_fd_sc_hd__tapvpwrvgnd_1
XTAP_TAPCELL_ROW_114_1623 VGND VPWR sky130_fd_sc_hd__tapvpwrvgnd_1
XFILLER_78_50 VGND VGND VPWR VPWR sky130_fd_sc_hd__decap_3
XFILLER_96_415 VGND VGND VPWR VPWR sky130_fd_sc_hd__decap_3
XFILLER_110_247 VGND VGND VPWR VPWR sky130_fd_sc_hd__decap_3
XFILLER_1_393 VGND VGND VPWR VPWR sky130_fd_sc_hd__decap_3
XFILLER_77_673 VGND VGND VPWR VPWR sky130_fd_sc_hd__fill_2
XFILLER_64_323 VGND VGND VPWR VPWR sky130_fd_sc_hd__fill_2
XFILLER_64_334 VGND VGND VPWR VPWR sky130_fd_sc_hd__fill_2
XFILLER_92_643 VGND VGND VPWR VPWR sky130_fd_sc_hd__fill_1
XFILLER_37_559 VGND VGND VPWR VPWR sky130_fd_sc_hd__fill_1
XFILLER_94_82 VGND VGND VPWR VPWR sky130_fd_sc_hd__fill_2
XFILLER_64_378 VGND VGND VPWR VPWR sky130_fd_sc_hd__fill_1
XFILLER_91_175 VGND VGND VPWR VPWR sky130_fd_sc_hd__fill_2
X_4940_ _5042_/A1 _4943_/A2 _4943_/B1 _4940_/B2 VGND VGND VPWR VPWR _5970_/D sky130_fd_sc_hd__a22o_2
X_4871_ _5041_/A1 wire367/X wire151/X _4871_/B2 VGND VGND VPWR VPWR _5905_/D sky130_fd_sc_hd__a22o_2
XTAP_TAPCELL_ROW_43_760 VGND VPWR sky130_fd_sc_hd__tapvpwrvgnd_1
XTAP_TAPCELL_ROW_43_771 VGND VPWR sky130_fd_sc_hd__tapvpwrvgnd_1
X_3822_ _5522_/Q _5490_/Q _3822_/S VGND VGND VPWR VPWR _3822_/X sky130_fd_sc_hd__mux2_1
XFILLER_20_437 VGND VGND VPWR VPWR sky130_fd_sc_hd__fill_2
XFILLER_60_595 VGND VGND VPWR VPWR sky130_fd_sc_hd__decap_3
X_3753_ _3753_/A1 _3750_/X _3752_/X VGND VGND VPWR VPWR _3753_/X sky130_fd_sc_hd__a21o_2
XFILLER_9_482 VGND VGND VPWR VPWR sky130_fd_sc_hd__decap_3
X_3684_ _3806_/A _3681_/X _3683_/X _3927_/B2 VGND VGND VPWR VPWR _3684_/X sky130_fd_sc_hd__a22o_2
X_2704_ _3019_/A _2701_/X _2703_/X wire641/X VGND VGND VPWR VPWR _2704_/X sky130_fd_sc_hd__o22a_2
X_5423_ _5871_/CLK _5423_/D VGND VGND VPWR VPWR _5423_/Q sky130_fd_sc_hd__dfxtp_2
X_2635_ _5693_/Q _5661_/Q _5629_/Q _5597_/Q _2638_/S _2996_/S1 VGND VGND VPWR VPWR
+ _2636_/B sky130_fd_sc_hd__mux4_2
X_5354_ _5514_/CLK _5354_/D VGND VGND VPWR VPWR _5354_/Q sky130_fd_sc_hd__dfxtp_2
X_4305_ _4885_/A1 _4329_/A2 _4321_/B1 _4305_/B2 VGND VGND VPWR VPWR _5373_/D sky130_fd_sc_hd__a22o_2
X_2566_ _2990_/A1 _2563_/X _2565_/X VGND VGND VPWR VPWR _2566_/Y sky130_fd_sc_hd__o21ai_2
XFILLER_101_203 VGND VGND VPWR VPWR sky130_fd_sc_hd__decap_3
XFILLER_99_264 VGND VGND VPWR VPWR sky130_fd_sc_hd__decap_3
X_5285_ _6021_/CLK _5285_/D VGND VGND VPWR VPWR _5285_/Q sky130_fd_sc_hd__dfxtp_2
X_2497_ _2503_/B _2497_/B VGND VGND VPWR VPWR _2497_/X sky130_fd_sc_hd__or2_2
XFILLER_101_225 VGND VGND VPWR VPWR sky130_fd_sc_hd__fill_2
XFILLER_114_15 VGND VGND VPWR VPWR sky130_fd_sc_hd__decap_3
XFILLER_68_640 VGND VGND VPWR VPWR sky130_fd_sc_hd__decap_3
X_4236_ _4750_/A1 wire482/X wire262/X _4236_/B2 VGND VGND VPWR VPWR _5308_/D sky130_fd_sc_hd__a22o_2
XFILLER_101_269 VGND VGND VPWR VPWR sky130_fd_sc_hd__decap_3
XFILLER_68_684 VGND VGND VPWR VPWR sky130_fd_sc_hd__decap_3
XPHY_EDGE_ROW_113_Left_229 VGND VGND VPWR VPWR sky130_fd_sc_hd__decap_3
X_4167_ _4986_/A1 _4192_/A2 _4180_/B1 _4167_/B2 VGND VGND VPWR VPWR _5244_/D sky130_fd_sc_hd__a22o_2
XFILLER_114_59 VGND VGND VPWR VPWR sky130_fd_sc_hd__decap_3
XFILLER_28_548 VGND VGND VPWR VPWR sky130_fd_sc_hd__decap_3
XFILLER_67_194 VGND VGND VPWR VPWR sky130_fd_sc_hd__fill_1
X_3118_ _3118_/A1 _3101_/X _3117_/X _3118_/B2 VGND VGND VPWR VPWR _3118_/X sky130_fd_sc_hd__a22o_2
X_4098_ _4985_/A1 _4124_/A2 _4124_/B1 _4098_/B2 VGND VGND VPWR VPWR _5179_/D sky130_fd_sc_hd__a22o_2
XFILLER_36_581 VGND VGND VPWR VPWR sky130_fd_sc_hd__decap_3
XFILLER_83_687 VGND VGND VPWR VPWR sky130_fd_sc_hd__fill_1
X_3049_ _3198_/A _3045_/X _3048_/X _3207_/B2 VGND VGND VPWR VPWR _3049_/X sky130_fd_sc_hd__o211a_2
XFILLER_23_220 VGND VGND VPWR VPWR sky130_fd_sc_hd__decap_3
XFILLER_36_592 VGND VGND VPWR VPWR sky130_fd_sc_hd__decap_3
XFILLER_82_197 VGND VGND VPWR VPWR sky130_fd_sc_hd__decap_3
XFILLER_90_18 VGND VGND VPWR VPWR sky130_fd_sc_hd__fill_2
XFILLER_23_264 VGND VGND VPWR VPWR sky130_fd_sc_hd__decap_3
XFILLER_90_29 VGND VGND VPWR VPWR sky130_fd_sc_hd__decap_3
Xwire306 wire306/A VGND VGND VPWR VPWR wire306/X sky130_fd_sc_hd__buf_4
XFILLER_7_408 VGND VGND VPWR VPWR sky130_fd_sc_hd__decap_3
XFILLER_109_325 VGND VGND VPWR VPWR sky130_fd_sc_hd__decap_3
XTAP_TAPCELL_ROW_21_498 VGND VPWR sky130_fd_sc_hd__tapvpwrvgnd_1
XFILLER_2_102 VGND VGND VPWR VPWR sky130_fd_sc_hd__fill_1
XFILLER_105_553 VGND VGND VPWR VPWR sky130_fd_sc_hd__decap_3
XFILLER_3_647 VGND VGND VPWR VPWR sky130_fd_sc_hd__decap_3
XFILLER_105_564 VGND VGND VPWR VPWR sky130_fd_sc_hd__fill_1
Xfanout450 _4402_/Y VGND VGND VPWR VPWR _4403_/B sky130_fd_sc_hd__clkdlybuf4s25_1
Xfanout483 _4230_/Y VGND VGND VPWR VPWR _4261_/A2 sky130_fd_sc_hd__clkdlybuf4s25_1
Xfanout472 _4298_/Y VGND VGND VPWR VPWR _4331_/A2 sky130_fd_sc_hd__clkdlybuf4s25_1
Xfanout461 _4332_/Y VGND VGND VPWR VPWR wire462/A sky130_fd_sc_hd__clkdlybuf4s25_1
XFILLER_48_97 VGND VGND VPWR VPWR sky130_fd_sc_hd__fill_1
XFILLER_74_632 VGND VGND VPWR VPWR sky130_fd_sc_hd__decap_3
Xfanout494 _4196_/Y VGND VGND VPWR VPWR _4229_/A2 sky130_fd_sc_hd__clkdlybuf4s25_1
XFILLER_0_27 VGND VGND VPWR VPWR sky130_fd_sc_hd__fill_1
XFILLER_0_38 VGND VGND VPWR VPWR sky130_fd_sc_hd__decap_3
XFILLER_34_507 VGND VGND VPWR VPWR sky130_fd_sc_hd__decap_3
XFILLER_73_153 VGND VGND VPWR VPWR sky130_fd_sc_hd__decap_3
XFILLER_74_665 VGND VGND VPWR VPWR sky130_fd_sc_hd__fill_1
XFILLER_64_41 VGND VGND VPWR VPWR sky130_fd_sc_hd__decap_3
XFILLER_64_85 VGND VGND VPWR VPWR sky130_fd_sc_hd__fill_2
XTAP_TAPCELL_ROW_29_598 VGND VPWR sky130_fd_sc_hd__tapvpwrvgnd_1
XTAP_TAPCELL_ROW_64_1021 VGND VPWR sky130_fd_sc_hd__tapvpwrvgnd_1
XFILLER_42_562 VGND VGND VPWR VPWR sky130_fd_sc_hd__decap_3
XFILLER_9_36 VGND VGND VPWR VPWR sky130_fd_sc_hd__decap_3
XFILLER_14_286 VGND VGND VPWR VPWR sky130_fd_sc_hd__decap_3
XFILLER_42_595 VGND VGND VPWR VPWR sky130_fd_sc_hd__decap_3
XTAP_TAPCELL_ROW_40_730 VGND VPWR sky130_fd_sc_hd__tapvpwrvgnd_1
XFILLER_108_380 VGND VGND VPWR VPWR sky130_fd_sc_hd__decap_3
XFILLER_50_6 VGND VGND VPWR VPWR sky130_fd_sc_hd__fill_1
XFILLER_89_60 VGND VGND VPWR VPWR sky130_fd_sc_hd__decap_3
XTAP_TAPCELL_ROW_75_1150 VGND VPWR sky130_fd_sc_hd__tapvpwrvgnd_1
Xload_slew812 _2660_/S VGND VGND VPWR VPWR _2889_/S sky130_fd_sc_hd__buf_4
XFILLER_69_437 VGND VGND VPWR VPWR sky130_fd_sc_hd__decap_3
Xload_slew845 _3209_/S0 VGND VGND VPWR VPWR _3221_/S sky130_fd_sc_hd__buf_4
Xload_slew834 _2800_/S VGND VGND VPWR VPWR _3150_/S sky130_fd_sc_hd__clkbuf_4
X_5070_ _6062_/CLK _5070_/D VGND VGND VPWR VPWR _5070_/Q sky130_fd_sc_hd__dfxtp_2
XFILLER_111_578 VGND VGND VPWR VPWR sky130_fd_sc_hd__decap_3
XFILLER_29_3 VGND VGND VPWR VPWR sky130_fd_sc_hd__decap_3
XFILLER_84_429 VGND VGND VPWR VPWR sky130_fd_sc_hd__decap_3
Xhold1609 _5602_/Q VGND VGND VPWR VPWR _4551_/B2 sky130_fd_sc_hd__dlygate4sd3_1
X_4021_ input2/X input1/X VGND VGND VPWR VPWR _4878_/A sky130_fd_sc_hd__or2_2
XTAP_TAPCELL_ROW_48_830 VGND VPWR sky130_fd_sc_hd__tapvpwrvgnd_1
XFILLER_37_356 VGND VGND VPWR VPWR sky130_fd_sc_hd__decap_3
XFILLER_65_676 VGND VGND VPWR VPWR sky130_fd_sc_hd__fill_2
XFILLER_52_326 VGND VGND VPWR VPWR sky130_fd_sc_hd__decap_3
XFILLER_64_153 VGND VGND VPWR VPWR sky130_fd_sc_hd__decap_3
XFILLER_64_186 VGND VGND VPWR VPWR sky130_fd_sc_hd__decap_3
X_5972_ _6068_/CLK _5972_/D VGND VGND VPWR VPWR _5972_/Q sky130_fd_sc_hd__dfxtp_2
XFILLER_18_592 VGND VGND VPWR VPWR sky130_fd_sc_hd__decap_3
X_4923_ _5025_/A1 wire353/X wire136/A _4923_/B2 VGND VGND VPWR VPWR _5953_/D sky130_fd_sc_hd__a22o_2
X_4854_ _5024_/A1 _4868_/A2 wire146/X _4854_/B2 VGND VGND VPWR VPWR _5888_/D sky130_fd_sc_hd__a22o_2
XFILLER_20_234 VGND VGND VPWR VPWR sky130_fd_sc_hd__decap_3
XFILLER_20_256 VGND VGND VPWR VPWR sky130_fd_sc_hd__decap_3
X_4785_ wire1003/X _4785_/B VGND VGND VPWR VPWR _5823_/D sky130_fd_sc_hd__and2b_2
X_3805_ _5841_/Q _5457_/Q _6065_/Q _5969_/Q _3802_/S _3805_/S1 VGND VGND VPWR VPWR
+ _3806_/B sky130_fd_sc_hd__mux4_2
X_3736_ _5710_/Q _5678_/Q _5646_/Q _5614_/Q _3744_/S _3736_/S1 VGND VGND VPWR VPWR
+ _3736_/X sky130_fd_sc_hd__mux4_2
XFILLER_109_15 VGND VGND VPWR VPWR sky130_fd_sc_hd__decap_3
XFILLER_109_48 VGND VGND VPWR VPWR sky130_fd_sc_hd__decap_3
X_3667_ _3738_/A _3664_/X _3666_/X _3261_/B VGND VGND VPWR VPWR _3667_/X sky130_fd_sc_hd__a211o_2
X_5406_ _6013_/CLK _5406_/D VGND VGND VPWR VPWR _5406_/Q sky130_fd_sc_hd__dfxtp_2
X_3598_ _5928_/Q _5896_/Q _5864_/Q _5768_/Q _3779_/S _3905_/S1 VGND VGND VPWR VPWR
+ _3598_/X sky130_fd_sc_hd__mux4_2
X_2618_ _2618_/A _2618_/B _2608_/A VGND VGND VPWR VPWR _2619_/C sky130_fd_sc_hd__or3b_2
XFILLER_0_617 VGND VGND VPWR VPWR sky130_fd_sc_hd__decap_3
XFILLER_102_512 VGND VGND VPWR VPWR sky130_fd_sc_hd__decap_3
X_5337_ _5692_/CLK _5337_/D VGND VGND VPWR VPWR _5337_/Q sky130_fd_sc_hd__dfxtp_2
X_2549_ _3017_/C1 _2539_/X _2542_/X _2548_/X VGND VGND VPWR VPWR _2549_/X sky130_fd_sc_hd__a31o_2
XFILLER_87_234 VGND VGND VPWR VPWR sky130_fd_sc_hd__decap_3
X_5268_ _5572_/CLK _5268_/D VGND VGND VPWR VPWR _5268_/Q sky130_fd_sc_hd__dfxtp_2
XFILLER_102_567 VGND VGND VPWR VPWR sky130_fd_sc_hd__decap_3
XFILLER_102_578 VGND VGND VPWR VPWR sky130_fd_sc_hd__decap_3
XFILLER_102_589 VGND VGND VPWR VPWR sky130_fd_sc_hd__fill_1
X_4219_ _4527_/A1 _4224_/A2 _4219_/B1 _4219_/B2 VGND VGND VPWR VPWR _5293_/D sky130_fd_sc_hd__a22o_2
XTAP_TAPCELL_ROW_89_1319 VGND VPWR sky130_fd_sc_hd__tapvpwrvgnd_1
XFILLER_18_23 VGND VGND VPWR VPWR sky130_fd_sc_hd__decap_3
XFILLER_28_312 VGND VGND VPWR VPWR sky130_fd_sc_hd__decap_3
X_5199_ _6021_/CLK _5199_/D VGND VGND VPWR VPWR _5199_/Q sky130_fd_sc_hd__dfxtp_2
XFILLER_56_665 VGND VGND VPWR VPWR sky130_fd_sc_hd__decap_3
XTAP_TAPCELL_ROW_26_557 VGND VPWR sky130_fd_sc_hd__tapvpwrvgnd_1
XFILLER_24_595 VGND VGND VPWR VPWR sky130_fd_sc_hd__fill_1
XFILLER_34_88 VGND VGND VPWR VPWR sky130_fd_sc_hd__decap_3
XTAP_TAPCELL_ROW_54_899 VGND VPWR sky130_fd_sc_hd__tapvpwrvgnd_1
XFILLER_11_234 VGND VGND VPWR VPWR sky130_fd_sc_hd__decap_3
Xwire136 wire136/A VGND VGND VPWR VPWR wire136/X sky130_fd_sc_hd__clkbuf_4
XFILLER_109_155 VGND VGND VPWR VPWR sky130_fd_sc_hd__decap_3
XFILLER_3_422 VGND VGND VPWR VPWR sky130_fd_sc_hd__fill_2
XFILLER_112_309 VGND VGND VPWR VPWR sky130_fd_sc_hd__decap_3
XFILLER_78_234 VGND VGND VPWR VPWR sky130_fd_sc_hd__fill_2
XFILLER_115_91 VGND VGND VPWR VPWR sky130_fd_sc_hd__decap_3
XFILLER_15_9 VGND VGND VPWR VPWR sky130_fd_sc_hd__decap_3
XFILLER_66_429 VGND VGND VPWR VPWR sky130_fd_sc_hd__decap_3
XFILLER_93_215 VGND VGND VPWR VPWR sky130_fd_sc_hd__fill_1
XTAP_TAPCELL_ROW_70_1091 VGND VPWR sky130_fd_sc_hd__tapvpwrvgnd_1
Xfanout291 _4128_/Y VGND VGND VPWR VPWR wire292/A sky130_fd_sc_hd__clkdlybuf4s25_1
Xfanout280 wire283/A VGND VGND VPWR VPWR wire281/A sky130_fd_sc_hd__clkdlybuf4s25_1
XFILLER_46_131 VGND VGND VPWR VPWR sky130_fd_sc_hd__decap_3
XTAP_TAPCELL_ROW_109_1555 VGND VPWR sky130_fd_sc_hd__tapvpwrvgnd_1
XFILLER_19_389 VGND VGND VPWR VPWR sky130_fd_sc_hd__decap_3
XFILLER_46_197 VGND VGND VPWR VPWR sky130_fd_sc_hd__decap_3
XFILLER_62_635 VGND VGND VPWR VPWR sky130_fd_sc_hd__decap_3
XFILLER_62_679 VGND VGND VPWR VPWR sky130_fd_sc_hd__fill_1
XFILLER_42_381 VGND VGND VPWR VPWR sky130_fd_sc_hd__decap_3
XFILLER_91_83 VGND VGND VPWR VPWR sky130_fd_sc_hd__decap_3
XFILLER_98_6 VGND VGND VPWR VPWR sky130_fd_sc_hd__decap_3
XFILLER_42_392 VGND VGND VPWR VPWR sky130_fd_sc_hd__decap_3
XFILLER_30_587 VGND VGND VPWR VPWR sky130_fd_sc_hd__fill_1
X_4570_ _4775_/A1 wire421/X _4570_/B1 _4570_/B2 VGND VGND VPWR VPWR _5621_/D sky130_fd_sc_hd__a22o_2
X_3521_ _5380_/Q _5348_/Q _5316_/Q _5284_/Q _3857_/S _3868_/S1 VGND VGND VPWR VPWR
+ _3522_/B sky130_fd_sc_hd__mux4_2
XFILLER_115_103 VGND VGND VPWR VPWR sky130_fd_sc_hd__decap_3
XFILLER_115_147 VGND VGND VPWR VPWR sky130_fd_sc_hd__fill_1
X_3452_ _3404_/A _3449_/X _3451_/X _3448_/X VGND VGND VPWR VPWR _3452_/X sky130_fd_sc_hd__o211a_2
X_3383_ _5918_/Q _5886_/Q _5854_/Q _5758_/Q _3609_/S _3705_/S1 VGND VGND VPWR VPWR
+ _3383_/X sky130_fd_sc_hd__mux4_2
Xhold2107 _5669_/Q VGND VGND VPWR VPWR _4622_/B2 sky130_fd_sc_hd__dlygate4sd3_1
Xhold2118 _5822_/Q VGND VGND VPWR VPWR _4784_/B sky130_fd_sc_hd__dlygate4sd3_1
Xload_slew620 _3619_/A1 VGND VGND VPWR VPWR _3738_/A sky130_fd_sc_hd__buf_2
X_5122_ _5815_/CLK _5122_/D VGND VGND VPWR VPWR _5122_/Q sky130_fd_sc_hd__dfxtp_2
Xhold1406 _5774_/Q VGND VGND VPWR VPWR _4734_/B2 sky130_fd_sc_hd__dlygate4sd3_1
Xhold2129 _5488_/Q VGND VGND VPWR VPWR _4428_/B2 sky130_fd_sc_hd__dlygate4sd3_1
Xload_slew664 _3071_/B2 VGND VGND VPWR VPWR _3146_/B2 sky130_fd_sc_hd__clkbuf_4
Xload_slew653 _2727_/A1 VGND VGND VPWR VPWR _3094_/A1 sky130_fd_sc_hd__buf_4
XFILLER_111_375 VGND VGND VPWR VPWR sky130_fd_sc_hd__decap_3
XFILLER_111_386 VGND VGND VPWR VPWR sky130_fd_sc_hd__decap_3
Xhold1417 _5648_/Q VGND VGND VPWR VPWR _4599_/B2 sky130_fd_sc_hd__dlygate4sd3_1
Xhold1428 _5185_/Q VGND VGND VPWR VPWR _4104_/B2 sky130_fd_sc_hd__dlygate4sd3_1
Xhold1439 _5592_/Q VGND VGND VPWR VPWR _4541_/B2 sky130_fd_sc_hd__dlygate4sd3_1
X_5053_ _5794_/CLK _5053_/D VGND VGND VPWR VPWR _5053_/Q sky130_fd_sc_hd__dfxtp_2
X_4004_ _4658_/A1 wire540/X _4020_/B1 _4004_/B2 VGND VGND VPWR VPWR _5095_/D sky130_fd_sc_hd__a22o_2
XFILLER_1_81 VGND VGND VPWR VPWR sky130_fd_sc_hd__fill_2
XFILLER_37_153 VGND VGND VPWR VPWR sky130_fd_sc_hd__decap_3
XFILLER_111_27 VGND VGND VPWR VPWR sky130_fd_sc_hd__decap_3
XFILLER_80_421 VGND VGND VPWR VPWR sky130_fd_sc_hd__decap_3
XFILLER_92_292 VGND VGND VPWR VPWR sky130_fd_sc_hd__decap_3
XFILLER_52_156 VGND VGND VPWR VPWR sky130_fd_sc_hd__fill_2
XFILLER_80_454 VGND VGND VPWR VPWR sky130_fd_sc_hd__decap_3
X_5955_ _6051_/CLK _5955_/D VGND VGND VPWR VPWR _5955_/Q sky130_fd_sc_hd__dfxtp_2
XFILLER_52_178 VGND VGND VPWR VPWR sky130_fd_sc_hd__fill_1
XTAP_TAPCELL_ROW_23_527 VGND VPWR sky130_fd_sc_hd__tapvpwrvgnd_1
X_5886_ _6046_/CLK _5886_/D VGND VGND VPWR VPWR _5886_/Q sky130_fd_sc_hd__dfxtp_2
X_4906_ _5042_/A1 _4909_/A2 _4909_/B1 _4906_/B2 VGND VGND VPWR VPWR _5938_/D sky130_fd_sc_hd__a22o_2
XFILLER_21_554 VGND VGND VPWR VPWR sky130_fd_sc_hd__decap_3
XTAP_TAPCELL_ROW_51_858 VGND VPWR sky130_fd_sc_hd__tapvpwrvgnd_1
X_4837_ _5041_/A1 wire376/X _4843_/B1 _4837_/B2 VGND VGND VPWR VPWR _5873_/D sky130_fd_sc_hd__a22o_2
XFILLER_107_604 VGND VGND VPWR VPWR sky130_fd_sc_hd__fill_2
X_4768_ _4768_/A1 _4745_/B _4768_/B1 _4768_/B2 VGND VGND VPWR VPWR _5806_/D sky130_fd_sc_hd__a22o_2
XFILLER_20_24 VGND VGND VPWR VPWR sky130_fd_sc_hd__decap_3
X_4699_ _4768_/A1 _4676_/B _4699_/B1 _4699_/B2 VGND VGND VPWR VPWR _5742_/D sky130_fd_sc_hd__a22o_2
X_3719_ _5709_/Q _5677_/Q _5645_/Q _5613_/Q _3721_/S _3826_/S1 VGND VGND VPWR VPWR
+ _3719_/X sky130_fd_sc_hd__mux4_2
XFILLER_106_136 VGND VGND VPWR VPWR sky130_fd_sc_hd__decap_3
XFILLER_106_147 VGND VGND VPWR VPWR sky130_fd_sc_hd__decap_3
XFILLER_107_648 VGND VGND VPWR VPWR sky130_fd_sc_hd__decap_3
XFILLER_88_510 VGND VGND VPWR VPWR sky130_fd_sc_hd__fill_2
XTAP_TAPCELL_ROW_95_1389 VGND VPWR sky130_fd_sc_hd__tapvpwrvgnd_1
XFILLER_0_458 VGND VGND VPWR VPWR sky130_fd_sc_hd__decap_3
XTAP_TAPCELL_ROW_59_958 VGND VPWR sky130_fd_sc_hd__tapvpwrvgnd_1
Xhold1940 _5606_/Q VGND VGND VPWR VPWR _4555_/B2 sky130_fd_sc_hd__dlygate4sd3_1
Xhold1951 _5087_/Q VGND VGND VPWR VPWR _3996_/B2 sky130_fd_sc_hd__dlygate4sd3_1
Xhold1962 _5362_/Q VGND VGND VPWR VPWR _4292_/B2 sky130_fd_sc_hd__dlygate4sd3_1
XFILLER_16_315 VGND VGND VPWR VPWR sky130_fd_sc_hd__fill_1
XFILLER_29_676 VGND VGND VPWR VPWR sky130_fd_sc_hd__decap_3
XFILLER_90_207 VGND VGND VPWR VPWR sky130_fd_sc_hd__decap_3
XTAP_TAPCELL_ROW_3_285 VGND VPWR sky130_fd_sc_hd__tapvpwrvgnd_1
Xhold1973 _5936_/Q VGND VGND VPWR VPWR _4904_/B2 sky130_fd_sc_hd__dlygate4sd3_1
Xhold1984 _5510_/Q VGND VGND VPWR VPWR _4452_/B2 sky130_fd_sc_hd__dlygate4sd3_1
Xhold1995 _5473_/Q VGND VGND VPWR VPWR _4413_/B2 sky130_fd_sc_hd__dlygate4sd3_1
XFILLER_28_197 VGND VGND VPWR VPWR sky130_fd_sc_hd__decap_3
XFILLER_44_657 VGND VGND VPWR VPWR sky130_fd_sc_hd__fill_2
XFILLER_45_54 VGND VGND VPWR VPWR sky130_fd_sc_hd__fill_2
XFILLER_45_87 VGND VGND VPWR VPWR sky130_fd_sc_hd__decap_3
XTAP_TAPCELL_ROW_104_1496 VGND VPWR sky130_fd_sc_hd__tapvpwrvgnd_1
XFILLER_61_86 VGND VGND VPWR VPWR sky130_fd_sc_hd__decap_3
XFILLER_6_15 VGND VGND VPWR VPWR sky130_fd_sc_hd__decap_3
XANTENNA_8 _4436_/Y VGND VGND VPWR VPWR sky130_fd_sc_hd__diode_2
XFILLER_6_59 VGND VGND VPWR VPWR sky130_fd_sc_hd__decap_3
XFILLER_113_629 VGND VGND VPWR VPWR sky130_fd_sc_hd__decap_3
XFILLER_106_681 VGND VGND VPWR VPWR sky130_fd_sc_hd__decap_3
XFILLER_79_532 VGND VGND VPWR VPWR sky130_fd_sc_hd__decap_3
XFILLER_39_407 VGND VGND VPWR VPWR sky130_fd_sc_hd__decap_3
XFILLER_79_576 VGND VGND VPWR VPWR sky130_fd_sc_hd__decap_3
Xfanout1031 _3878_/S1 VGND VGND VPWR VPWR _3826_/S1 sky130_fd_sc_hd__clkdlybuf4s25_1
Xfanout1064 _3339_/S VGND VGND VPWR VPWR _3895_/S sky130_fd_sc_hd__clkbuf_2
Xfanout1042 _3868_/S1 VGND VGND VPWR VPWR _3870_/S1 sky130_fd_sc_hd__clkdlybuf4s25_1
XFILLER_13_6 VGND VGND VPWR VPWR sky130_fd_sc_hd__decap_3
XFILLER_94_568 VGND VGND VPWR VPWR sky130_fd_sc_hd__decap_3
XFILLER_94_579 VGND VGND VPWR VPWR sky130_fd_sc_hd__decap_3
Xfanout1086 _3469_/S0 VGND VGND VPWR VPWR _3707_/S sky130_fd_sc_hd__clkbuf_2
Xfanout1075 input11/X VGND VGND VPWR VPWR _3339_/S sky130_fd_sc_hd__clkbuf_2
XFILLER_19_164 VGND VGND VPWR VPWR sky130_fd_sc_hd__decap_3
XFILLER_19_186 VGND VGND VPWR VPWR sky130_fd_sc_hd__decap_3
XFILLER_34_101 VGND VGND VPWR VPWR sky130_fd_sc_hd__decap_3
XFILLER_35_635 VGND VGND VPWR VPWR sky130_fd_sc_hd__decap_3
XFILLER_22_307 VGND VGND VPWR VPWR sky130_fd_sc_hd__fill_1
XFILLER_35_679 VGND VGND VPWR VPWR sky130_fd_sc_hd__fill_1
XFILLER_50_627 VGND VGND VPWR VPWR sky130_fd_sc_hd__decap_3
XFILLER_96_3 VGND VGND VPWR VPWR sky130_fd_sc_hd__decap_3
X_5740_ _6058_/CLK _5740_/D VGND VGND VPWR VPWR _5740_/Q sky130_fd_sc_hd__dfxtp_2
X_2952_ _5419_/Q _5067_/Q _3060_/S VGND VGND VPWR VPWR _2952_/X sky130_fd_sc_hd__mux2_1
X_5671_ _5799_/CLK _5671_/D VGND VGND VPWR VPWR _5671_/Q sky130_fd_sc_hd__dfxtp_2
X_2883_ _3058_/A _2883_/B VGND VGND VPWR VPWR _2883_/X sky130_fd_sc_hd__or2_2
X_4622_ _4927_/A1 _4634_/A2 _4634_/B1 _4622_/B2 VGND VGND VPWR VPWR _5669_/D sky130_fd_sc_hd__a22o_2
X_4553_ _4926_/A1 wire421/A _4563_/B1 _4553_/B2 VGND VGND VPWR VPWR _5604_/D sky130_fd_sc_hd__a22o_2
XFILLER_7_580 VGND VGND VPWR VPWR sky130_fd_sc_hd__fill_2
X_4484_ _4994_/A1 wire437/X _4502_/B1 _4484_/B2 VGND VGND VPWR VPWR _5540_/D sky130_fd_sc_hd__a22o_2
X_3504_ wire628/A _3496_/X _3498_/X _3898_/A1 _3489_/X VGND VGND VPWR VPWR _3504_/X
+ sky130_fd_sc_hd__a32o_2
X_3435_ _5696_/Q _5664_/Q _5632_/Q _5600_/Q _3744_/S _3615_/S1 VGND VGND VPWR VPWR
+ _3436_/B sky130_fd_sc_hd__mux4_2
XFILLER_106_27 VGND VGND VPWR VPWR sky130_fd_sc_hd__fill_1
XFILLER_106_38 VGND VGND VPWR VPWR sky130_fd_sc_hd__decap_3
XFILLER_112_640 VGND VGND VPWR VPWR sky130_fd_sc_hd__decap_3
XFILLER_112_651 VGND VGND VPWR VPWR sky130_fd_sc_hd__decap_3
X_3366_ _5373_/Q _5341_/Q _5309_/Q _5277_/Q _3379_/S _3705_/S1 VGND VGND VPWR VPWR
+ _3366_/X sky130_fd_sc_hd__mux4_2
XFILLER_112_684 VGND VGND VPWR VPWR sky130_fd_sc_hd__decap_3
XFILLER_57_204 VGND VGND VPWR VPWR sky130_fd_sc_hd__fill_1
XFILLER_85_513 VGND VGND VPWR VPWR sky130_fd_sc_hd__decap_3
Xhold1203 _6045_/Q VGND VGND VPWR VPWR _5021_/B2 sky130_fd_sc_hd__dlygate4sd3_1
Xhold1214 _5617_/Q VGND VGND VPWR VPWR _4566_/B2 sky130_fd_sc_hd__dlygate4sd3_1
Xhold1225 _5586_/Q VGND VGND VPWR VPWR _4532_/B2 sky130_fd_sc_hd__dlygate4sd3_1
X_5105_ _6033_/CLK _5105_/D VGND VGND VPWR VPWR _5105_/Q sky130_fd_sc_hd__dfxtp_2
X_3297_ _3308_/A1 _3295_/X _3296_/X _3308_/B2 VGND VGND VPWR VPWR _3297_/X sky130_fd_sc_hd__o22a_2
Xhold1236 _5618_/Q VGND VGND VPWR VPWR _4567_/B2 sky130_fd_sc_hd__dlygate4sd3_1
Xhold1247 _5604_/Q VGND VGND VPWR VPWR _4553_/B2 sky130_fd_sc_hd__dlygate4sd3_1
Xhold1258 _5182_/Q VGND VGND VPWR VPWR _4101_/B2 sky130_fd_sc_hd__dlygate4sd3_1
X_5036_ _5036_/A1 wire334/X _5047_/B1 _5036_/B2 VGND VGND VPWR VPWR _6060_/D sky130_fd_sc_hd__a22o_2
XFILLER_38_473 VGND VGND VPWR VPWR sky130_fd_sc_hd__decap_3
XTAP_TAPCELL_ROW_56_917 VGND VPWR sky130_fd_sc_hd__tapvpwrvgnd_1
Xhold1269 _5204_/Q VGND VGND VPWR VPWR _4123_/B2 sky130_fd_sc_hd__dlygate4sd3_1
XFILLER_65_281 VGND VGND VPWR VPWR sky130_fd_sc_hd__fill_2
XTAP_TAPCELL_ROW_0_233 VGND VPWR sky130_fd_sc_hd__tapvpwrvgnd_1
XTAP_TAPCELL_ROW_0_244 VGND VPWR sky130_fd_sc_hd__tapvpwrvgnd_1
XTAP_TAPCELL_ROW_0_255 VGND VPWR sky130_fd_sc_hd__tapvpwrvgnd_1
XFILLER_15_46 VGND VGND VPWR VPWR sky130_fd_sc_hd__decap_3
XFILLER_15_57 VGND VGND VPWR VPWR sky130_fd_sc_hd__decap_3
XFILLER_41_638 VGND VGND VPWR VPWR sky130_fd_sc_hd__decap_3
XTAP_TAPCELL_ROW_36_685 VGND VPWR sky130_fd_sc_hd__tapvpwrvgnd_1
X_5938_ _5938_/CLK _5938_/D VGND VGND VPWR VPWR _5938_/Q sky130_fd_sc_hd__dfxtp_2
X_5869_ _5938_/CLK _5869_/D VGND VGND VPWR VPWR _5869_/Q sky130_fd_sc_hd__dfxtp_2
XFILLER_31_12 VGND VGND VPWR VPWR sky130_fd_sc_hd__fill_1
XTAP_TAPCELL_ROW_97_1418 VGND VPWR sky130_fd_sc_hd__tapvpwrvgnd_1
XFILLER_107_434 VGND VGND VPWR VPWR sky130_fd_sc_hd__decap_3
XFILLER_107_478 VGND VGND VPWR VPWR sky130_fd_sc_hd__decap_3
Xoutput67 _3096_/X VGND VGND VPWR VPWR rd1[25] sky130_fd_sc_hd__clkbuf_4
Xoutput56 _2871_/X VGND VGND VPWR VPWR rd1[15] sky130_fd_sc_hd__dlymetal6s4s_1
XTAP_TAPCELL_ROW_8_344 VGND VPWR sky130_fd_sc_hd__tapvpwrvgnd_1
Xoutput89 _3614_/X VGND VGND VPWR VPWR rd2[16] sky130_fd_sc_hd__dlymetal6s2s_1
Xoutput78 _2665_/X VGND VGND VPWR VPWR rd1[6] sky130_fd_sc_hd__clkbuf_2
XFILLER_103_673 VGND VGND VPWR VPWR sky130_fd_sc_hd__decap_3
XFILLER_88_362 VGND VGND VPWR VPWR sky130_fd_sc_hd__fill_2
XFILLER_88_373 VGND VGND VPWR VPWR sky130_fd_sc_hd__fill_1
XFILLER_102_194 VGND VGND VPWR VPWR sky130_fd_sc_hd__fill_2
Xhold1770 _6027_/Q VGND VGND VPWR VPWR _5001_/B2 sky130_fd_sc_hd__dlygate4sd3_1
XFILLER_17_646 VGND VGND VPWR VPWR sky130_fd_sc_hd__decap_3
XFILLER_44_432 VGND VGND VPWR VPWR sky130_fd_sc_hd__fill_2
XFILLER_56_97 VGND VGND VPWR VPWR sky130_fd_sc_hd__decap_3
XTAP_TAPCELL_ROW_106_1525 VGND VPWR sky130_fd_sc_hd__tapvpwrvgnd_1
Xhold1781 _5540_/Q VGND VGND VPWR VPWR _4484_/B2 sky130_fd_sc_hd__dlygate4sd3_1
Xhold1792 _5974_/Q VGND VGND VPWR VPWR _4944_/B2 sky130_fd_sc_hd__dlygate4sd3_1
XPHY_EDGE_ROW_113_Right_113 VGND VGND VPWR VPWR sky130_fd_sc_hd__decap_3
XFILLER_44_487 VGND VGND VPWR VPWR sky130_fd_sc_hd__decap_3
XFILLER_71_284 VGND VGND VPWR VPWR sky130_fd_sc_hd__fill_1
XFILLER_72_85 VGND VGND VPWR VPWR sky130_fd_sc_hd__decap_3
XFILLER_12_351 VGND VGND VPWR VPWR sky130_fd_sc_hd__decap_3
XFILLER_12_384 VGND VGND VPWR VPWR sky130_fd_sc_hd__decap_3
XFILLER_8_377 VGND VGND VPWR VPWR sky130_fd_sc_hd__decap_3
XFILLER_113_426 VGND VGND VPWR VPWR sky130_fd_sc_hd__decap_3
XFILLER_98_115 VGND VGND VPWR VPWR sky130_fd_sc_hd__decap_3
XFILLER_98_137 VGND VGND VPWR VPWR sky130_fd_sc_hd__decap_3
XFILLER_97_60 VGND VGND VPWR VPWR sky130_fd_sc_hd__decap_3
XFILLER_97_71 VGND VGND VPWR VPWR sky130_fd_sc_hd__fill_2
X_3220_ _5527_/Q _5495_/Q _3221_/S VGND VGND VPWR VPWR _3220_/X sky130_fd_sc_hd__mux2_1
XFILLER_67_502 VGND VGND VPWR VPWR sky130_fd_sc_hd__fill_2
XFILLER_67_513 VGND VGND VPWR VPWR sky130_fd_sc_hd__fill_2
X_3151_ wire651/X _3149_/X _3150_/X wire685/X VGND VGND VPWR VPWR _3151_/X sky130_fd_sc_hd__o22a_2
XFILLER_11_3 VGND VGND VPWR VPWR sky130_fd_sc_hd__decap_3
XFILLER_94_343 VGND VGND VPWR VPWR sky130_fd_sc_hd__decap_3
XFILLER_94_365 VGND VGND VPWR VPWR sky130_fd_sc_hd__decap_3
X_3082_ _5201_/Q _5169_/Q _3083_/S VGND VGND VPWR VPWR _3082_/X sky130_fd_sc_hd__mux2_1
XFILLER_47_281 VGND VGND VPWR VPWR sky130_fd_sc_hd__fill_1
XFILLER_35_465 VGND VGND VPWR VPWR sky130_fd_sc_hd__fill_2
XFILLER_62_251 VGND VGND VPWR VPWR sky130_fd_sc_hd__fill_1
XTAP_TAPCELL_ROW_81_1219 VGND VPWR sky130_fd_sc_hd__tapvpwrvgnd_1
XTAP_TAPCELL_ROW_33_644 VGND VPWR sky130_fd_sc_hd__tapvpwrvgnd_1
X_3984_ _3948_/B _3984_/B input3/X VGND VGND VPWR VPWR _4709_/C sky130_fd_sc_hd__nand3b_2
XFILLER_22_159 VGND VGND VPWR VPWR sky130_fd_sc_hd__decap_3
XTAP_TAPCELL_ROW_61_986 VGND VPWR sky130_fd_sc_hd__tapvpwrvgnd_1
X_5723_ _5938_/CLK _5723_/D VGND VGND VPWR VPWR _5723_/Q sky130_fd_sc_hd__dfxtp_2
X_2935_ _5834_/Q _5450_/Q _2975_/S VGND VGND VPWR VPWR _2935_/X sky130_fd_sc_hd__mux2_1
XFILLER_30_181 VGND VGND VPWR VPWR sky130_fd_sc_hd__decap_3
X_5654_ _5871_/CLK _5654_/D VGND VGND VPWR VPWR _5654_/Q sky130_fd_sc_hd__dfxtp_2
X_2866_ _5799_/Q _5735_/Q _3217_/S VGND VGND VPWR VPWR _2866_/X sky130_fd_sc_hd__mux2_1
X_4605_ _4776_/A1 _4605_/A2 _4605_/B1 _4605_/B2 VGND VGND VPWR VPWR _5654_/D sky130_fd_sc_hd__a22o_2
X_5585_ _5866_/CLK _5585_/D VGND VGND VPWR VPWR _5585_/Q sky130_fd_sc_hd__dfxtp_2
X_2797_ _3017_/C1 _2793_/X _2796_/X _2791_/X VGND VGND VPWR VPWR _2797_/X sky130_fd_sc_hd__a31o_2
X_4536_ _4776_/A1 wire431/X _4536_/B1 _4536_/B2 VGND VGND VPWR VPWR _5590_/D sky130_fd_sc_hd__a22o_2
XFILLER_104_437 VGND VGND VPWR VPWR sky130_fd_sc_hd__fill_1
X_4467_ _4535_/A1 _4467_/A2 _4467_/B1 _4467_/B2 VGND VGND VPWR VPWR _5525_/D sky130_fd_sc_hd__a22o_2
XTAP_TAPCELL_ROW_92_1359 VGND VPWR sky130_fd_sc_hd__tapvpwrvgnd_1
XTAP_TAPCELL_ROW_92_1348 VGND VPWR sky130_fd_sc_hd__tapvpwrvgnd_1
Xfanout813 _2736_/S0 VGND VGND VPWR VPWR _2998_/S sky130_fd_sc_hd__clkbuf_2
X_4398_ _4943_/A1 _4398_/A2 _4398_/B1 _4398_/B2 VGND VGND VPWR VPWR _5461_/D sky130_fd_sc_hd__a22o_2
X_3418_ _3412_/X _3414_/X _3416_/X _3406_/X VGND VGND VPWR VPWR _3418_/X sky130_fd_sc_hd__a31o_2
XFILLER_58_524 VGND VGND VPWR VPWR sky130_fd_sc_hd__fill_1
XTAP_TAPCELL_ROW_5_314 VGND VPWR sky130_fd_sc_hd__tapvpwrvgnd_1
Xfanout846 _3217_/S VGND VGND VPWR VPWR _2743_/S sky130_fd_sc_hd__clkbuf_2
Xfanout835 _3155_/S0 VGND VGND VPWR VPWR _3159_/S sky130_fd_sc_hd__dlymetal6s4s_1
X_3349_ _3626_/A _3345_/X _3348_/X _3632_/A _3898_/A1 VGND VGND VPWR VPWR _3349_/X
+ sky130_fd_sc_hd__o221a_2
XFILLER_100_643 VGND VGND VPWR VPWR sky130_fd_sc_hd__fill_1
XFILLER_85_343 VGND VGND VPWR VPWR sky130_fd_sc_hd__decap_3
Xfanout879 input45/X VGND VGND VPWR VPWR _4752_/A1 sky130_fd_sc_hd__clkdlybuf4s25_1
Xfanout868 input48/X VGND VGND VPWR VPWR _4755_/A1 sky130_fd_sc_hd__clkdlybuf4s25_1
XFILLER_100_687 VGND VGND VPWR VPWR sky130_fd_sc_hd__fill_1
XFILLER_93_18 VGND VGND VPWR VPWR sky130_fd_sc_hd__decap_3
X_6068_ _6068_/CLK _6068_/D VGND VGND VPWR VPWR _6068_/Q sky130_fd_sc_hd__dfxtp_2
XFILLER_26_12 VGND VGND VPWR VPWR sky130_fd_sc_hd__fill_2
X_5019_ _5019_/A1 _5043_/A2 wire115/A _5019_/B2 VGND VGND VPWR VPWR _6043_/D sky130_fd_sc_hd__a22o_2
XFILLER_13_104 VGND VGND VPWR VPWR sky130_fd_sc_hd__fill_1
XFILLER_41_413 VGND VGND VPWR VPWR sky130_fd_sc_hd__decap_3
XFILLER_53_273 VGND VGND VPWR VPWR sky130_fd_sc_hd__fill_1
XFILLER_13_137 VGND VGND VPWR VPWR sky130_fd_sc_hd__decap_3
XFILLER_53_295 VGND VGND VPWR VPWR sky130_fd_sc_hd__decap_3
XTAP_TAPCELL_ROW_101_1466 VGND VPWR sky130_fd_sc_hd__tapvpwrvgnd_1
XFILLER_21_181 VGND VGND VPWR VPWR sky130_fd_sc_hd__decap_3
XFILLER_22_682 VGND VGND VPWR VPWR sky130_fd_sc_hd__decap_3
XFILLER_42_55 VGND VGND VPWR VPWR sky130_fd_sc_hd__decap_3
XFILLER_1_531 VGND VGND VPWR VPWR sky130_fd_sc_hd__fill_1
XFILLER_3_27 VGND VGND VPWR VPWR sky130_fd_sc_hd__decap_3
XFILLER_107_81 VGND VGND VPWR VPWR sky130_fd_sc_hd__decap_3
XFILLER_1_575 VGND VGND VPWR VPWR sky130_fd_sc_hd__decap_3
XFILLER_67_30 VGND VGND VPWR VPWR sky130_fd_sc_hd__fill_1
XFILLER_89_682 VGND VGND VPWR VPWR sky130_fd_sc_hd__decap_3
XTAP_TAPCELL_ROW_112_1595 VGND VPWR sky130_fd_sc_hd__tapvpwrvgnd_1
XFILLER_76_365 VGND VGND VPWR VPWR sky130_fd_sc_hd__fill_1
XFILLER_29_281 VGND VGND VPWR VPWR sky130_fd_sc_hd__decap_3
Xload_slew1030 _3304_/S1 VGND VGND VPWR VPWR _3566_/S1 sky130_fd_sc_hd__buf_4
XFILLER_17_432 VGND VGND VPWR VPWR sky130_fd_sc_hd__decap_3
XFILLER_83_51 VGND VGND VPWR VPWR sky130_fd_sc_hd__decap_3
XTAP_TAPCELL_ROW_67_1052 VGND VPWR sky130_fd_sc_hd__tapvpwrvgnd_1
Xload_slew1063 _3277_/S VGND VGND VPWR VPWR _3847_/S sky130_fd_sc_hd__buf_4
XFILLER_17_498 VGND VGND VPWR VPWR sky130_fd_sc_hd__decap_3
XFILLER_32_457 VGND VGND VPWR VPWR sky130_fd_sc_hd__fill_1
XPHY_EDGE_ROW_17_Left_133 VGND VGND VPWR VPWR sky130_fd_sc_hd__decap_3
XFILLER_13_682 VGND VGND VPWR VPWR sky130_fd_sc_hd__decap_3
XTAP_TAPCELL_ROW_30_614 VGND VPWR sky130_fd_sc_hd__tapvpwrvgnd_1
X_2720_ _6049_/Q _5953_/Q _2924_/S VGND VGND VPWR VPWR _2720_/X sky130_fd_sc_hd__mux2_1
XFILLER_12_192 VGND VGND VPWR VPWR sky130_fd_sc_hd__decap_3
XFILLER_8_141 VGND VGND VPWR VPWR sky130_fd_sc_hd__decap_3
X_2651_ _5406_/Q _5054_/Q _3114_/S VGND VGND VPWR VPWR _2651_/X sky130_fd_sc_hd__mux2_1
XFILLER_99_402 VGND VGND VPWR VPWR sky130_fd_sc_hd__fill_1
XTAP_TAPCELL_ROW_10_371 VGND VPWR sky130_fd_sc_hd__tapvpwrvgnd_1
XTAP_TAPCELL_ROW_78_1181 VGND VPWR sky130_fd_sc_hd__tapvpwrvgnd_1
X_5370_ _5658_/CLK _5370_/D VGND VGND VPWR VPWR _5370_/Q sky130_fd_sc_hd__dfxtp_2
X_2582_ _5403_/Q _5051_/Q _2582_/S VGND VGND VPWR VPWR _2582_/X sky130_fd_sc_hd__mux2_1
X_4321_ _4527_/A1 _4329_/A2 _4321_/B1 _4321_/B2 VGND VGND VPWR VPWR _5389_/D sky130_fd_sc_hd__a22o_2
XFILLER_99_479 VGND VGND VPWR VPWR sky130_fd_sc_hd__decap_3
XPHY_EDGE_ROW_26_Left_142 VGND VGND VPWR VPWR sky130_fd_sc_hd__decap_3
X_4252_ _4526_/A1 _4263_/A2 _4263_/B1 _4252_/B2 VGND VGND VPWR VPWR _5324_/D sky130_fd_sc_hd__a22o_2
X_3203_ _6070_/Q _5974_/Q _3204_/S VGND VGND VPWR VPWR _3203_/X sky130_fd_sc_hd__mux2_1
X_4183_ _5002_/A1 wire500/X wire281/X _4183_/B2 VGND VGND VPWR VPWR _5260_/D sky130_fd_sc_hd__a22o_2
XTAP_TAPCELL_ROW_38_703 VGND VPWR sky130_fd_sc_hd__tapvpwrvgnd_1
X_3134_ _3134_/A1 _3132_/X _3133_/X wire676/A VGND VGND VPWR VPWR _3134_/X sky130_fd_sc_hd__o22a_2
XFILLER_94_195 VGND VGND VPWR VPWR sky130_fd_sc_hd__fill_1
X_3065_ _3195_/A1 _3063_/X _3064_/X _2499_/A VGND VGND VPWR VPWR _3065_/X sky130_fd_sc_hd__o22a_2
XFILLER_35_240 VGND VGND VPWR VPWR sky130_fd_sc_hd__decap_3
XPHY_EDGE_ROW_35_Left_151 VGND VGND VPWR VPWR sky130_fd_sc_hd__decap_3
XTAP_TAPCELL_ROW_18_460 VGND VPWR sky130_fd_sc_hd__tapvpwrvgnd_1
XFILLER_35_284 VGND VGND VPWR VPWR sky130_fd_sc_hd__decap_3
XTAP_TAPCELL_ROW_18_471 VGND VPWR sky130_fd_sc_hd__tapvpwrvgnd_1
X_3967_ _4658_/A1 wire546/A wire325/A _3967_/B2 VGND VGND VPWR VPWR _5063_/D sky130_fd_sc_hd__a22o_2
X_5706_ _5804_/CLK _5706_/D VGND VGND VPWR VPWR _5706_/Q sky130_fd_sc_hd__dfxtp_2
X_2918_ _5386_/Q _5354_/Q _5322_/Q _5290_/Q _2856_/S _2503_/B VGND VGND VPWR VPWR
+ _2918_/X sky130_fd_sc_hd__mux4_2
Xclkbuf_leaf_30_clk clkload5/A VGND VGND VPWR VPWR _6070_/CLK sky130_fd_sc_hd__clkbuf_8
X_3898_ _3898_/A1 _3889_/X _3892_/X _3882_/X _3248_/X VGND VGND VPWR VPWR _3898_/X
+ sky130_fd_sc_hd__a32o_2
X_5637_ _5925_/CLK _5637_/D VGND VGND VPWR VPWR _5637_/Q sky130_fd_sc_hd__dfxtp_2
X_2849_ _2832_/X _2842_/X _2848_/X _3119_/B1 VGND VGND VPWR VPWR _2849_/X sky130_fd_sc_hd__o31a_2
X_5568_ _6019_/CLK _5568_/D VGND VGND VPWR VPWR _5568_/Q sky130_fd_sc_hd__dfxtp_2
XFILLER_2_306 VGND VGND VPWR VPWR sky130_fd_sc_hd__fill_2
XFILLER_88_29 VGND VGND VPWR VPWR sky130_fd_sc_hd__decap_3
XPHY_EDGE_ROW_44_Left_160 VGND VGND VPWR VPWR sky130_fd_sc_hd__decap_3
X_4519_ _4519_/A1 _4537_/A2 _4530_/B1 _4519_/B2 VGND VGND VPWR VPWR _5573_/D sky130_fd_sc_hd__a22o_2
XFILLER_104_234 VGND VGND VPWR VPWR sky130_fd_sc_hd__fill_2
X_5499_ _5502_/CLK _5499_/D VGND VGND VPWR VPWR _5499_/Q sky130_fd_sc_hd__dfxtp_2
XFILLER_77_107 VGND VGND VPWR VPWR sky130_fd_sc_hd__decap_3
Xfanout632 _3232_/Y VGND VGND VPWR VPWR fanout632/X sky130_fd_sc_hd__clkdlybuf4s25_1
Xfanout621 _3233_/Y VGND VGND VPWR VPWR _3753_/A1 sky130_fd_sc_hd__clkdlybuf4s25_1
Xfanout610 _3914_/A VGND VGND VPWR VPWR _3547_/B2 sky130_fd_sc_hd__clkdlybuf4s25_1
XFILLER_86_630 VGND VGND VPWR VPWR sky130_fd_sc_hd__decap_3
Xfanout665 _2502_/X VGND VGND VPWR VPWR _3229_/A1 sky130_fd_sc_hd__clkdlybuf4s25_1
Xfanout654 _2936_/A1 VGND VGND VPWR VPWR _3222_/A1 sky130_fd_sc_hd__clkbuf_2
Xclkbuf_leaf_97_clk clkload0/A VGND VGND VPWR VPWR _6067_/CLK sky130_fd_sc_hd__clkbuf_8
XFILLER_58_365 VGND VGND VPWR VPWR sky130_fd_sc_hd__fill_2
XFILLER_100_473 VGND VGND VPWR VPWR sky130_fd_sc_hd__decap_3
XFILLER_37_44 VGND VGND VPWR VPWR sky130_fd_sc_hd__decap_3
XFILLER_14_413 VGND VGND VPWR VPWR sky130_fd_sc_hd__decap_3
XFILLER_54_582 VGND VGND VPWR VPWR sky130_fd_sc_hd__decap_3
XFILLER_73_379 VGND VGND VPWR VPWR sky130_fd_sc_hd__decap_3
XFILLER_41_221 VGND VGND VPWR VPWR sky130_fd_sc_hd__decap_3
XFILLER_6_612 VGND VGND VPWR VPWR sky130_fd_sc_hd__decap_3
Xclkbuf_leaf_21_clk clkbuf_4_8_0_clk/X VGND VGND VPWR VPWR _6040_/CLK sky130_fd_sc_hd__clkbuf_8
XFILLER_10_685 VGND VGND VPWR VPWR sky130_fd_sc_hd__decap_3
XFILLER_6_645 VGND VGND VPWR VPWR sky130_fd_sc_hd__fill_1
XFILLER_108_540 VGND VGND VPWR VPWR sky130_fd_sc_hd__decap_3
XFILLER_6_678 VGND VGND VPWR VPWR sky130_fd_sc_hd__decap_3
XTAP_TAPCELL_ROW_114_1613 VGND VPWR sky130_fd_sc_hd__tapvpwrvgnd_1
XFILLER_45_9 VGND VGND VPWR VPWR sky130_fd_sc_hd__fill_1
XFILLER_78_73 VGND VGND VPWR VPWR sky130_fd_sc_hd__decap_3
XFILLER_96_427 VGND VGND VPWR VPWR sky130_fd_sc_hd__decap_3
XFILLER_1_383 VGND VGND VPWR VPWR sky130_fd_sc_hd__fill_2
XFILLER_49_310 VGND VGND VPWR VPWR sky130_fd_sc_hd__decap_3
XFILLER_77_641 VGND VGND VPWR VPWR sky130_fd_sc_hd__decap_3
Xclkbuf_leaf_88_clk clkbuf_4_6_0_clk/X VGND VGND VPWR VPWR _5800_/CLK sky130_fd_sc_hd__clkbuf_8
XFILLER_76_151 VGND VGND VPWR VPWR sky130_fd_sc_hd__decap_3
XFILLER_49_387 VGND VGND VPWR VPWR sky130_fd_sc_hd__fill_1
XFILLER_94_61 VGND VGND VPWR VPWR sky130_fd_sc_hd__fill_1
XFILLER_45_571 VGND VGND VPWR VPWR sky130_fd_sc_hd__decap_3
XFILLER_52_519 VGND VGND VPWR VPWR sky130_fd_sc_hd__decap_3
XFILLER_91_165 VGND VGND VPWR VPWR sky130_fd_sc_hd__decap_3
XFILLER_72_390 VGND VGND VPWR VPWR sky130_fd_sc_hd__decap_3
X_4870_ _4904_/A1 _4870_/A2 _4874_/B1 _4870_/B2 VGND VGND VPWR VPWR _5904_/D sky130_fd_sc_hd__a22o_2
XTAP_TAPCELL_ROW_15_430 VGND VPWR sky130_fd_sc_hd__tapvpwrvgnd_1
XTAP_TAPCELL_ROW_43_761 VGND VPWR sky130_fd_sc_hd__tapvpwrvgnd_1
X_3821_ _5586_/Q _5554_/Q _3821_/S VGND VGND VPWR VPWR _3821_/X sky130_fd_sc_hd__mux2_1
Xclkbuf_leaf_12_clk clkload1/A VGND VGND VPWR VPWR _6056_/CLK sky130_fd_sc_hd__clkbuf_8
X_3752_ _3920_/A _3749_/X _3751_/X _3791_/B2 VGND VGND VPWR VPWR _3752_/X sky130_fd_sc_hd__a22o_2
X_3683_ _6060_/Q _5964_/Q _3683_/S VGND VGND VPWR VPWR _3683_/X sky130_fd_sc_hd__mux2_1
X_2703_ _5504_/Q _5472_/Q _2772_/S VGND VGND VPWR VPWR _2703_/X sky130_fd_sc_hd__mux2_1
X_5422_ _6062_/CLK _5422_/D VGND VGND VPWR VPWR _5422_/Q sky130_fd_sc_hd__dfxtp_2
X_2634_ _3105_/A1 _2632_/X _2633_/X _3105_/B2 VGND VGND VPWR VPWR _2634_/X sky130_fd_sc_hd__o22a_2
X_5353_ _5824_/CLK _5353_/D VGND VGND VPWR VPWR _5353_/Q sky130_fd_sc_hd__dfxtp_2
X_2565_ _2987_/A _2562_/X _2564_/X wire643/X VGND VGND VPWR VPWR _2565_/X sky130_fd_sc_hd__o22a_2
XFILLER_99_254 VGND VGND VPWR VPWR sky130_fd_sc_hd__fill_1
X_4304_ _4510_/A1 _4327_/A2 wire248/X _4304_/B2 VGND VGND VPWR VPWR _5372_/D sky130_fd_sc_hd__a22o_2
XFILLER_114_565 VGND VGND VPWR VPWR sky130_fd_sc_hd__decap_3
XFILLER_99_276 VGND VGND VPWR VPWR sky130_fd_sc_hd__decap_3
XFILLER_99_287 VGND VGND VPWR VPWR sky130_fd_sc_hd__decap_3
X_5284_ _5572_/CLK _5284_/D VGND VGND VPWR VPWR _5284_/Q sky130_fd_sc_hd__dfxtp_2
X_2496_ _2503_/B _2497_/B VGND VGND VPWR VPWR _2496_/Y sky130_fd_sc_hd__nor2_2
XFILLER_114_598 VGND VGND VPWR VPWR sky130_fd_sc_hd__decap_3
Xclkbuf_leaf_79_clk clkbuf_4_4_0_clk/X VGND VGND VPWR VPWR _5938_/CLK sky130_fd_sc_hd__clkbuf_8
X_4235_ _4749_/A1 wire482/X wire262/A _4235_/B2 VGND VGND VPWR VPWR _5307_/D sky130_fd_sc_hd__a22o_2
XFILLER_114_27 VGND VGND VPWR VPWR sky130_fd_sc_hd__fill_1
XFILLER_114_38 VGND VGND VPWR VPWR sky130_fd_sc_hd__decap_3
XFILLER_95_460 VGND VGND VPWR VPWR sky130_fd_sc_hd__fill_1
X_4166_ _4985_/A1 _4192_/A2 _4192_/B1 _4166_/B2 VGND VGND VPWR VPWR _5243_/D sky130_fd_sc_hd__a22o_2
XFILLER_28_516 VGND VGND VPWR VPWR sky130_fd_sc_hd__decap_3
X_3117_ _2830_/A _3114_/X _3116_/X VGND VGND VPWR VPWR _3117_/X sky130_fd_sc_hd__a21o_2
XFILLER_83_644 VGND VGND VPWR VPWR sky130_fd_sc_hd__fill_1
X_4097_ _4984_/A1 _4124_/A2 _4124_/B1 _4097_/B2 VGND VGND VPWR VPWR _5178_/D sky130_fd_sc_hd__a22o_2
X_3048_ wire651/X _3046_/X _3047_/X wire685/X VGND VGND VPWR VPWR _3048_/X sky130_fd_sc_hd__o22a_2
XFILLER_51_530 VGND VGND VPWR VPWR sky130_fd_sc_hd__decap_3
XFILLER_51_585 VGND VGND VPWR VPWR sky130_fd_sc_hd__decap_3
X_4999_ _4999_/A1 _5011_/A2 _5011_/B1 _4999_/B2 VGND VGND VPWR VPWR _6025_/D sky130_fd_sc_hd__a22o_2
XFILLER_23_57 VGND VGND VPWR VPWR sky130_fd_sc_hd__fill_2
XFILLER_109_337 VGND VGND VPWR VPWR sky130_fd_sc_hd__decap_3
XFILLER_109_348 VGND VGND VPWR VPWR sky130_fd_sc_hd__fill_1
XTAP_TAPCELL_ROW_21_499 VGND VPWR sky130_fd_sc_hd__tapvpwrvgnd_1
XFILLER_3_604 VGND VGND VPWR VPWR sky130_fd_sc_hd__decap_3
XFILLER_3_626 VGND VGND VPWR VPWR sky130_fd_sc_hd__decap_3
XFILLER_3_659 VGND VGND VPWR VPWR sky130_fd_sc_hd__decap_3
XFILLER_2_169 VGND VGND VPWR VPWR sky130_fd_sc_hd__fill_2
XFILLER_78_438 VGND VGND VPWR VPWR sky130_fd_sc_hd__fill_1
XFILLER_74_600 VGND VGND VPWR VPWR sky130_fd_sc_hd__decap_3
XFILLER_59_685 VGND VGND VPWR VPWR sky130_fd_sc_hd__decap_3
XFILLER_86_471 VGND VGND VPWR VPWR sky130_fd_sc_hd__decap_3
Xfanout495 fanout501/X VGND VGND VPWR VPWR _4179_/A2 sky130_fd_sc_hd__clkdlybuf4s25_1
XFILLER_100_281 VGND VGND VPWR VPWR sky130_fd_sc_hd__decap_3
XFILLER_58_195 VGND VGND VPWR VPWR sky130_fd_sc_hd__fill_1
XFILLER_34_519 VGND VGND VPWR VPWR sky130_fd_sc_hd__decap_3
XFILLER_64_53 VGND VGND VPWR VPWR sky130_fd_sc_hd__decap_3
XTAP_TAPCELL_ROW_29_599 VGND VPWR sky130_fd_sc_hd__tapvpwrvgnd_1
XTAP_TAPCELL_ROW_64_1022 VGND VPWR sky130_fd_sc_hd__tapvpwrvgnd_1
XFILLER_42_574 VGND VGND VPWR VPWR sky130_fd_sc_hd__decap_3
XFILLER_9_15 VGND VGND VPWR VPWR sky130_fd_sc_hd__decap_3
XFILLER_14_298 VGND VGND VPWR VPWR sky130_fd_sc_hd__decap_3
XFILLER_9_48 VGND VGND VPWR VPWR sky130_fd_sc_hd__decap_3
XTAP_TAPCELL_ROW_40_731 VGND VPWR sky130_fd_sc_hd__tapvpwrvgnd_1
XFILLER_80_85 VGND VGND VPWR VPWR sky130_fd_sc_hd__fill_1
XFILLER_10_493 VGND VGND VPWR VPWR sky130_fd_sc_hd__decap_3
XFILLER_6_475 VGND VGND VPWR VPWR sky130_fd_sc_hd__fill_1
XTAP_TAPCELL_ROW_75_1151 VGND VPWR sky130_fd_sc_hd__tapvpwrvgnd_1
Xload_slew824 _3060_/S VGND VGND VPWR VPWR _2942_/S sky130_fd_sc_hd__buf_2
Xload_slew802 _2578_/S VGND VGND VPWR VPWR _2564_/S sky130_fd_sc_hd__buf_4
XFILLER_2_681 VGND VGND VPWR VPWR sky130_fd_sc_hd__decap_3
XFILLER_96_213 VGND VGND VPWR VPWR sky130_fd_sc_hd__decap_3
Xload_slew857 _2724_/S0 VGND VGND VPWR VPWR _2971_/S sky130_fd_sc_hd__buf_4
Xclkbuf_leaf_1_clk clkbuf_4_0_0_clk/X VGND VGND VPWR VPWR _5692_/CLK sky130_fd_sc_hd__clkbuf_8
X_4020_ _5013_/A1 wire540/X _4020_/B1 _4020_/B2 VGND VGND VPWR VPWR _5111_/D sky130_fd_sc_hd__a22o_2
XTAP_TAPCELL_ROW_48_820 VGND VPWR sky130_fd_sc_hd__tapvpwrvgnd_1
XFILLER_37_346 VGND VGND VPWR VPWR sky130_fd_sc_hd__fill_2
XTAP_TAPCELL_ROW_48_831 VGND VPWR sky130_fd_sc_hd__tapvpwrvgnd_1
XFILLER_64_165 VGND VGND VPWR VPWR sky130_fd_sc_hd__fill_1
XFILLER_92_474 VGND VGND VPWR VPWR sky130_fd_sc_hd__fill_2
X_5971_ _6067_/CLK _5971_/D VGND VGND VPWR VPWR _5971_/Q sky130_fd_sc_hd__dfxtp_2
X_4922_ _5024_/A1 _4936_/A2 wire133/X _4922_/B2 VGND VGND VPWR VPWR _5952_/D sky130_fd_sc_hd__a22o_2
XTAP_TAPCELL_ROW_86_1280 VGND VPWR sky130_fd_sc_hd__tapvpwrvgnd_1
XFILLER_100_18 VGND VGND VPWR VPWR sky130_fd_sc_hd__fill_2
X_4853_ _5023_/A1 wire367/X _4861_/B1 _4853_/B2 VGND VGND VPWR VPWR _5887_/D sky130_fd_sc_hd__a22o_2
X_4784_ _4805_/A_N _4784_/B VGND VGND VPWR VPWR _5822_/D sky130_fd_sc_hd__and2b_2
X_3804_ _5937_/Q _5905_/Q _5873_/Q _5777_/Q _3802_/S _3805_/S1 VGND VGND VPWR VPWR
+ _3804_/X sky130_fd_sc_hd__mux4_2
XFILLER_20_268 VGND VGND VPWR VPWR sky130_fd_sc_hd__decap_3
X_3735_ _3784_/A _3732_/X _3734_/X _3781_/C1 VGND VGND VPWR VPWR _3735_/X sky130_fd_sc_hd__a211o_2
XFILLER_109_27 VGND VGND VPWR VPWR sky130_fd_sc_hd__decap_3
XFILLER_106_307 VGND VGND VPWR VPWR sky130_fd_sc_hd__fill_1
XFILLER_106_318 VGND VGND VPWR VPWR sky130_fd_sc_hd__decap_3
Xclkload50 _6058_/CLK VGND VGND VPWR VPWR clkload50/X sky130_fd_sc_hd__clkbuf_8
X_5405_ _5810_/CLK _5405_/D VGND VGND VPWR VPWR _5405_/Q sky130_fd_sc_hd__dfxtp_2
X_3666_ _3791_/A1 _3663_/X _3665_/X _3745_/B2 VGND VGND VPWR VPWR _3666_/X sky130_fd_sc_hd__a22o_2
X_3597_ _3595_/X _3596_/X _3597_/S VGND VGND VPWR VPWR _3597_/X sky130_fd_sc_hd__mux2_1
X_2617_ _2904_/A1 _2614_/X _2616_/X _2516_/B VGND VGND VPWR VPWR _2618_/B sky130_fd_sc_hd__o211a_2
X_5336_ _5400_/CLK _5336_/D VGND VGND VPWR VPWR _5336_/Q sky130_fd_sc_hd__dfxtp_2
X_2548_ _2544_/X _2547_/X _2700_/A VGND VGND VPWR VPWR _2548_/X sky130_fd_sc_hd__o21a_2
XFILLER_102_524 VGND VGND VPWR VPWR sky130_fd_sc_hd__decap_3
XFILLER_114_373 VGND VGND VPWR VPWR sky130_fd_sc_hd__decap_3
X_5267_ _6069_/CLK _5267_/D VGND VGND VPWR VPWR _5267_/Q sky130_fd_sc_hd__dfxtp_2
X_4218_ _4526_/A1 _4229_/A2 _4229_/B1 _4218_/B2 VGND VGND VPWR VPWR _5292_/D sky130_fd_sc_hd__a22o_2
X_5198_ _6030_/CLK _5198_/D VGND VGND VPWR VPWR _5198_/Q sky130_fd_sc_hd__dfxtp_2
XFILLER_83_430 VGND VGND VPWR VPWR sky130_fd_sc_hd__decap_3
X_4149_ _5002_/A1 wire508/X wire290/X _4149_/B2 VGND VGND VPWR VPWR _5228_/D sky130_fd_sc_hd__a22o_2
XFILLER_55_154 VGND VGND VPWR VPWR sky130_fd_sc_hd__fill_2
XFILLER_55_165 VGND VGND VPWR VPWR sky130_fd_sc_hd__decap_3
XFILLER_71_625 VGND VGND VPWR VPWR sky130_fd_sc_hd__fill_1
XFILLER_83_474 VGND VGND VPWR VPWR sky130_fd_sc_hd__decap_3
XFILLER_24_541 VGND VGND VPWR VPWR sky130_fd_sc_hd__decap_3
XFILLER_34_23 VGND VGND VPWR VPWR sky130_fd_sc_hd__decap_3
XFILLER_34_45 VGND VGND VPWR VPWR sky130_fd_sc_hd__decap_3
XTAP_TAPCELL_ROW_26_558 VGND VPWR sky130_fd_sc_hd__tapvpwrvgnd_1
XFILLER_34_56 VGND VGND VPWR VPWR sky130_fd_sc_hd__decap_3
XFILLER_7_239 VGND VGND VPWR VPWR sky130_fd_sc_hd__decap_3
Xwire115 wire115/A VGND VGND VPWR VPWR wire115/X sky130_fd_sc_hd__buf_4
Xclkload0 clkload0/A VGND VGND VPWR VPWR clkload0/X sky130_fd_sc_hd__clkbuf_8
XFILLER_50_55 VGND VGND VPWR VPWR sky130_fd_sc_hd__decap_3
XFILLER_50_88 VGND VGND VPWR VPWR sky130_fd_sc_hd__fill_2
XFILLER_105_362 VGND VGND VPWR VPWR sky130_fd_sc_hd__decap_3
XFILLER_78_224 VGND VGND VPWR VPWR sky130_fd_sc_hd__fill_2
XFILLER_115_81 VGND VGND VPWR VPWR sky130_fd_sc_hd__decap_3
XTAP_TAPCELL_ROW_70_1092 VGND VPWR sky130_fd_sc_hd__tapvpwrvgnd_1
Xfanout270 _4229_/B1 VGND VGND VPWR VPWR _4219_/B1 sky130_fd_sc_hd__clkdlybuf4s25_1
XFILLER_19_346 VGND VGND VPWR VPWR sky130_fd_sc_hd__decap_3
XFILLER_46_176 VGND VGND VPWR VPWR sky130_fd_sc_hd__decap_3
XFILLER_74_474 VGND VGND VPWR VPWR sky130_fd_sc_hd__fill_2
XTAP_TAPCELL_ROW_109_1556 VGND VPWR sky130_fd_sc_hd__tapvpwrvgnd_1
XFILLER_61_113 VGND VGND VPWR VPWR sky130_fd_sc_hd__fill_2
XFILLER_61_146 VGND VGND VPWR VPWR sky130_fd_sc_hd__decap_3
XFILLER_91_40 VGND VGND VPWR VPWR sky130_fd_sc_hd__decap_3
XFILLER_15_574 VGND VGND VPWR VPWR sky130_fd_sc_hd__decap_3
XFILLER_15_585 VGND VGND VPWR VPWR sky130_fd_sc_hd__decap_3
XFILLER_30_533 VGND VGND VPWR VPWR sky130_fd_sc_hd__decap_3
X_3520_ _3920_/A _3520_/B VGND VGND VPWR VPWR _3520_/X sky130_fd_sc_hd__or2_2
XFILLER_6_250 VGND VGND VPWR VPWR sky130_fd_sc_hd__fill_2
Xwire693 wire693/A VGND VGND VPWR VPWR wire693/X sky130_fd_sc_hd__buf_4
X_3451_ _3414_/A _3450_/X _3922_/B1 VGND VGND VPWR VPWR _3451_/X sky130_fd_sc_hd__o21a_2
XFILLER_41_3 VGND VGND VPWR VPWR sky130_fd_sc_hd__decap_3
XFILLER_97_500 VGND VGND VPWR VPWR sky130_fd_sc_hd__decap_3
X_3382_ _3385_/A _3379_/X _3381_/X _3612_/C1 VGND VGND VPWR VPWR _3382_/X sky130_fd_sc_hd__a211o_2
XFILLER_97_544 VGND VGND VPWR VPWR sky130_fd_sc_hd__decap_3
Xhold2108 _5382_/Q VGND VGND VPWR VPWR _4314_/B2 sky130_fd_sc_hd__dlygate4sd3_1
X_5121_ _6026_/CLK _5121_/D VGND VGND VPWR VPWR _5121_/Q sky130_fd_sc_hd__dfxtp_2
Xhold1407 _5697_/Q VGND VGND VPWR VPWR _4652_/B2 sky130_fd_sc_hd__dlygate4sd3_1
Xhold2119 _5840_/Q VGND VGND VPWR VPWR _4802_/B sky130_fd_sc_hd__dlygate4sd3_1
Xhold1418 _5708_/Q VGND VGND VPWR VPWR _4663_/B2 sky130_fd_sc_hd__dlygate4sd3_1
Xhold1429 _5526_/Q VGND VGND VPWR VPWR _4468_/B2 sky130_fd_sc_hd__dlygate4sd3_1
Xload_slew698 _3191_/A1 VGND VGND VPWR VPWR _3147_/A1 sky130_fd_sc_hd__buf_2
Xload_slew687 _3094_/B2 VGND VGND VPWR VPWR _2972_/A1 sky130_fd_sc_hd__buf_4
X_5052_ clkload8/A _5052_/D VGND VGND VPWR VPWR _5052_/Q sky130_fd_sc_hd__dfxtp_2
X_4003_ _4894_/A1 _4015_/A2 _4015_/B1 _4003_/B2 VGND VGND VPWR VPWR _5094_/D sky130_fd_sc_hd__a22o_2
XFILLER_1_60 VGND VGND VPWR VPWR sky130_fd_sc_hd__decap_3
XFILLER_38_666 VGND VGND VPWR VPWR sky130_fd_sc_hd__fill_2
XFILLER_25_349 VGND VGND VPWR VPWR sky130_fd_sc_hd__decap_3
XFILLER_52_113 VGND VGND VPWR VPWR sky130_fd_sc_hd__fill_2
XPHY_EDGE_ROW_9_Left_125 VGND VGND VPWR VPWR sky130_fd_sc_hd__decap_3
XFILLER_111_39 VGND VGND VPWR VPWR sky130_fd_sc_hd__decap_3
XFILLER_18_390 VGND VGND VPWR VPWR sky130_fd_sc_hd__decap_3
X_5954_ _6050_/CLK _5954_/D VGND VGND VPWR VPWR _5954_/Q sky130_fd_sc_hd__dfxtp_2
XTAP_TAPCELL_ROW_23_528 VGND VPWR sky130_fd_sc_hd__tapvpwrvgnd_1
X_5885_ _5885_/CLK _5885_/D VGND VGND VPWR VPWR _5885_/Q sky130_fd_sc_hd__dfxtp_2
X_4905_ _5041_/A1 wire360/X wire144/X _4905_/B2 VGND VGND VPWR VPWR _5937_/D sky130_fd_sc_hd__a22o_2
XFILLER_33_393 VGND VGND VPWR VPWR sky130_fd_sc_hd__decap_3
XTAP_TAPCELL_ROW_51_859 VGND VPWR sky130_fd_sc_hd__tapvpwrvgnd_1
X_4836_ _4904_/A1 _4811_/B wire156/X _4836_/B2 VGND VGND VPWR VPWR _5872_/D sky130_fd_sc_hd__a22o_2
X_4767_ _4767_/A1 _4772_/A2 _4772_/B1 _4767_/B2 VGND VGND VPWR VPWR _5805_/D sky130_fd_sc_hd__a22o_2
X_4698_ _4767_/A1 _4703_/A2 _4703_/B1 _4698_/B2 VGND VGND VPWR VPWR _5741_/D sky130_fd_sc_hd__a22o_2
X_3718_ _3718_/A _3718_/B VGND VGND VPWR VPWR _3718_/X sky130_fd_sc_hd__or2_2
XFILLER_20_58 VGND VGND VPWR VPWR sky130_fd_sc_hd__fill_1
X_3649_ _3687_/A _3649_/B VGND VGND VPWR VPWR _3649_/X sky130_fd_sc_hd__or2_2
XFILLER_0_404 VGND VGND VPWR VPWR sky130_fd_sc_hd__decap_3
XFILLER_106_159 VGND VGND VPWR VPWR sky130_fd_sc_hd__decap_3
XFILLER_115_660 VGND VGND VPWR VPWR sky130_fd_sc_hd__decap_3
XFILLER_0_415 VGND VGND VPWR VPWR sky130_fd_sc_hd__decap_3
XFILLER_114_170 VGND VGND VPWR VPWR sky130_fd_sc_hd__decap_3
XFILLER_115_682 VGND VGND VPWR VPWR sky130_fd_sc_hd__decap_3
XFILLER_88_544 VGND VGND VPWR VPWR sky130_fd_sc_hd__decap_3
XFILLER_96_29 VGND VGND VPWR VPWR sky130_fd_sc_hd__fill_1
X_5319_ _5832_/CLK _5319_/D VGND VGND VPWR VPWR _5319_/Q sky130_fd_sc_hd__dfxtp_2
XFILLER_102_354 VGND VGND VPWR VPWR sky130_fd_sc_hd__decap_3
XFILLER_102_365 VGND VGND VPWR VPWR sky130_fd_sc_hd__decap_3
XTAP_TAPCELL_ROW_59_959 VGND VPWR sky130_fd_sc_hd__tapvpwrvgnd_1
Xhold1930 _5389_/Q VGND VGND VPWR VPWR _4321_/B2 sky130_fd_sc_hd__dlygate4sd3_1
Xhold1941 _5337_/Q VGND VGND VPWR VPWR _4267_/B2 sky130_fd_sc_hd__dlygate4sd3_1
Xhold1952 _5695_/Q VGND VGND VPWR VPWR _4650_/B2 sky130_fd_sc_hd__dlygate4sd3_1
Xhold1963 _5222_/Q VGND VGND VPWR VPWR _4143_/B2 sky130_fd_sc_hd__dlygate4sd3_1
XFILLER_16_305 VGND VGND VPWR VPWR sky130_fd_sc_hd__decap_3
XFILLER_29_666 VGND VGND VPWR VPWR sky130_fd_sc_hd__decap_3
XFILLER_90_219 VGND VGND VPWR VPWR sky130_fd_sc_hd__decap_3
XTAP_TAPCELL_ROW_3_286 VGND VPWR sky130_fd_sc_hd__tapvpwrvgnd_1
Xhold1974 _5474_/Q VGND VGND VPWR VPWR _4414_/B2 sky130_fd_sc_hd__dlygate4sd3_1
Xhold1985 _6056_/Q VGND VGND VPWR VPWR _5032_/B2 sky130_fd_sc_hd__dlygate4sd3_1
Xhold1996 _5522_/Q VGND VGND VPWR VPWR _4464_/B2 sky130_fd_sc_hd__dlygate4sd3_1
XFILLER_43_113 VGND VGND VPWR VPWR sky130_fd_sc_hd__decap_3
XFILLER_31_308 VGND VGND VPWR VPWR sky130_fd_sc_hd__fill_1
XFILLER_71_488 VGND VGND VPWR VPWR sky130_fd_sc_hd__fill_1
XFILLER_12_533 VGND VGND VPWR VPWR sky130_fd_sc_hd__fill_2
XTAP_TAPCELL_ROW_104_1497 VGND VPWR sky130_fd_sc_hd__tapvpwrvgnd_1
XFILLER_8_559 VGND VGND VPWR VPWR sky130_fd_sc_hd__decap_3
XANTENNA_9 _4745_/Y VGND VGND VPWR VPWR sky130_fd_sc_hd__diode_2
XFILLER_6_27 VGND VGND VPWR VPWR sky130_fd_sc_hd__fill_1
XFILLER_6_38 VGND VGND VPWR VPWR sky130_fd_sc_hd__decap_3
XFILLER_106_660 VGND VGND VPWR VPWR sky130_fd_sc_hd__decap_3
XFILLER_113_608 VGND VGND VPWR VPWR sky130_fd_sc_hd__decap_3
XTAP_TAPCELL_ROW_72_1110 VGND VPWR sky130_fd_sc_hd__tapvpwrvgnd_1
XFILLER_79_544 VGND VGND VPWR VPWR sky130_fd_sc_hd__fill_1
Xfanout1021 _3878_/S1 VGND VGND VPWR VPWR _3629_/S1 sky130_fd_sc_hd__clkdlybuf4s25_1
XFILLER_39_419 VGND VGND VPWR VPWR sky130_fd_sc_hd__decap_3
XFILLER_79_588 VGND VGND VPWR VPWR sky130_fd_sc_hd__decap_3
XFILLER_94_503 VGND VGND VPWR VPWR sky130_fd_sc_hd__decap_3
Xfanout1065 _3743_/S VGND VGND VPWR VPWR _3501_/S sky130_fd_sc_hd__clkbuf_2
Xfanout1054 input12/X VGND VGND VPWR VPWR _3919_/S1 sky130_fd_sc_hd__buf_6
XFILLER_94_547 VGND VGND VPWR VPWR sky130_fd_sc_hd__decap_3
Xfanout1076 _3326_/S VGND VGND VPWR VPWR _3325_/S sky130_fd_sc_hd__clkbuf_2
XFILLER_34_113 VGND VGND VPWR VPWR sky130_fd_sc_hd__fill_1
XFILLER_35_647 VGND VGND VPWR VPWR sky130_fd_sc_hd__fill_1
XFILLER_22_319 VGND VGND VPWR VPWR sky130_fd_sc_hd__fill_1
XFILLER_34_179 VGND VGND VPWR VPWR sky130_fd_sc_hd__fill_1
XFILLER_50_639 VGND VGND VPWR VPWR sky130_fd_sc_hd__decap_3
X_2951_ _5803_/Q _5739_/Q _3060_/S VGND VGND VPWR VPWR _2951_/X sky130_fd_sc_hd__mux2_1
XTAP_TAPCELL_ROW_83_1250 VGND VPWR sky130_fd_sc_hd__tapvpwrvgnd_1
X_5670_ _5790_/CLK _5670_/D VGND VGND VPWR VPWR _5670_/Q sky130_fd_sc_hd__dfxtp_2
XFILLER_89_3 VGND VGND VPWR VPWR sky130_fd_sc_hd__decap_3
X_4621_ _4926_/A1 wire407/A wire186/X _4621_/B2 VGND VGND VPWR VPWR _5668_/D sky130_fd_sc_hd__a22o_2
X_2882_ _5928_/Q _5896_/Q _5864_/Q _5768_/Q _2885_/S wire772/X VGND VGND VPWR VPWR
+ _2883_/B sky130_fd_sc_hd__mux4_2
X_4552_ _4891_/A1 wire421/X _4563_/B1 _4552_/B2 VGND VGND VPWR VPWR _5603_/D sky130_fd_sc_hd__a22o_2
XFILLER_7_570 VGND VGND VPWR VPWR sky130_fd_sc_hd__fill_2
X_4483_ _4517_/A1 _4501_/A2 _4494_/B1 _4483_/B2 VGND VGND VPWR VPWR _5539_/D sky130_fd_sc_hd__a22o_2
X_3503_ _3496_/A _3499_/X _3502_/X _3341_/A VGND VGND VPWR VPWR _3503_/X sky130_fd_sc_hd__o211a_2
X_3434_ _3496_/A _3431_/X _3433_/X wire628/A VGND VGND VPWR VPWR _3434_/X sky130_fd_sc_hd__o211a_2
XFILLER_112_663 VGND VGND VPWR VPWR sky130_fd_sc_hd__decap_3
Xload_slew440 _4465_/A2 VGND VGND VPWR VPWR _4460_/A2 sky130_fd_sc_hd__buf_2
X_3365_ _3831_/A1 _3362_/X _3364_/X _3612_/C1 VGND VGND VPWR VPWR _3371_/A sky130_fd_sc_hd__o211a_2
XFILLER_85_503 VGND VGND VPWR VPWR sky130_fd_sc_hd__fill_1
XFILLER_85_525 VGND VGND VPWR VPWR sky130_fd_sc_hd__decap_3
Xhold1204 _5280_/Q VGND VGND VPWR VPWR _4206_/B2 sky130_fd_sc_hd__dlygate4sd3_1
Xhold1215 _5406_/Q VGND VGND VPWR VPWR _4340_/B2 sky130_fd_sc_hd__dlygate4sd3_1
Xload_slew451 _4403_/B VGND VGND VPWR VPWR _4434_/A2 sky130_fd_sc_hd__buf_4
X_5104_ _6000_/CLK _5104_/D VGND VGND VPWR VPWR _5104_/Q sky130_fd_sc_hd__dfxtp_2
X_3296_ _5818_/Q _5434_/Q _3325_/S VGND VGND VPWR VPWR _3296_/X sky130_fd_sc_hd__mux2_1
XFILLER_85_569 VGND VGND VPWR VPWR sky130_fd_sc_hd__decap_3
Xhold1226 _5306_/Q VGND VGND VPWR VPWR _4234_/B2 sky130_fd_sc_hd__dlygate4sd3_1
Xhold1237 _5986_/Q VGND VGND VPWR VPWR _4958_/B2 sky130_fd_sc_hd__dlygate4sd3_1
Xhold1248 _5798_/Q VGND VGND VPWR VPWR _4760_/B2 sky130_fd_sc_hd__dlygate4sd3_1
Xload_slew484 _4261_/A2 VGND VGND VPWR VPWR _4258_/A2 sky130_fd_sc_hd__buf_2
X_5035_ _5035_/A1 _5015_/B wire118/X _5035_/B2 VGND VGND VPWR VPWR _6059_/D sky130_fd_sc_hd__a22o_2
XFILLER_72_219 VGND VGND VPWR VPWR sky130_fd_sc_hd__fill_1
XTAP_TAPCELL_ROW_56_918 VGND VPWR sky130_fd_sc_hd__tapvpwrvgnd_1
Xhold1259 _5118_/Q VGND VGND VPWR VPWR _4030_/B2 sky130_fd_sc_hd__dlygate4sd3_1
XFILLER_25_102 VGND VGND VPWR VPWR sky130_fd_sc_hd__decap_3
XFILLER_25_113 VGND VGND VPWR VPWR sky130_fd_sc_hd__decap_3
XFILLER_93_580 VGND VGND VPWR VPWR sky130_fd_sc_hd__decap_3
XTAP_TAPCELL_ROW_0_234 VGND VPWR sky130_fd_sc_hd__tapvpwrvgnd_1
XTAP_TAPCELL_ROW_0_245 VGND VPWR sky130_fd_sc_hd__tapvpwrvgnd_1
XFILLER_41_617 VGND VGND VPWR VPWR sky130_fd_sc_hd__decap_3
XTAP_TAPCELL_ROW_36_686 VGND VPWR sky130_fd_sc_hd__tapvpwrvgnd_1
X_5937_ _6065_/CLK _5937_/D VGND VGND VPWR VPWR _5937_/Q sky130_fd_sc_hd__dfxtp_2
X_5868_ _5932_/CLK _5868_/D VGND VGND VPWR VPWR _5868_/Q sky130_fd_sc_hd__dfxtp_2
X_5799_ _5799_/CLK _5799_/D VGND VGND VPWR VPWR _5799_/Q sky130_fd_sc_hd__dfxtp_2
X_4819_ _5023_/A1 wire374/X wire156/A _4819_/B2 VGND VGND VPWR VPWR _5855_/D sky130_fd_sc_hd__a22o_2
XTAP_TAPCELL_ROW_97_1419 VGND VPWR sky130_fd_sc_hd__tapvpwrvgnd_1
XTAP_TAPCELL_ROW_97_1408 VGND VPWR sky130_fd_sc_hd__tapvpwrvgnd_1
XFILLER_31_57 VGND VGND VPWR VPWR sky130_fd_sc_hd__fill_2
XFILLER_110_6 VGND VGND VPWR VPWR sky130_fd_sc_hd__decap_3
Xoutput57 _2894_/X VGND VGND VPWR VPWR rd1[16] sky130_fd_sc_hd__dlymetal6s2s_1
XTAP_TAPCELL_ROW_8_345 VGND VPWR sky130_fd_sc_hd__tapvpwrvgnd_1
Xoutput79 _2688_/X VGND VGND VPWR VPWR rd1[7] sky130_fd_sc_hd__clkbuf_2
Xoutput68 _3119_/X VGND VGND VPWR VPWR rd1[26] sky130_fd_sc_hd__dlymetal6s2s_1
XFILLER_103_685 VGND VGND VPWR VPWR sky130_fd_sc_hd__decap_3
XFILLER_102_184 VGND VGND VPWR VPWR sky130_fd_sc_hd__fill_2
Xhold1760 _5534_/Q VGND VGND VPWR VPWR _4478_/B2 sky130_fd_sc_hd__dlygate4sd3_1
Xhold1771 _5711_/Q VGND VGND VPWR VPWR _4666_/B2 sky130_fd_sc_hd__dlygate4sd3_1
XFILLER_16_113 VGND VGND VPWR VPWR sky130_fd_sc_hd__fill_1
XTAP_TAPCELL_ROW_106_1526 VGND VPWR sky130_fd_sc_hd__tapvpwrvgnd_1
Xhold1782 _5728_/Q VGND VGND VPWR VPWR _4685_/B2 sky130_fd_sc_hd__dlygate4sd3_1
Xhold1793 _5661_/Q VGND VGND VPWR VPWR _4614_/B2 sky130_fd_sc_hd__dlygate4sd3_1
XPHY_EDGE_ROW_19_Right_19 VGND VGND VPWR VPWR sky130_fd_sc_hd__decap_3
XFILLER_112_71 VGND VGND VPWR VPWR sky130_fd_sc_hd__decap_3
XFILLER_16_168 VGND VGND VPWR VPWR sky130_fd_sc_hd__decap_3
XFILLER_44_477 VGND VGND VPWR VPWR sky130_fd_sc_hd__fill_2
XFILLER_72_53 VGND VGND VPWR VPWR sky130_fd_sc_hd__fill_2
XFILLER_12_330 VGND VGND VPWR VPWR sky130_fd_sc_hd__decap_3
XFILLER_31_138 VGND VGND VPWR VPWR sky130_fd_sc_hd__decap_3
XFILLER_8_323 VGND VGND VPWR VPWR sky130_fd_sc_hd__decap_3
XFILLER_99_628 VGND VGND VPWR VPWR sky130_fd_sc_hd__decap_3
XPHY_EDGE_ROW_28_Right_28 VGND VGND VPWR VPWR sky130_fd_sc_hd__decap_3
X_3150_ _5428_/Q _5076_/Q _3150_/S VGND VGND VPWR VPWR _3150_/X sky130_fd_sc_hd__mux2_1
XFILLER_67_558 VGND VGND VPWR VPWR sky130_fd_sc_hd__fill_2
X_3081_ _3081_/A _3081_/B VGND VGND VPWR VPWR _3081_/X sky130_fd_sc_hd__or2_2
XPHY_EDGE_ROW_37_Right_37 VGND VGND VPWR VPWR sky130_fd_sc_hd__decap_3
XFILLER_62_230 VGND VGND VPWR VPWR sky130_fd_sc_hd__fill_2
XFILLER_23_617 VGND VGND VPWR VPWR sky130_fd_sc_hd__decap_3
XFILLER_90_583 VGND VGND VPWR VPWR sky130_fd_sc_hd__decap_3
XPHY_EDGE_ROW_99_Left_215 VGND VGND VPWR VPWR sky130_fd_sc_hd__decap_3
XTAP_TAPCELL_ROW_33_645 VGND VPWR sky130_fd_sc_hd__tapvpwrvgnd_1
X_5722_ _6010_/CLK _5722_/D VGND VGND VPWR VPWR _5722_/Q sky130_fd_sc_hd__dfxtp_2
X_3983_ _4777_/A1 wire548/X wire327/X _3983_/B2 VGND VGND VPWR VPWR _5079_/D sky130_fd_sc_hd__a22o_2
XFILLER_15_190 VGND VGND VPWR VPWR sky130_fd_sc_hd__fill_2
XTAP_TAPCELL_ROW_61_976 VGND VPWR sky130_fd_sc_hd__tapvpwrvgnd_1
XTAP_TAPCELL_ROW_61_987 VGND VPWR sky130_fd_sc_hd__tapvpwrvgnd_1
X_2934_ _6058_/Q _5962_/Q _2975_/S VGND VGND VPWR VPWR _2934_/X sky130_fd_sc_hd__mux2_1
X_5653_ _5813_/CLK _5653_/D VGND VGND VPWR VPWR _5653_/Q sky130_fd_sc_hd__dfxtp_2
X_2865_ _5703_/Q _5671_/Q _5639_/Q _5607_/Q _2743_/S _3214_/S1 VGND VGND VPWR VPWR
+ _2865_/X sky130_fd_sc_hd__mux4_2
XPHY_EDGE_ROW_46_Right_46 VGND VGND VPWR VPWR sky130_fd_sc_hd__decap_3
X_5584_ _6027_/CLK _5584_/D VGND VGND VPWR VPWR _5584_/Q sky130_fd_sc_hd__dfxtp_2
X_4604_ _4775_/A1 wire414/X wire193/A _4604_/B2 VGND VGND VPWR VPWR _5653_/D sky130_fd_sc_hd__a22o_2
X_4535_ _4535_/A1 _4535_/A2 _4535_/B1 _4535_/B2 VGND VGND VPWR VPWR _5589_/D sky130_fd_sc_hd__a22o_2
X_2796_ wire685/X _2794_/X _2795_/X wire651/X VGND VGND VPWR VPWR _2796_/X sky130_fd_sc_hd__o22a_2
X_4466_ _4534_/A1 _4468_/A2 _4468_/B1 _4466_/B2 VGND VGND VPWR VPWR _5524_/D sky130_fd_sc_hd__a22o_2
XTAP_TAPCELL_ROW_92_1349 VGND VPWR sky130_fd_sc_hd__tapvpwrvgnd_1
XTAP_TAPCELL_ROW_5_304 VGND VPWR sky130_fd_sc_hd__tapvpwrvgnd_1
Xfanout803 _2593_/S VGND VGND VPWR VPWR _2589_/S sky130_fd_sc_hd__clkbuf_4
X_4397_ _5044_/A1 _4399_/A2 wire238/X _4397_/B2 VGND VGND VPWR VPWR _5460_/D sky130_fd_sc_hd__a22o_2
X_3417_ wire630/A _3408_/X _3410_/X _3922_/B1 _3400_/X VGND VGND VPWR VPWR _3417_/X
+ sky130_fd_sc_hd__a32o_2
XTAP_TAPCELL_ROW_5_315 VGND VPWR sky130_fd_sc_hd__tapvpwrvgnd_1
Xfanout858 _2925_/S VGND VGND VPWR VPWR _2678_/S sky130_fd_sc_hd__clkdlybuf4s25_1
X_3348_ _5180_/Q _5148_/Q _3622_/S VGND VGND VPWR VPWR _3348_/X sky130_fd_sc_hd__mux2_1
XFILLER_58_547 VGND VGND VPWR VPWR sky130_fd_sc_hd__fill_2
Xfanout869 _4754_/A1 VGND VGND VPWR VPWR _5024_/A1 sky130_fd_sc_hd__clkdlybuf4s25_1
XFILLER_58_569 VGND VGND VPWR VPWR sky130_fd_sc_hd__decap_3
XPHY_EDGE_ROW_55_Right_55 VGND VGND VPWR VPWR sky130_fd_sc_hd__decap_3
X_6067_ _6067_/CLK _6067_/D VGND VGND VPWR VPWR _6067_/Q sky130_fd_sc_hd__dfxtp_2
X_3279_ _3626_/A _3275_/X _3278_/X _3898_/A1 VGND VGND VPWR VPWR _3279_/X sky130_fd_sc_hd__o211a_2
XFILLER_26_411 VGND VGND VPWR VPWR sky130_fd_sc_hd__fill_1
X_5018_ _5018_/A1 _5043_/A2 wire115/A _5018_/B2 VGND VGND VPWR VPWR _6042_/D sky130_fd_sc_hd__a22o_2
XFILLER_14_628 VGND VGND VPWR VPWR sky130_fd_sc_hd__decap_3
XFILLER_26_477 VGND VGND VPWR VPWR sky130_fd_sc_hd__fill_1
XFILLER_26_499 VGND VGND VPWR VPWR sky130_fd_sc_hd__fill_2
XFILLER_53_252 VGND VGND VPWR VPWR sky130_fd_sc_hd__decap_3
XFILLER_13_116 VGND VGND VPWR VPWR sky130_fd_sc_hd__fill_1
XFILLER_13_149 VGND VGND VPWR VPWR sky130_fd_sc_hd__fill_2
XFILLER_41_458 VGND VGND VPWR VPWR sky130_fd_sc_hd__fill_2
XTAP_TAPCELL_ROW_101_1456 VGND VPWR sky130_fd_sc_hd__tapvpwrvgnd_1
XPHY_EDGE_ROW_64_Right_64 VGND VGND VPWR VPWR sky130_fd_sc_hd__decap_3
XTAP_TAPCELL_ROW_101_1467 VGND VPWR sky130_fd_sc_hd__tapvpwrvgnd_1
XFILLER_5_337 VGND VGND VPWR VPWR sky130_fd_sc_hd__decap_3
XFILLER_5_348 VGND VGND VPWR VPWR sky130_fd_sc_hd__decap_3
XFILLER_107_276 VGND VGND VPWR VPWR sky130_fd_sc_hd__decap_3
XFILLER_107_60 VGND VGND VPWR VPWR sky130_fd_sc_hd__decap_3
XFILLER_107_93 VGND VGND VPWR VPWR sky130_fd_sc_hd__fill_2
XFILLER_1_587 VGND VGND VPWR VPWR sky130_fd_sc_hd__decap_3
XFILLER_3_39 VGND VGND VPWR VPWR sky130_fd_sc_hd__decap_3
XFILLER_49_514 VGND VGND VPWR VPWR sky130_fd_sc_hd__fill_1
XFILLER_103_471 VGND VGND VPWR VPWR sky130_fd_sc_hd__decap_3
XPHY_EDGE_ROW_73_Right_73 VGND VGND VPWR VPWR sky130_fd_sc_hd__decap_3
XTAP_TAPCELL_ROW_112_1596 VGND VPWR sky130_fd_sc_hd__tapvpwrvgnd_1
XFILLER_67_97 VGND VGND VPWR VPWR sky130_fd_sc_hd__decap_3
XFILLER_76_344 VGND VGND VPWR VPWR sky130_fd_sc_hd__decap_3
Xload_slew1020 input13/X VGND VGND VPWR VPWR _3718_/A sky130_fd_sc_hd__clkbuf_4
Xhold1590 _5143_/Q VGND VGND VPWR VPWR _4055_/B2 sky130_fd_sc_hd__dlygate4sd3_1
Xload_slew1053 _3805_/S1 VGND VGND VPWR VPWR _3698_/S1 sky130_fd_sc_hd__clkbuf_4
XFILLER_17_477 VGND VGND VPWR VPWR sky130_fd_sc_hd__decap_3
XFILLER_32_403 VGND VGND VPWR VPWR sky130_fd_sc_hd__decap_3
XTAP_TAPCELL_ROW_67_1053 VGND VPWR sky130_fd_sc_hd__tapvpwrvgnd_1
Xload_slew1097 _3790_/S VGND VGND VPWR VPWR _3676_/S sky130_fd_sc_hd__buf_2
XFILLER_32_469 VGND VGND VPWR VPWR sky130_fd_sc_hd__decap_3
XFILLER_9_610 VGND VGND VPWR VPWR sky130_fd_sc_hd__decap_3
XPHY_EDGE_ROW_82_Right_82 VGND VGND VPWR VPWR sky130_fd_sc_hd__decap_3
XTAP_TAPCELL_ROW_30_604 VGND VPWR sky130_fd_sc_hd__tapvpwrvgnd_1
XFILLER_8_120 VGND VGND VPWR VPWR sky130_fd_sc_hd__decap_3
XTAP_TAPCELL_ROW_30_615 VGND VPWR sky130_fd_sc_hd__tapvpwrvgnd_1
XFILLER_9_676 VGND VGND VPWR VPWR sky130_fd_sc_hd__decap_3
X_2650_ _5790_/Q _5726_/Q _3114_/S VGND VGND VPWR VPWR _2650_/X sky130_fd_sc_hd__mux2_1
XFILLER_8_164 VGND VGND VPWR VPWR sky130_fd_sc_hd__decap_3
XFILLER_8_186 VGND VGND VPWR VPWR sky130_fd_sc_hd__decap_3
XFILLER_8_197 VGND VGND VPWR VPWR sky130_fd_sc_hd__decap_3
XTAP_TAPCELL_ROW_10_372 VGND VPWR sky130_fd_sc_hd__tapvpwrvgnd_1
X_2581_ _5787_/Q _5723_/Q _2589_/S VGND VGND VPWR VPWR _2581_/X sky130_fd_sc_hd__mux2_1
XFILLER_99_436 VGND VGND VPWR VPWR sky130_fd_sc_hd__decap_3
XTAP_TAPCELL_ROW_78_1182 VGND VPWR sky130_fd_sc_hd__tapvpwrvgnd_1
X_4320_ _4526_/A1 _4331_/A2 _4331_/B1 _4320_/B2 VGND VGND VPWR VPWR _5388_/D sky130_fd_sc_hd__a22o_2
XFILLER_87_609 VGND VGND VPWR VPWR sky130_fd_sc_hd__decap_3
X_4251_ _4525_/A1 wire482/A wire262/X _4251_/B2 VGND VGND VPWR VPWR _5323_/D sky130_fd_sc_hd__a22o_2
XFILLER_86_108 VGND VGND VPWR VPWR sky130_fd_sc_hd__decap_3
XPHY_EDGE_ROW_91_Right_91 VGND VGND VPWR VPWR sky130_fd_sc_hd__decap_3
X_3202_ _5942_/Q _5910_/Q _5878_/Q _5782_/Q _3204_/S _3202_/S1 VGND VGND VPWR VPWR
+ _3202_/X sky130_fd_sc_hd__mux4_2
X_4182_ _5001_/A1 _4162_/B _4185_/B1 _4182_/B2 VGND VGND VPWR VPWR _5259_/D sky130_fd_sc_hd__a22o_2
XFILLER_67_366 VGND VGND VPWR VPWR sky130_fd_sc_hd__fill_1
XFILLER_94_141 VGND VGND VPWR VPWR sky130_fd_sc_hd__decap_3
XTAP_TAPCELL_ROW_38_704 VGND VPWR sky130_fd_sc_hd__tapvpwrvgnd_1
X_3133_ _5587_/Q _5555_/Q _3133_/S VGND VGND VPWR VPWR _3133_/X sky130_fd_sc_hd__mux2_1
XFILLER_103_18 VGND VGND VPWR VPWR sky130_fd_sc_hd__fill_1
XFILLER_67_377 VGND VGND VPWR VPWR sky130_fd_sc_hd__fill_2
XFILLER_94_174 VGND VGND VPWR VPWR sky130_fd_sc_hd__decap_3
X_3064_ _5584_/Q _5552_/Q _3070_/S VGND VGND VPWR VPWR _3064_/X sky130_fd_sc_hd__mux2_1
XFILLER_63_572 VGND VGND VPWR VPWR sky130_fd_sc_hd__decap_3
XTAP_TAPCELL_ROW_18_461 VGND VPWR sky130_fd_sc_hd__tapvpwrvgnd_1
XFILLER_90_391 VGND VGND VPWR VPWR sky130_fd_sc_hd__decap_3
X_3966_ _4520_/A1 wire546/X wire325/X _3966_/B2 VGND VGND VPWR VPWR _5062_/D sky130_fd_sc_hd__a22o_2
X_5705_ _5785_/CLK _5705_/D VGND VGND VPWR VPWR _5705_/Q sky130_fd_sc_hd__dfxtp_2
X_2917_ _2905_/X _2916_/X _2619_/A VGND VGND VPWR VPWR _2917_/X sky130_fd_sc_hd__o21a_2
XFILLER_109_519 VGND VGND VPWR VPWR sky130_fd_sc_hd__decap_3
XFILLER_12_15 VGND VGND VPWR VPWR sky130_fd_sc_hd__decap_3
X_5636_ _6052_/CLK _5636_/D VGND VGND VPWR VPWR _5636_/Q sky130_fd_sc_hd__dfxtp_2
X_3897_ _3889_/A _3893_/X _3896_/X _3341_/A VGND VGND VPWR VPWR _3897_/X sky130_fd_sc_hd__o211a_2
XFILLER_12_59 VGND VGND VPWR VPWR sky130_fd_sc_hd__decap_3
X_2848_ _3118_/A1 _2844_/X _2847_/X _2837_/X VGND VGND VPWR VPWR _2848_/X sky130_fd_sc_hd__a31o_2
X_5567_ _5866_/CLK _5567_/D VGND VGND VPWR VPWR _5567_/Q sky130_fd_sc_hd__dfxtp_2
X_2779_ wire693/X _2776_/X _2778_/X VGND VGND VPWR VPWR _2779_/X sky130_fd_sc_hd__a21o_2
X_5498_ _5658_/CLK _5498_/D VGND VGND VPWR VPWR _5498_/Q sky130_fd_sc_hd__dfxtp_2
X_4518_ _4994_/A1 wire431/X _4536_/B1 _4518_/B2 VGND VGND VPWR VPWR _5572_/D sky130_fd_sc_hd__a22o_2
XFILLER_5_9 VGND VGND VPWR VPWR sky130_fd_sc_hd__decap_3
X_4449_ _4993_/A1 _4460_/A2 _4460_/B1 _4449_/B2 VGND VGND VPWR VPWR _5507_/D sky130_fd_sc_hd__a22o_2
Xfanout600 _3238_/X VGND VGND VPWR VPWR _3881_/B2 sky130_fd_sc_hd__dlymetal6s2s_1
XFILLER_98_491 VGND VGND VPWR VPWR sky130_fd_sc_hd__decap_3
Xfanout666 _2498_/Y VGND VGND VPWR VPWR _2572_/A sky130_fd_sc_hd__clkdlybuf4s25_1
Xfanout644 wire647/X VGND VGND VPWR VPWR _3004_/A1 sky130_fd_sc_hd__clkbuf_2
XFILLER_86_653 VGND VGND VPWR VPWR sky130_fd_sc_hd__decap_3
Xfanout699 _2496_/Y VGND VGND VPWR VPWR _3228_/B2 sky130_fd_sc_hd__clkdlybuf4s25_1
XFILLER_46_539 VGND VGND VPWR VPWR sky130_fd_sc_hd__decap_3
XFILLER_39_591 VGND VGND VPWR VPWR sky130_fd_sc_hd__decap_3
XFILLER_73_358 VGND VGND VPWR VPWR sky130_fd_sc_hd__decap_3
XFILLER_54_572 VGND VGND VPWR VPWR sky130_fd_sc_hd__fill_2
XFILLER_10_620 VGND VGND VPWR VPWR sky130_fd_sc_hd__decap_3
XFILLER_6_624 VGND VGND VPWR VPWR sky130_fd_sc_hd__decap_3
XFILLER_6_657 VGND VGND VPWR VPWR sky130_fd_sc_hd__decap_3
XFILLER_5_167 VGND VGND VPWR VPWR sky130_fd_sc_hd__fill_1
XFILLER_5_178 VGND VGND VPWR VPWR sky130_fd_sc_hd__fill_1
XTAP_TAPCELL_ROW_114_1614 VGND VPWR sky130_fd_sc_hd__tapvpwrvgnd_1
XFILLER_1_351 VGND VGND VPWR VPWR sky130_fd_sc_hd__decap_3
XFILLER_78_85 VGND VGND VPWR VPWR sky130_fd_sc_hd__decap_3
XFILLER_96_439 VGND VGND VPWR VPWR sky130_fd_sc_hd__decap_3
XFILLER_37_517 VGND VGND VPWR VPWR sky130_fd_sc_hd__decap_3
XFILLER_77_686 VGND VGND VPWR VPWR sky130_fd_sc_hd__fill_2
XFILLER_92_634 VGND VGND VPWR VPWR sky130_fd_sc_hd__decap_3
XFILLER_92_645 VGND VGND VPWR VPWR sky130_fd_sc_hd__decap_3
XFILLER_45_550 VGND VGND VPWR VPWR sky130_fd_sc_hd__fill_1
XFILLER_45_561 VGND VGND VPWR VPWR sky130_fd_sc_hd__fill_2
XFILLER_45_594 VGND VGND VPWR VPWR sky130_fd_sc_hd__decap_3
XFILLER_60_531 VGND VGND VPWR VPWR sky130_fd_sc_hd__fill_1
XTAP_TAPCELL_ROW_15_431 VGND VPWR sky130_fd_sc_hd__tapvpwrvgnd_1
XTAP_TAPCELL_ROW_43_762 VGND VPWR sky130_fd_sc_hd__tapvpwrvgnd_1
X_3820_ _5394_/Q _5362_/Q _5330_/Q _5298_/Q _3822_/S _3820_/S1 VGND VGND VPWR VPWR
+ _3820_/X sky130_fd_sc_hd__mux4_2
X_3751_ _5519_/Q _5487_/Q _3762_/S VGND VGND VPWR VPWR _3751_/X sky130_fd_sc_hd__mux2_1
XFILLER_9_462 VGND VGND VPWR VPWR sky130_fd_sc_hd__decap_3
X_2702_ _5568_/Q _5536_/Q _3021_/S VGND VGND VPWR VPWR _2702_/X sky130_fd_sc_hd__mux2_1
XFILLER_71_3 VGND VGND VPWR VPWR sky130_fd_sc_hd__decap_3
X_3682_ _5836_/Q _5452_/Q _3683_/S VGND VGND VPWR VPWR _3682_/X sky130_fd_sc_hd__mux2_1
X_5421_ _5805_/CLK _5421_/D VGND VGND VPWR VPWR _5421_/Q sky130_fd_sc_hd__dfxtp_2
X_2633_ _5821_/Q _5437_/Q _3114_/S VGND VGND VPWR VPWR _2633_/X sky130_fd_sc_hd__mux2_1
X_5352_ _6024_/CLK _5352_/D VGND VGND VPWR VPWR _5352_/Q sky130_fd_sc_hd__dfxtp_2
X_2564_ _5178_/Q _5146_/Q _2564_/S VGND VGND VPWR VPWR _2564_/X sky130_fd_sc_hd__mux2_1
XFILLER_114_533 VGND VGND VPWR VPWR sky130_fd_sc_hd__decap_3
X_4303_ _4509_/A1 _4329_/A2 _4329_/B1 _4303_/B2 VGND VGND VPWR VPWR _5371_/D sky130_fd_sc_hd__a22o_2
XFILLER_114_577 VGND VGND VPWR VPWR sky130_fd_sc_hd__decap_3
XFILLER_87_428 VGND VGND VPWR VPWR sky130_fd_sc_hd__decap_3
X_5283_ _5571_/CLK _5283_/D VGND VGND VPWR VPWR _5283_/Q sky130_fd_sc_hd__dfxtp_2
X_2495_ _3261_/B VGND VGND VPWR VPWR _2495_/Y sky130_fd_sc_hd__inv_2
XFILLER_101_238 VGND VGND VPWR VPWR sky130_fd_sc_hd__decap_3
X_4234_ _4645_/A1 wire482/X wire262/A _4234_/B2 VGND VGND VPWR VPWR _5306_/D sky130_fd_sc_hd__a22o_2
X_4165_ _5018_/A1 _4192_/A2 _4192_/B1 _4165_/B2 VGND VGND VPWR VPWR _5242_/D sky130_fd_sc_hd__a22o_2
XFILLER_28_539 VGND VGND VPWR VPWR sky130_fd_sc_hd__decap_3
X_3116_ _3183_/A1 _3113_/X _3115_/X _2558_/A VGND VGND VPWR VPWR _3116_/X sky130_fd_sc_hd__a22o_2
XFILLER_82_144 VGND VGND VPWR VPWR sky130_fd_sc_hd__fill_1
X_4096_ _4983_/A1 _4124_/A2 _4112_/B1 _4096_/B2 VGND VGND VPWR VPWR _5177_/D sky130_fd_sc_hd__a22o_2
X_3047_ _5583_/Q _5551_/Q _3145_/S VGND VGND VPWR VPWR _3047_/X sky130_fd_sc_hd__mux2_1
XFILLER_11_439 VGND VGND VPWR VPWR sky130_fd_sc_hd__fill_1
X_4998_ _4998_/A1 _4998_/A2 _4998_/B1 _4998_/B2 VGND VGND VPWR VPWR _6024_/D sky130_fd_sc_hd__a22o_2
X_3949_ _4401_/B input5/X input4/X VGND VGND VPWR VPWR _4744_/A sky130_fd_sc_hd__or3b_2
XFILLER_99_18 VGND VGND VPWR VPWR sky130_fd_sc_hd__decap_3
X_5619_ _5683_/CLK _5619_/D VGND VGND VPWR VPWR _5619_/Q sky130_fd_sc_hd__dfxtp_2
XFILLER_2_137 VGND VGND VPWR VPWR sky130_fd_sc_hd__decap_3
XFILLER_3_6 VGND VGND VPWR VPWR sky130_fd_sc_hd__decap_3
XFILLER_3_638 VGND VGND VPWR VPWR sky130_fd_sc_hd__decap_3
XFILLER_105_599 VGND VGND VPWR VPWR sky130_fd_sc_hd__decap_3
Xfanout441 _4436_/Y VGND VGND VPWR VPWR _4467_/A2 sky130_fd_sc_hd__clkdlybuf4s25_1
Xfanout430 _4504_/Y VGND VGND VPWR VPWR _4505_/B sky130_fd_sc_hd__clkdlybuf4s25_1
Xfanout474 _4264_/Y VGND VGND VPWR VPWR wire475/A sky130_fd_sc_hd__clkdlybuf4s25_1
Xfanout463 _4332_/Y VGND VGND VPWR VPWR _4364_/A2 sky130_fd_sc_hd__clkdlybuf4s25_1
Xfanout452 _4402_/Y VGND VGND VPWR VPWR _4435_/A2 sky130_fd_sc_hd__clkdlybuf4s25_1
XFILLER_19_539 VGND VGND VPWR VPWR sky130_fd_sc_hd__decap_3
XFILLER_48_88 VGND VGND VPWR VPWR sky130_fd_sc_hd__decap_3
XFILLER_58_174 VGND VGND VPWR VPWR sky130_fd_sc_hd__fill_1
Xfanout485 _4230_/Y VGND VGND VPWR VPWR _4260_/A2 sky130_fd_sc_hd__clkdlybuf4s25_1
XFILLER_0_18 VGND VGND VPWR VPWR sky130_fd_sc_hd__decap_3
XFILLER_0_29 VGND VGND VPWR VPWR sky130_fd_sc_hd__decap_3
XFILLER_73_144 VGND VGND VPWR VPWR sky130_fd_sc_hd__decap_3
XFILLER_86_494 VGND VGND VPWR VPWR sky130_fd_sc_hd__decap_3
XFILLER_104_83 VGND VGND VPWR VPWR sky130_fd_sc_hd__fill_1
XFILLER_27_561 VGND VGND VPWR VPWR sky130_fd_sc_hd__fill_2
XFILLER_14_200 VGND VGND VPWR VPWR sky130_fd_sc_hd__fill_2
XFILLER_54_391 VGND VGND VPWR VPWR sky130_fd_sc_hd__fill_2
XTAP_TAPCELL_ROW_64_1012 VGND VPWR sky130_fd_sc_hd__tapvpwrvgnd_1
XTAP_TAPCELL_ROW_64_1023 VGND VPWR sky130_fd_sc_hd__tapvpwrvgnd_1
XFILLER_14_244 VGND VGND VPWR VPWR sky130_fd_sc_hd__decap_3
XFILLER_9_27 VGND VGND VPWR VPWR sky130_fd_sc_hd__decap_3
XTAP_TAPCELL_ROW_40_732 VGND VPWR sky130_fd_sc_hd__tapvpwrvgnd_1
XFILLER_6_421 VGND VGND VPWR VPWR sky130_fd_sc_hd__decap_3
XPHY_EDGE_ROW_108_Right_108 VGND VGND VPWR VPWR sky130_fd_sc_hd__decap_3
XTAP_TAPCELL_ROW_75_1152 VGND VPWR sky130_fd_sc_hd__tapvpwrvgnd_1
XFILLER_2_660 VGND VGND VPWR VPWR sky130_fd_sc_hd__decap_3
Xload_slew814 _2998_/S VGND VGND VPWR VPWR _3115_/S sky130_fd_sc_hd__buf_4
XFILLER_69_428 VGND VGND VPWR VPWR sky130_fd_sc_hd__decap_3
Xload_slew847 _2743_/S VGND VGND VPWR VPWR _3227_/S sky130_fd_sc_hd__buf_2
Xload_slew836 _3159_/S VGND VGND VPWR VPWR _2794_/S sky130_fd_sc_hd__clkbuf_2
XFILLER_111_569 VGND VGND VPWR VPWR sky130_fd_sc_hd__decap_3
XPHY_EDGE_ROW_63_Left_179 VGND VGND VPWR VPWR sky130_fd_sc_hd__decap_3
XFILLER_49_196 VGND VGND VPWR VPWR sky130_fd_sc_hd__decap_3
XTAP_TAPCELL_ROW_48_821 VGND VPWR sky130_fd_sc_hd__tapvpwrvgnd_1
XFILLER_18_550 VGND VGND VPWR VPWR sky130_fd_sc_hd__decap_3
XFILLER_92_464 VGND VGND VPWR VPWR sky130_fd_sc_hd__fill_2
X_5970_ _6066_/CLK _5970_/D VGND VGND VPWR VPWR _5970_/Q sky130_fd_sc_hd__dfxtp_2
XFILLER_80_637 VGND VGND VPWR VPWR sky130_fd_sc_hd__decap_3
XFILLER_80_648 VGND VGND VPWR VPWR sky130_fd_sc_hd__decap_3
XFILLER_92_497 VGND VGND VPWR VPWR sky130_fd_sc_hd__decap_3
X_4921_ _5023_/A1 wire353/X wire136/A _4921_/B2 VGND VGND VPWR VPWR _5951_/D sky130_fd_sc_hd__a22o_2
XTAP_TAPCELL_ROW_86_1281 VGND VPWR sky130_fd_sc_hd__tapvpwrvgnd_1
X_4852_ _4886_/A1 _4875_/A2 _4875_/B1 _4852_/B2 VGND VGND VPWR VPWR _5886_/D sky130_fd_sc_hd__a22o_2
XFILLER_33_597 VGND VGND VPWR VPWR sky130_fd_sc_hd__fill_2
X_3803_ _3404_/A _3801_/X _3802_/X _3842_/A1 VGND VGND VPWR VPWR _3803_/X sky130_fd_sc_hd__o22a_2
XPHY_EDGE_ROW_72_Left_188 VGND VGND VPWR VPWR sky130_fd_sc_hd__decap_3
X_4783_ _4805_/A_N _4783_/B VGND VGND VPWR VPWR _5821_/D sky130_fd_sc_hd__and2b_2
X_3734_ _3433_/A _3731_/X _3733_/X _3791_/B2 VGND VGND VPWR VPWR _3734_/X sky130_fd_sc_hd__a22o_2
XFILLER_9_281 VGND VGND VPWR VPWR sky130_fd_sc_hd__decap_3
X_3665_ _5515_/Q _5483_/Q _3665_/S VGND VGND VPWR VPWR _3665_/X sky130_fd_sc_hd__mux2_1
XFILLER_109_39 VGND VGND VPWR VPWR sky130_fd_sc_hd__decap_3
Xclkload40 _5514_/CLK VGND VGND VPWR VPWR clkload40/Y sky130_fd_sc_hd__bufinv_16
X_5404_ clkload8/A _5404_/D VGND VGND VPWR VPWR _5404_/Q sky130_fd_sc_hd__dfxtp_2
X_2616_ _3019_/A _2613_/X _2615_/X _3134_/A1 VGND VGND VPWR VPWR _2616_/X sky130_fd_sc_hd__o22a_2
X_3596_ _5416_/Q _5064_/Q _5800_/Q _5736_/Q _3609_/S _3820_/S1 VGND VGND VPWR VPWR
+ _3596_/X sky130_fd_sc_hd__mux4_2
X_5335_ _5704_/CLK _5335_/D VGND VGND VPWR VPWR _5335_/Q sky130_fd_sc_hd__dfxtp_2
X_2547_ wire693/X _2545_/X _2546_/X wire659/X VGND VGND VPWR VPWR _2547_/X sky130_fd_sc_hd__a22o_2
XFILLER_87_225 VGND VGND VPWR VPWR sky130_fd_sc_hd__fill_1
XPHY_EDGE_ROW_81_Left_197 VGND VGND VPWR VPWR sky130_fd_sc_hd__decap_3
X_5266_ _5805_/CLK _5266_/D VGND VGND VPWR VPWR _5266_/Q sky130_fd_sc_hd__dfxtp_2
XFILLER_102_558 VGND VGND VPWR VPWR sky130_fd_sc_hd__decap_3
X_4217_ _4525_/A1 wire489/A wire269/X _4217_/B2 VGND VGND VPWR VPWR _5291_/D sky130_fd_sc_hd__a22o_2
XFILLER_18_14 VGND VGND VPWR VPWR sky130_fd_sc_hd__decap_3
X_5197_ _6029_/CLK _5197_/D VGND VGND VPWR VPWR _5197_/Q sky130_fd_sc_hd__dfxtp_2
XFILLER_110_580 VGND VGND VPWR VPWR sky130_fd_sc_hd__decap_3
XFILLER_56_634 VGND VGND VPWR VPWR sky130_fd_sc_hd__fill_1
XFILLER_56_645 VGND VGND VPWR VPWR sky130_fd_sc_hd__decap_3
XFILLER_83_420 VGND VGND VPWR VPWR sky130_fd_sc_hd__fill_1
XFILLER_83_442 VGND VGND VPWR VPWR sky130_fd_sc_hd__decap_3
X_4148_ _5001_/A1 _4128_/B _4151_/B1 _4148_/B2 VGND VGND VPWR VPWR _5227_/D sky130_fd_sc_hd__a22o_2
XFILLER_16_509 VGND VGND VPWR VPWR sky130_fd_sc_hd__fill_2
XFILLER_55_144 VGND VGND VPWR VPWR sky130_fd_sc_hd__fill_1
X_4079_ _4525_/A1 _4059_/B _4088_/B1 _4079_/B2 VGND VGND VPWR VPWR _5163_/D sky130_fd_sc_hd__a22o_2
XFILLER_24_520 VGND VGND VPWR VPWR sky130_fd_sc_hd__decap_3
XFILLER_83_486 VGND VGND VPWR VPWR sky130_fd_sc_hd__fill_1
XFILLER_24_553 VGND VGND VPWR VPWR sky130_fd_sc_hd__decap_3
XTAP_TAPCELL_ROW_26_559 VGND VPWR sky130_fd_sc_hd__tapvpwrvgnd_1
XFILLER_24_575 VGND VGND VPWR VPWR sky130_fd_sc_hd__fill_2
XFILLER_24_586 VGND VGND VPWR VPWR sky130_fd_sc_hd__fill_2
XFILLER_34_68 VGND VGND VPWR VPWR sky130_fd_sc_hd__decap_3
XFILLER_11_225 VGND VGND VPWR VPWR sky130_fd_sc_hd__fill_1
XFILLER_109_102 VGND VGND VPWR VPWR sky130_fd_sc_hd__fill_2
Xclkload1 clkload1/A VGND VGND VPWR VPWR clkload1/X sky130_fd_sc_hd__clkbuf_8
XFILLER_109_135 VGND VGND VPWR VPWR sky130_fd_sc_hd__decap_3
XFILLER_50_67 VGND VGND VPWR VPWR sky130_fd_sc_hd__decap_3
XFILLER_1_3 VGND VGND VPWR VPWR sky130_fd_sc_hd__decap_3
XFILLER_105_374 VGND VGND VPWR VPWR sky130_fd_sc_hd__fill_1
XFILLER_59_76 VGND VGND VPWR VPWR sky130_fd_sc_hd__decap_3
XFILLER_115_60 VGND VGND VPWR VPWR sky130_fd_sc_hd__decap_3
XFILLER_19_303 VGND VGND VPWR VPWR sky130_fd_sc_hd__decap_3
XFILLER_93_206 VGND VGND VPWR VPWR sky130_fd_sc_hd__decap_3
XFILLER_93_228 VGND VGND VPWR VPWR sky130_fd_sc_hd__fill_1
Xfanout282 _4162_/Y VGND VGND VPWR VPWR wire283/A sky130_fd_sc_hd__clkdlybuf4s25_1
Xfanout260 _4265_/Y VGND VGND VPWR VPWR _4297_/B1 sky130_fd_sc_hd__clkdlybuf4s25_1
XFILLER_46_122 VGND VGND VPWR VPWR sky130_fd_sc_hd__decap_3
XFILLER_47_634 VGND VGND VPWR VPWR sky130_fd_sc_hd__decap_3
XFILLER_47_645 VGND VGND VPWR VPWR sky130_fd_sc_hd__decap_3
XFILLER_86_291 VGND VGND VPWR VPWR sky130_fd_sc_hd__decap_3
XTAP_TAPCELL_ROW_70_1093 VGND VPWR sky130_fd_sc_hd__tapvpwrvgnd_1
Xfanout293 _4121_/B1 VGND VGND VPWR VPWR _4112_/B1 sky130_fd_sc_hd__clkdlybuf4s25_1
XFILLER_19_358 VGND VGND VPWR VPWR sky130_fd_sc_hd__decap_3
XFILLER_46_144 VGND VGND VPWR VPWR sky130_fd_sc_hd__decap_3
XFILLER_62_604 VGND VGND VPWR VPWR sky130_fd_sc_hd__fill_1
XTAP_TAPCELL_ROW_109_1557 VGND VPWR sky130_fd_sc_hd__tapvpwrvgnd_1
XFILLER_34_328 VGND VGND VPWR VPWR sky130_fd_sc_hd__decap_3
XFILLER_62_648 VGND VGND VPWR VPWR sky130_fd_sc_hd__decap_3
XFILLER_62_659 VGND VGND VPWR VPWR sky130_fd_sc_hd__decap_3
XFILLER_74_497 VGND VGND VPWR VPWR sky130_fd_sc_hd__fill_1
XFILLER_27_391 VGND VGND VPWR VPWR sky130_fd_sc_hd__fill_1
XFILLER_15_564 VGND VGND VPWR VPWR sky130_fd_sc_hd__fill_2
XFILLER_15_597 VGND VGND VPWR VPWR sky130_fd_sc_hd__decap_3
XFILLER_30_523 VGND VGND VPWR VPWR sky130_fd_sc_hd__fill_1
XFILLER_30_545 VGND VGND VPWR VPWR sky130_fd_sc_hd__decap_3
XTAP_TAPCELL_ROW_53_890 VGND VPWR sky130_fd_sc_hd__tapvpwrvgnd_1
XFILLER_115_116 VGND VGND VPWR VPWR sky130_fd_sc_hd__fill_1
XFILLER_115_127 VGND VGND VPWR VPWR sky130_fd_sc_hd__fill_1
X_3450_ _5569_/Q _5537_/Q _3700_/S VGND VGND VPWR VPWR _3450_/X sky130_fd_sc_hd__mux2_1
X_3381_ _3708_/A1 _3378_/X _3380_/X _3881_/B2 VGND VGND VPWR VPWR _3381_/X sky130_fd_sc_hd__a22o_2
XFILLER_34_3 VGND VGND VPWR VPWR sky130_fd_sc_hd__decap_3
XFILLER_69_225 VGND VGND VPWR VPWR sky130_fd_sc_hd__decap_3
Xhold2109 _5895_/Q VGND VGND VPWR VPWR _4861_/B2 sky130_fd_sc_hd__dlygate4sd3_1
Xload_slew622 _3753_/A1 VGND VGND VPWR VPWR _3784_/A sky130_fd_sc_hd__buf_4
Xload_slew611 _3547_/B2 VGND VGND VPWR VPWR _3872_/A sky130_fd_sc_hd__clkbuf_4
X_5120_ _6056_/CLK _5120_/D VGND VGND VPWR VPWR _5120_/Q sky130_fd_sc_hd__dfxtp_2
Xload_slew655 _3222_/A1 VGND VGND VPWR VPWR _3218_/B2 sky130_fd_sc_hd__buf_4
Xload_slew633 fanout632/X VGND VGND VPWR VPWR _3833_/B2 sky130_fd_sc_hd__buf_4
X_5051_ _5659_/CLK _5051_/D VGND VGND VPWR VPWR _5051_/Q sky130_fd_sc_hd__dfxtp_2
XFILLER_97_589 VGND VGND VPWR VPWR sky130_fd_sc_hd__decap_3
Xhold1408 _5630_/Q VGND VGND VPWR VPWR _4581_/B2 sky130_fd_sc_hd__dlygate4sd3_1
Xhold1419 _5196_/Q VGND VGND VPWR VPWR _4115_/B2 sky130_fd_sc_hd__dlygate4sd3_1
X_4002_ _4519_/A1 _3988_/B _4019_/B1 _4002_/B2 VGND VGND VPWR VPWR _5093_/D sky130_fd_sc_hd__a22o_2
XFILLER_38_645 VGND VGND VPWR VPWR sky130_fd_sc_hd__decap_3
XTAP_TAPCELL_ROW_88_1310 VGND VPWR sky130_fd_sc_hd__tapvpwrvgnd_1
XFILLER_1_72 VGND VGND VPWR VPWR sky130_fd_sc_hd__decap_3
XFILLER_53_615 VGND VGND VPWR VPWR sky130_fd_sc_hd__fill_1
XFILLER_65_475 VGND VGND VPWR VPWR sky130_fd_sc_hd__fill_2
XFILLER_111_18 VGND VGND VPWR VPWR sky130_fd_sc_hd__decap_3
XFILLER_1_94 VGND VGND VPWR VPWR sky130_fd_sc_hd__fill_1
XFILLER_37_188 VGND VGND VPWR VPWR sky130_fd_sc_hd__fill_2
XFILLER_92_272 VGND VGND VPWR VPWR sky130_fd_sc_hd__decap_3
X_5953_ _6049_/CLK _5953_/D VGND VGND VPWR VPWR _5953_/Q sky130_fd_sc_hd__dfxtp_2
XFILLER_33_350 VGND VGND VPWR VPWR sky130_fd_sc_hd__decap_3
XFILLER_40_309 VGND VGND VPWR VPWR sky130_fd_sc_hd__decap_3
XFILLER_61_681 VGND VGND VPWR VPWR sky130_fd_sc_hd__decap_3
XTAP_TAPCELL_ROW_23_529 VGND VPWR sky130_fd_sc_hd__tapvpwrvgnd_1
X_5884_ _6044_/CLK _5884_/D VGND VGND VPWR VPWR _5884_/Q sky130_fd_sc_hd__dfxtp_2
X_4904_ _4904_/A1 _4904_/A2 _4908_/B1 _4904_/B2 VGND VGND VPWR VPWR _5936_/D sky130_fd_sc_hd__a22o_2
X_4835_ _4903_/A1 wire374/X wire156/X _4835_/B2 VGND VGND VPWR VPWR _5871_/D sky130_fd_sc_hd__a22o_2
X_4766_ _4766_/A1 _4777_/A2 _4777_/B1 _4766_/B2 VGND VGND VPWR VPWR _5804_/D sky130_fd_sc_hd__a22o_2
X_3717_ _5837_/Q _5453_/Q _6061_/Q _5965_/Q _3568_/S _3717_/S1 VGND VGND VPWR VPWR
+ _3718_/B sky130_fd_sc_hd__mux4_2
X_4697_ _4766_/A1 _4708_/A2 _4708_/B1 _4697_/B2 VGND VGND VPWR VPWR _5740_/D sky130_fd_sc_hd__a22o_2
XFILLER_105_9 VGND VGND VPWR VPWR sky130_fd_sc_hd__decap_3
X_3648_ _5386_/Q _5354_/Q _5322_/Q _5290_/Q _3585_/S _3648_/S1 VGND VGND VPWR VPWR
+ _3649_/B sky130_fd_sc_hd__mux4_2
X_3579_ _5255_/Q _5223_/Q _3580_/S VGND VGND VPWR VPWR _3579_/X sky130_fd_sc_hd__mux2_1
X_5318_ _5659_/CLK _5318_/D VGND VGND VPWR VPWR _5318_/Q sky130_fd_sc_hd__dfxtp_2
XFILLER_0_449 VGND VGND VPWR VPWR sky130_fd_sc_hd__fill_1
XFILLER_29_24 VGND VGND VPWR VPWR sky130_fd_sc_hd__fill_2
XFILLER_29_57 VGND VGND VPWR VPWR sky130_fd_sc_hd__decap_3
XFILLER_88_589 VGND VGND VPWR VPWR sky130_fd_sc_hd__decap_3
Xhold1920 _5671_/Q VGND VGND VPWR VPWR _4624_/B2 sky130_fd_sc_hd__dlygate4sd3_1
X_5249_ _6026_/CLK _5249_/D VGND VGND VPWR VPWR _5249_/Q sky130_fd_sc_hd__dfxtp_2
XFILLER_29_623 VGND VGND VPWR VPWR sky130_fd_sc_hd__decap_3
Xhold1931 _5963_/Q VGND VGND VPWR VPWR _4933_/B2 sky130_fd_sc_hd__dlygate4sd3_1
Xhold1942 _5598_/Q VGND VGND VPWR VPWR _4547_/B2 sky130_fd_sc_hd__dlygate4sd3_1
Xhold1953 _5585_/Q VGND VGND VPWR VPWR _4531_/B2 sky130_fd_sc_hd__dlygate4sd3_1
XTAP_TAPCELL_ROW_3_287 VGND VPWR sky130_fd_sc_hd__tapvpwrvgnd_1
Xhold1964 _5723_/Q VGND VGND VPWR VPWR _4680_/B2 sky130_fd_sc_hd__dlygate4sd3_1
Xhold1975 _5730_/Q VGND VGND VPWR VPWR _4687_/B2 sky130_fd_sc_hd__dlygate4sd3_1
Xhold1986 _5622_/Q VGND VGND VPWR VPWR _4571_/B2 sky130_fd_sc_hd__dlygate4sd3_1
Xhold1997 _5223_/Q VGND VGND VPWR VPWR _4144_/B2 sky130_fd_sc_hd__dlygate4sd3_1
XFILLER_28_177 VGND VGND VPWR VPWR sky130_fd_sc_hd__decap_3
XFILLER_28_188 VGND VGND VPWR VPWR sky130_fd_sc_hd__decap_3
XFILLER_44_648 VGND VGND VPWR VPWR sky130_fd_sc_hd__fill_1
XFILLER_45_45 VGND VGND VPWR VPWR sky130_fd_sc_hd__decap_3
XFILLER_45_78 VGND VGND VPWR VPWR sky130_fd_sc_hd__decap_3
XFILLER_24_350 VGND VGND VPWR VPWR sky130_fd_sc_hd__decap_3
XTAP_TAPCELL_ROW_104_1498 VGND VPWR sky130_fd_sc_hd__tapvpwrvgnd_1
XFILLER_12_589 VGND VGND VPWR VPWR sky130_fd_sc_hd__fill_2
XFILLER_106_672 VGND VGND VPWR VPWR sky130_fd_sc_hd__decap_3
XFILLER_79_523 VGND VGND VPWR VPWR sky130_fd_sc_hd__decap_3
XTAP_TAPCELL_ROW_72_1111 VGND VPWR sky130_fd_sc_hd__tapvpwrvgnd_1
XFILLER_79_556 VGND VGND VPWR VPWR sky130_fd_sc_hd__decap_3
Xfanout1011 input13/X VGND VGND VPWR VPWR _3745_/A1 sky130_fd_sc_hd__clkdlybuf4s25_1
Xfanout1044 _3919_/S1 VGND VGND VPWR VPWR _3866_/S1 sky130_fd_sc_hd__clkdlybuf4s25_1
Xfanout1033 wire1038/A VGND VGND VPWR VPWR _3820_/S1 sky130_fd_sc_hd__clkdlybuf4s25_1
XFILLER_19_111 VGND VGND VPWR VPWR sky130_fd_sc_hd__fill_1
XFILLER_66_239 VGND VGND VPWR VPWR sky130_fd_sc_hd__fill_1
XFILLER_86_85 VGND VGND VPWR VPWR sky130_fd_sc_hd__decap_3
Xfanout1088 _3469_/S0 VGND VGND VPWR VPWR _3379_/S sky130_fd_sc_hd__clkbuf_2
XFILLER_19_90 VGND VGND VPWR VPWR sky130_fd_sc_hd__fill_1
XFILLER_35_604 VGND VGND VPWR VPWR sky130_fd_sc_hd__fill_1
XFILLER_35_626 VGND VGND VPWR VPWR sky130_fd_sc_hd__decap_3
XFILLER_15_361 VGND VGND VPWR VPWR sky130_fd_sc_hd__fill_2
XFILLER_22_309 VGND VGND VPWR VPWR sky130_fd_sc_hd__fill_2
X_2950_ _5707_/Q _5675_/Q _5643_/Q _5611_/Q _2942_/S _3057_/S1 VGND VGND VPWR VPWR
+ _2950_/X sky130_fd_sc_hd__mux4_2
XTAP_TAPCELL_ROW_83_1251 VGND VPWR sky130_fd_sc_hd__tapvpwrvgnd_1
XTAP_TAPCELL_ROW_83_1240 VGND VPWR sky130_fd_sc_hd__tapvpwrvgnd_1
X_2881_ wire725/A _2877_/X _2880_/X _3185_/A1 VGND VGND VPWR VPWR _2881_/X sky130_fd_sc_hd__o211a_2
XFILLER_30_353 VGND VGND VPWR VPWR sky130_fd_sc_hd__decap_3
X_4620_ _4891_/A1 wire407/X wire186/X _4620_/B2 VGND VGND VPWR VPWR _5667_/D sky130_fd_sc_hd__a22o_2
XFILLER_30_397 VGND VGND VPWR VPWR sky130_fd_sc_hd__decap_3
X_4551_ _4992_/A1 _4572_/A2 _4572_/B1 _4551_/B2 VGND VGND VPWR VPWR _5602_/D sky130_fd_sc_hd__a22o_2
X_4482_ _4822_/A1 _4498_/A2 _4498_/B1 _4482_/B2 VGND VGND VPWR VPWR _5538_/D sky130_fd_sc_hd__a22o_2
X_3502_ _3502_/A1 _3500_/X _3501_/X _3611_/B2 VGND VGND VPWR VPWR _3502_/X sky130_fd_sc_hd__o22a_2
XFILLER_104_609 VGND VGND VPWR VPWR sky130_fd_sc_hd__fill_1
X_3433_ _3433_/A _3433_/B VGND VGND VPWR VPWR _3433_/X sky130_fd_sc_hd__or2_2
XFILLER_103_119 VGND VGND VPWR VPWR sky130_fd_sc_hd__decap_3
XFILLER_106_18 VGND VGND VPWR VPWR sky130_fd_sc_hd__decap_3
XTAP_TAPCELL_ROW_94_1380 VGND VPWR sky130_fd_sc_hd__tapvpwrvgnd_1
XFILLER_106_29 VGND VGND VPWR VPWR sky130_fd_sc_hd__decap_3
XFILLER_112_631 VGND VGND VPWR VPWR sky130_fd_sc_hd__decap_3
X_5103_ _6031_/CLK _5103_/D VGND VGND VPWR VPWR _5103_/Q sky130_fd_sc_hd__dfxtp_2
X_3364_ _3470_/S _3361_/X _3363_/X _3831_/B2 VGND VGND VPWR VPWR _3364_/X sky130_fd_sc_hd__o22a_2
XFILLER_111_141 VGND VGND VPWR VPWR sky130_fd_sc_hd__fill_1
XFILLER_112_675 VGND VGND VPWR VPWR sky130_fd_sc_hd__decap_3
Xhold1205 _5755_/Q VGND VGND VPWR VPWR _4715_/B2 sky130_fd_sc_hd__dlygate4sd3_1
Xhold1216 _5610_/Q VGND VGND VPWR VPWR _4559_/B2 sky130_fd_sc_hd__dlygate4sd3_1
X_3295_ _6042_/Q _5946_/Q _3325_/S VGND VGND VPWR VPWR _3295_/X sky130_fd_sc_hd__mux2_1
XFILLER_38_431 VGND VGND VPWR VPWR sky130_fd_sc_hd__fill_2
XFILLER_85_537 VGND VGND VPWR VPWR sky130_fd_sc_hd__fill_2
Xhold1227 _5255_/Q VGND VGND VPWR VPWR _4178_/B2 sky130_fd_sc_hd__dlygate4sd3_1
Xhold1238 _5808_/Q VGND VGND VPWR VPWR _4770_/B2 sky130_fd_sc_hd__dlygate4sd3_1
Xhold1249 _6057_/Q VGND VGND VPWR VPWR _5033_/B2 sky130_fd_sc_hd__dlygate4sd3_1
Xload_slew496 _4179_/A2 VGND VGND VPWR VPWR _4192_/A2 sky130_fd_sc_hd__clkbuf_4
X_5034_ _5034_/A1 wire334/X _5047_/B1 _5034_/B2 VGND VGND VPWR VPWR _6058_/D sky130_fd_sc_hd__a22o_2
XTAP_TAPCELL_ROW_56_919 VGND VPWR sky130_fd_sc_hd__tapvpwrvgnd_1
XTAP_TAPCELL_ROW_0_235 VGND VPWR sky130_fd_sc_hd__tapvpwrvgnd_1
XFILLER_25_136 VGND VGND VPWR VPWR sky130_fd_sc_hd__decap_3
XFILLER_53_434 VGND VGND VPWR VPWR sky130_fd_sc_hd__decap_3
XTAP_TAPCELL_ROW_0_246 VGND VPWR sky130_fd_sc_hd__tapvpwrvgnd_1
XFILLER_15_15 VGND VGND VPWR VPWR sky130_fd_sc_hd__decap_3
XFILLER_15_37 VGND VGND VPWR VPWR sky130_fd_sc_hd__fill_1
XFILLER_41_629 VGND VGND VPWR VPWR sky130_fd_sc_hd__decap_3
XTAP_TAPCELL_ROW_36_676 VGND VPWR sky130_fd_sc_hd__tapvpwrvgnd_1
XTAP_TAPCELL_ROW_36_687 VGND VPWR sky130_fd_sc_hd__tapvpwrvgnd_1
X_5936_ _6064_/CLK _5936_/D VGND VGND VPWR VPWR _5936_/Q sky130_fd_sc_hd__dfxtp_2
XFILLER_34_681 VGND VGND VPWR VPWR sky130_fd_sc_hd__decap_3
XFILLER_40_128 VGND VGND VPWR VPWR sky130_fd_sc_hd__decap_3
X_5867_ _5867_/CLK _5867_/D VGND VGND VPWR VPWR _5867_/Q sky130_fd_sc_hd__dfxtp_2
X_5798_ _6034_/CLK _5798_/D VGND VGND VPWR VPWR _5798_/Q sky130_fd_sc_hd__dfxtp_2
X_4818_ _4886_/A1 _4841_/A2 _4841_/B1 _4818_/B2 VGND VGND VPWR VPWR _5854_/D sky130_fd_sc_hd__a22o_2
XTAP_TAPCELL_ROW_97_1409 VGND VPWR sky130_fd_sc_hd__tapvpwrvgnd_1
X_4749_ _4749_/A1 _4762_/A2 _4762_/B1 _4749_/B2 VGND VGND VPWR VPWR _5787_/D sky130_fd_sc_hd__a22o_2
XFILLER_103_6 VGND VGND VPWR VPWR sky130_fd_sc_hd__decap_3
Xoutput58 _2917_/X VGND VGND VPWR VPWR rd1[17] sky130_fd_sc_hd__dlymetal6s2s_1
XFILLER_103_620 VGND VGND VPWR VPWR sky130_fd_sc_hd__decap_3
Xoutput69 _3142_/X VGND VGND VPWR VPWR rd1[27] sky130_fd_sc_hd__dlymetal6s2s_1
XTAP_TAPCELL_ROW_8_346 VGND VPWR sky130_fd_sc_hd__tapvpwrvgnd_1
XFILLER_76_504 VGND VGND VPWR VPWR sky130_fd_sc_hd__fill_2
XFILLER_88_353 VGND VGND VPWR VPWR sky130_fd_sc_hd__decap_3
XFILLER_29_431 VGND VGND VPWR VPWR sky130_fd_sc_hd__decap_3
XFILLER_88_397 VGND VGND VPWR VPWR sky130_fd_sc_hd__fill_1
XFILLER_29_442 VGND VGND VPWR VPWR sky130_fd_sc_hd__decap_3
Xhold1750 _5743_/Q VGND VGND VPWR VPWR _4700_/B2 sky130_fd_sc_hd__dlygate4sd3_1
Xhold1761 _5968_/Q VGND VGND VPWR VPWR _4938_/B2 sky130_fd_sc_hd__dlygate4sd3_1
XFILLER_17_615 VGND VGND VPWR VPWR sky130_fd_sc_hd__fill_1
XFILLER_56_283 VGND VGND VPWR VPWR sky130_fd_sc_hd__fill_1
XFILLER_56_88 VGND VGND VPWR VPWR sky130_fd_sc_hd__decap_3
XFILLER_84_592 VGND VGND VPWR VPWR sky130_fd_sc_hd__decap_3
XTAP_TAPCELL_ROW_106_1516 VGND VPWR sky130_fd_sc_hd__tapvpwrvgnd_1
XTAP_TAPCELL_ROW_106_1527 VGND VPWR sky130_fd_sc_hd__tapvpwrvgnd_1
Xhold1772 _5675_/Q VGND VGND VPWR VPWR _4628_/B2 sky130_fd_sc_hd__dlygate4sd3_1
Xhold1783 _5340_/Q VGND VGND VPWR VPWR _4270_/B2 sky130_fd_sc_hd__dlygate4sd3_1
Xhold1794 _5060_/Q VGND VGND VPWR VPWR _3964_/B2 sky130_fd_sc_hd__dlygate4sd3_1
XFILLER_112_50 VGND VGND VPWR VPWR sky130_fd_sc_hd__decap_3
XFILLER_112_83 VGND VGND VPWR VPWR sky130_fd_sc_hd__fill_1
XFILLER_112_94 VGND VGND VPWR VPWR sky130_fd_sc_hd__decap_3
XFILLER_12_397 VGND VGND VPWR VPWR sky130_fd_sc_hd__fill_1
XFILLER_8_368 VGND VGND VPWR VPWR sky130_fd_sc_hd__decap_3
XFILLER_21_91 VGND VGND VPWR VPWR sky130_fd_sc_hd__decap_3
XFILLER_106_480 VGND VGND VPWR VPWR sky130_fd_sc_hd__decap_3
XFILLER_97_51 VGND VGND VPWR VPWR sky130_fd_sc_hd__decap_3
XFILLER_39_239 VGND VGND VPWR VPWR sky130_fd_sc_hd__decap_3
XFILLER_67_526 VGND VGND VPWR VPWR sky130_fd_sc_hd__fill_1
X_3080_ _5137_/Q _5105_/Q _6033_/Q _6001_/Q _3083_/S _3091_/S1 VGND VGND VPWR VPWR
+ _3081_/B sky130_fd_sc_hd__mux4_2
XFILLER_90_551 VGND VGND VPWR VPWR sky130_fd_sc_hd__decap_3
XFILLER_62_253 VGND VGND VPWR VPWR sky130_fd_sc_hd__fill_1
X_3982_ _4776_/A1 _3982_/A2 _3982_/B1 _3982_/B2 VGND VGND VPWR VPWR _5078_/D sky130_fd_sc_hd__a22o_2
XFILLER_22_139 VGND VGND VPWR VPWR sky130_fd_sc_hd__fill_1
XFILLER_90_595 VGND VGND VPWR VPWR sky130_fd_sc_hd__decap_3
XTAP_TAPCELL_ROW_33_646 VGND VPWR sky130_fd_sc_hd__tapvpwrvgnd_1
X_5721_ _5785_/CLK _5721_/D VGND VGND VPWR VPWR _5721_/Q sky130_fd_sc_hd__dfxtp_2
X_2933_ _5930_/Q _5898_/Q _5866_/Q _5770_/Q _2971_/S _2973_/S1 VGND VGND VPWR VPWR
+ _2933_/X sky130_fd_sc_hd__mux4_2
XTAP_TAPCELL_ROW_61_977 VGND VPWR sky130_fd_sc_hd__tapvpwrvgnd_1
XFILLER_31_673 VGND VGND VPWR VPWR sky130_fd_sc_hd__decap_3
X_5652_ _6068_/CLK _5652_/D VGND VGND VPWR VPWR _5652_/Q sky130_fd_sc_hd__dfxtp_2
X_2864_ _3218_/B2 _2862_/X _2863_/X _3218_/A1 VGND VGND VPWR VPWR _2864_/X sky130_fd_sc_hd__o22a_2
X_5583_ _5999_/CLK _5583_/D VGND VGND VPWR VPWR _5583_/Q sky130_fd_sc_hd__dfxtp_2
X_4603_ _4908_/A1 _4605_/A2 _4605_/B1 _4603_/B2 VGND VGND VPWR VPWR _5652_/D sky130_fd_sc_hd__a22o_2
X_2795_ _5796_/Q _5732_/Q _3159_/S VGND VGND VPWR VPWR _2795_/X sky130_fd_sc_hd__mux2_1
XFILLER_7_60 VGND VGND VPWR VPWR sky130_fd_sc_hd__decap_3
X_4534_ _4534_/A1 wire431/X _4536_/B1 _4534_/B2 VGND VGND VPWR VPWR _5588_/D sky130_fd_sc_hd__a22o_2
XFILLER_7_390 VGND VGND VPWR VPWR sky130_fd_sc_hd__fill_2
X_4465_ _4533_/A1 _4465_/A2 _4465_/B1 _4465_/B2 VGND VGND VPWR VPWR _5523_/D sky130_fd_sc_hd__a22o_2
Xfanout815 _3110_/S VGND VGND VPWR VPWR _2627_/S sky130_fd_sc_hd__clkbuf_2
X_4396_ _5043_/A1 _4396_/A2 _4396_/B1 _4396_/B2 VGND VGND VPWR VPWR _5459_/D sky130_fd_sc_hd__a22o_2
X_3416_ _3404_/A _3415_/X _3832_/C1 VGND VGND VPWR VPWR _3416_/X sky130_fd_sc_hd__o21a_2
XTAP_TAPCELL_ROW_5_305 VGND VPWR sky130_fd_sc_hd__tapvpwrvgnd_1
Xfanout848 _3217_/S VGND VGND VPWR VPWR _2863_/S sky130_fd_sc_hd__dlymetal6s2s_1
Xfanout837 _3204_/S VGND VGND VPWR VPWR _3188_/S sky130_fd_sc_hd__dlygate4sd1_1
X_3347_ _3347_/A _3347_/B VGND VGND VPWR VPWR _3347_/X sky130_fd_sc_hd__or2_2
XFILLER_112_494 VGND VGND VPWR VPWR sky130_fd_sc_hd__decap_3
Xload_slew271 _4219_/B1 VGND VGND VPWR VPWR _4227_/B1 sky130_fd_sc_hd__buf_2
X_6066_ _6066_/CLK _6066_/D VGND VGND VPWR VPWR _6066_/Q sky130_fd_sc_hd__dfxtp_2
X_5017_ _5017_/A1 _5043_/A2 wire115/X _5017_/B2 VGND VGND VPWR VPWR _6041_/D sky130_fd_sc_hd__a22o_2
X_3278_ _3347_/A _3276_/X _3277_/X _3632_/A VGND VGND VPWR VPWR _3278_/X sky130_fd_sc_hd__o22a_2
XFILLER_85_389 VGND VGND VPWR VPWR sky130_fd_sc_hd__decap_3
XFILLER_26_25 VGND VGND VPWR VPWR sky130_fd_sc_hd__decap_3
XFILLER_66_592 VGND VGND VPWR VPWR sky130_fd_sc_hd__decap_3
XFILLER_26_58 VGND VGND VPWR VPWR sky130_fd_sc_hd__decap_3
XTAP_TAPCELL_ROW_101_1457 VGND VPWR sky130_fd_sc_hd__tapvpwrvgnd_1
X_5919_ _5932_/CLK _5919_/D VGND VGND VPWR VPWR _5919_/Q sky130_fd_sc_hd__dfxtp_2
XFILLER_21_161 VGND VGND VPWR VPWR sky130_fd_sc_hd__decap_3
XFILLER_22_673 VGND VGND VPWR VPWR sky130_fd_sc_hd__decap_3
XFILLER_42_46 VGND VGND VPWR VPWR sky130_fd_sc_hd__decap_3
XFILLER_107_222 VGND VGND VPWR VPWR sky130_fd_sc_hd__fill_2
XFILLER_107_244 VGND VGND VPWR VPWR sky130_fd_sc_hd__decap_3
XFILLER_101_3 VGND VGND VPWR VPWR sky130_fd_sc_hd__decap_3
XFILLER_1_522 VGND VGND VPWR VPWR sky130_fd_sc_hd__decap_3
XFILLER_3_18 VGND VGND VPWR VPWR sky130_fd_sc_hd__decap_3
XFILLER_107_72 VGND VGND VPWR VPWR sky130_fd_sc_hd__decap_3
XFILLER_89_662 VGND VGND VPWR VPWR sky130_fd_sc_hd__fill_1
XFILLER_1_599 VGND VGND VPWR VPWR sky130_fd_sc_hd__decap_3
XFILLER_67_54 VGND VGND VPWR VPWR sky130_fd_sc_hd__fill_2
XTAP_TAPCELL_ROW_112_1597 VGND VPWR sky130_fd_sc_hd__tapvpwrvgnd_1
XFILLER_49_559 VGND VGND VPWR VPWR sky130_fd_sc_hd__fill_1
Xload_slew1010 _3433_/A VGND VGND VPWR VPWR _3837_/A sky130_fd_sc_hd__buf_4
XFILLER_29_250 VGND VGND VPWR VPWR sky130_fd_sc_hd__decap_3
XFILLER_29_261 VGND VGND VPWR VPWR sky130_fd_sc_hd__decap_3
Xhold1580 _6032_/Q VGND VGND VPWR VPWR _5006_/B2 sky130_fd_sc_hd__dlygate4sd3_1
Xload_slew1032 _3826_/S1 VGND VGND VPWR VPWR _3717_/S1 sky130_fd_sc_hd__clkbuf_2
XFILLER_17_423 VGND VGND VPWR VPWR sky130_fd_sc_hd__decap_3
XFILLER_44_220 VGND VGND VPWR VPWR sky130_fd_sc_hd__decap_3
XFILLER_57_592 VGND VGND VPWR VPWR sky130_fd_sc_hd__fill_2
XFILLER_91_337 VGND VGND VPWR VPWR sky130_fd_sc_hd__decap_3
Xhold1591 _6041_/Q VGND VGND VPWR VPWR _5017_/B2 sky130_fd_sc_hd__dlygate4sd3_1
XFILLER_17_489 VGND VGND VPWR VPWR sky130_fd_sc_hd__decap_3
XTAP_TAPCELL_ROW_67_1054 VGND VPWR sky130_fd_sc_hd__tapvpwrvgnd_1
Xload_slew1087 _3707_/S VGND VGND VPWR VPWR _3822_/S sky130_fd_sc_hd__buf_4
XFILLER_32_437 VGND VGND VPWR VPWR sky130_fd_sc_hd__decap_3
XFILLER_72_595 VGND VGND VPWR VPWR sky130_fd_sc_hd__decap_3
XTAP_TAPCELL_ROW_80_1210 VGND VPWR sky130_fd_sc_hd__tapvpwrvgnd_1
XFILLER_13_651 VGND VGND VPWR VPWR sky130_fd_sc_hd__fill_2
XFILLER_12_150 VGND VGND VPWR VPWR sky130_fd_sc_hd__decap_3
XFILLER_13_673 VGND VGND VPWR VPWR sky130_fd_sc_hd__decap_3
XTAP_TAPCELL_ROW_30_605 VGND VPWR sky130_fd_sc_hd__tapvpwrvgnd_1
XTAP_TAPCELL_ROW_10_373 VGND VPWR sky130_fd_sc_hd__tapvpwrvgnd_1
X_2580_ _5691_/Q _5659_/Q _5627_/Q _5595_/Q _2582_/S wire760/X VGND VGND VPWR VPWR
+ _2580_/X sky130_fd_sc_hd__mux4_2
XTAP_TAPCELL_ROW_78_1183 VGND VPWR sky130_fd_sc_hd__tapvpwrvgnd_1
XFILLER_113_225 VGND VGND VPWR VPWR sky130_fd_sc_hd__fill_1
X_4250_ _4830_/A1 _4263_/A2 _4250_/B1 _4250_/B2 VGND VGND VPWR VPWR _5322_/D sky130_fd_sc_hd__a22o_2
XFILLER_101_409 VGND VGND VPWR VPWR sky130_fd_sc_hd__fill_1
X_4181_ _4695_/A1 wire500/X wire281/X _4181_/B2 VGND VGND VPWR VPWR _5258_/D sky130_fd_sc_hd__a22o_2
X_3201_ wire651/X _3199_/X _3200_/X wire685/X VGND VGND VPWR VPWR _3201_/X sky130_fd_sc_hd__o22a_2
XFILLER_95_632 VGND VGND VPWR VPWR sky130_fd_sc_hd__decap_3
X_3132_ _5523_/Q _5491_/Q _3133_/S VGND VGND VPWR VPWR _3132_/X sky130_fd_sc_hd__mux2_1
XFILLER_82_326 VGND VGND VPWR VPWR sky130_fd_sc_hd__fill_2
XFILLER_95_687 VGND VGND VPWR VPWR sky130_fd_sc_hd__fill_1
XTAP_TAPCELL_ROW_38_705 VGND VPWR sky130_fd_sc_hd__tapvpwrvgnd_1
X_3063_ _5520_/Q _5488_/Q _3070_/S VGND VGND VPWR VPWR _3063_/X sky130_fd_sc_hd__mux2_1
XFILLER_48_592 VGND VGND VPWR VPWR sky130_fd_sc_hd__decap_3
XFILLER_82_359 VGND VGND VPWR VPWR sky130_fd_sc_hd__decap_3
XFILLER_94_197 VGND VGND VPWR VPWR sky130_fd_sc_hd__decap_3
XTAP_TAPCELL_ROW_18_462 VGND VPWR sky130_fd_sc_hd__tapvpwrvgnd_1
X_3965_ _5029_/A1 _3982_/A2 _3982_/B1 _3965_/B2 VGND VGND VPWR VPWR _5061_/D sky130_fd_sc_hd__a22o_2
X_5704_ _5704_/CLK _5704_/D VGND VGND VPWR VPWR _5704_/Q sky130_fd_sc_hd__dfxtp_2
X_3896_ _3896_/A1 _3894_/X _3895_/X _3896_/B2 VGND VGND VPWR VPWR _3896_/X sky130_fd_sc_hd__o22a_2
X_2916_ _3185_/B2 _2910_/X _2915_/X _2700_/A VGND VGND VPWR VPWR _2916_/X sky130_fd_sc_hd__a22o_2
X_5635_ _6048_/CLK _5635_/D VGND VGND VPWR VPWR _5635_/Q sky130_fd_sc_hd__dfxtp_2
X_2847_ wire643/X _2845_/X _2846_/X _2990_/A1 VGND VGND VPWR VPWR _2847_/X sky130_fd_sc_hd__o22a_2
X_5566_ _5885_/CLK _5566_/D VGND VGND VPWR VPWR _5566_/Q sky130_fd_sc_hd__dfxtp_2
X_2778_ _2611_/A _2775_/X _2777_/X wire659/X VGND VGND VPWR VPWR _2778_/X sky130_fd_sc_hd__a22o_2
XFILLER_2_319 VGND VGND VPWR VPWR sky130_fd_sc_hd__decap_3
X_5497_ _5513_/CLK _5497_/D VGND VGND VPWR VPWR _5497_/Q sky130_fd_sc_hd__dfxtp_2
X_4517_ _4517_/A1 _4535_/A2 _4528_/B1 _4517_/B2 VGND VGND VPWR VPWR _5571_/D sky130_fd_sc_hd__a22o_2
X_4448_ _4822_/A1 _4459_/A2 _4459_/B1 _4448_/B2 VGND VGND VPWR VPWR _5506_/D sky130_fd_sc_hd__a22o_2
Xfanout623 _3233_/Y VGND VGND VPWR VPWR _3709_/A1 sky130_fd_sc_hd__clkdlybuf4s25_1
Xfanout612 _3842_/A1 VGND VGND VPWR VPWR _3914_/A sky130_fd_sc_hd__clkbuf_2
Xfanout601 _3238_/X VGND VGND VPWR VPWR _3927_/B2 sky130_fd_sc_hd__clkdlybuf4s25_1
Xfanout656 _2503_/Y VGND VGND VPWR VPWR fanout656/X sky130_fd_sc_hd__dlymetal6s2s_1
Xfanout634 _3196_/C1 VGND VGND VPWR VPWR _3179_/A1 sky130_fd_sc_hd__dlymetal6s4s_1
X_4379_ _4992_/A1 _4398_/A2 _4398_/B1 _4379_/B2 VGND VGND VPWR VPWR _5442_/D sky130_fd_sc_hd__a22o_2
XFILLER_100_486 VGND VGND VPWR VPWR sky130_fd_sc_hd__decap_3
XFILLER_46_529 VGND VGND VPWR VPWR sky130_fd_sc_hd__decap_3
XFILLER_86_687 VGND VGND VPWR VPWR sky130_fd_sc_hd__fill_1
X_6049_ _6049_/CLK _6049_/D VGND VGND VPWR VPWR _6049_/Q sky130_fd_sc_hd__dfxtp_2
XFILLER_26_231 VGND VGND VPWR VPWR sky130_fd_sc_hd__decap_3
XFILLER_26_253 VGND VGND VPWR VPWR sky130_fd_sc_hd__decap_3
XFILLER_26_264 VGND VGND VPWR VPWR sky130_fd_sc_hd__decap_3
XFILLER_41_289 VGND VGND VPWR VPWR sky130_fd_sc_hd__decap_3
XFILLER_53_89 VGND VGND VPWR VPWR sky130_fd_sc_hd__fill_1
XFILLER_10_676 VGND VGND VPWR VPWR sky130_fd_sc_hd__decap_3
XFILLER_108_531 VGND VGND VPWR VPWR sky130_fd_sc_hd__fill_1
XFILLER_6_669 VGND VGND VPWR VPWR sky130_fd_sc_hd__decap_3
XFILLER_108_564 VGND VGND VPWR VPWR sky130_fd_sc_hd__decap_3
XTAP_TAPCELL_ROW_114_1615 VGND VPWR sky130_fd_sc_hd__tapvpwrvgnd_1
XFILLER_108_597 VGND VGND VPWR VPWR sky130_fd_sc_hd__decap_3
XFILLER_68_109 VGND VGND VPWR VPWR sky130_fd_sc_hd__decap_3
XFILLER_78_53 VGND VGND VPWR VPWR sky130_fd_sc_hd__decap_3
XFILLER_96_418 VGND VGND VPWR VPWR sky130_fd_sc_hd__fill_2
XFILLER_110_217 VGND VGND VPWR VPWR sky130_fd_sc_hd__decap_3
XFILLER_1_374 VGND VGND VPWR VPWR sky130_fd_sc_hd__fill_1
XFILLER_76_197 VGND VGND VPWR VPWR sky130_fd_sc_hd__fill_2
XFILLER_17_297 VGND VGND VPWR VPWR sky130_fd_sc_hd__decap_3
XTAP_TAPCELL_ROW_15_432 VGND VPWR sky130_fd_sc_hd__tapvpwrvgnd_1
XFILLER_60_598 VGND VGND VPWR VPWR sky130_fd_sc_hd__decap_3
XTAP_TAPCELL_ROW_43_763 VGND VPWR sky130_fd_sc_hd__tapvpwrvgnd_1
X_3750_ _5583_/Q _5551_/Q _3762_/S VGND VGND VPWR VPWR _3750_/X sky130_fd_sc_hd__mux2_1
XFILLER_9_452 VGND VGND VPWR VPWR sky130_fd_sc_hd__decap_3
X_2701_ _5376_/Q _5344_/Q _5312_/Q _5280_/Q _2772_/S _3164_/S1 VGND VGND VPWR VPWR
+ _2701_/X sky130_fd_sc_hd__mux4_2
XFILLER_9_485 VGND VGND VPWR VPWR sky130_fd_sc_hd__decap_3
X_3681_ _5932_/Q _5900_/Q _5868_/Q _5772_/Q _3683_/S _3799_/S1 VGND VGND VPWR VPWR
+ _3681_/X sky130_fd_sc_hd__mux4_2
XFILLER_64_3 VGND VGND VPWR VPWR sky130_fd_sc_hd__decap_3
X_5420_ _6049_/CLK _5420_/D VGND VGND VPWR VPWR _5420_/Q sky130_fd_sc_hd__dfxtp_2
X_2632_ _6045_/Q _5949_/Q _3114_/S VGND VGND VPWR VPWR _2632_/X sky130_fd_sc_hd__mux2_1
X_5351_ _5832_/CLK _5351_/D VGND VGND VPWR VPWR _5351_/Q sky130_fd_sc_hd__dfxtp_2
X_2563_ _5242_/Q _5210_/Q _2564_/S VGND VGND VPWR VPWR _2563_/X sky130_fd_sc_hd__mux2_1
X_5282_ _6046_/CLK _5282_/D VGND VGND VPWR VPWR _5282_/Q sky130_fd_sc_hd__dfxtp_2
X_4302_ _4645_/A1 _4316_/A2 wire248/A _4302_/B2 VGND VGND VPWR VPWR _5370_/D sky130_fd_sc_hd__a22o_2
XFILLER_4_50 VGND VGND VPWR VPWR sky130_fd_sc_hd__decap_3
XFILLER_99_267 VGND VGND VPWR VPWR sky130_fd_sc_hd__decap_3
X_4233_ _4507_/A1 wire482/X wire262/X _4233_/B2 VGND VGND VPWR VPWR _5305_/D sky130_fd_sc_hd__a22o_2
X_2494_ _3234_/B VGND VGND VPWR VPWR _2494_/Y sky130_fd_sc_hd__inv_2
XFILLER_101_206 VGND VGND VPWR VPWR sky130_fd_sc_hd__fill_1
XFILLER_114_589 VGND VGND VPWR VPWR sky130_fd_sc_hd__decap_3
XFILLER_114_18 VGND VGND VPWR VPWR sky130_fd_sc_hd__decap_3
XFILLER_114_29 VGND VGND VPWR VPWR sky130_fd_sc_hd__decap_3
XFILLER_68_643 VGND VGND VPWR VPWR sky130_fd_sc_hd__fill_1
X_4164_ _4983_/A1 _4192_/A2 _4180_/B1 _4164_/B2 VGND VGND VPWR VPWR _5241_/D sky130_fd_sc_hd__a22o_2
XFILLER_28_529 VGND VGND VPWR VPWR sky130_fd_sc_hd__decap_3
XFILLER_68_687 VGND VGND VPWR VPWR sky130_fd_sc_hd__fill_1
X_4095_ _4506_/A1 _4120_/A2 _4123_/B1 _4095_/B2 VGND VGND VPWR VPWR _5176_/D sky130_fd_sc_hd__a22o_2
X_3115_ _5522_/Q _5490_/Q _3115_/S VGND VGND VPWR VPWR _3115_/X sky130_fd_sc_hd__mux2_1
XFILLER_55_337 VGND VGND VPWR VPWR sky130_fd_sc_hd__fill_2
XFILLER_83_635 VGND VGND VPWR VPWR sky130_fd_sc_hd__decap_3
X_3046_ _5519_/Q _5487_/Q _3145_/S VGND VGND VPWR VPWR _3046_/X sky130_fd_sc_hd__mux2_1
XFILLER_70_307 VGND VGND VPWR VPWR sky130_fd_sc_hd__fill_1
XFILLER_23_223 VGND VGND VPWR VPWR sky130_fd_sc_hd__fill_1
XFILLER_36_584 VGND VGND VPWR VPWR sky130_fd_sc_hd__decap_3
XFILLER_36_595 VGND VGND VPWR VPWR sky130_fd_sc_hd__decap_3
XFILLER_11_418 VGND VGND VPWR VPWR sky130_fd_sc_hd__decap_3
XFILLER_23_267 VGND VGND VPWR VPWR sky130_fd_sc_hd__decap_3
X_4997_ _4997_/A1 _5013_/A2 _5013_/B1 _4997_/B2 VGND VGND VPWR VPWR _6023_/D sky130_fd_sc_hd__a22o_2
X_3948_ input3/X _3948_/B _3984_/B VGND VGND VPWR VPWR _4401_/B sky130_fd_sc_hd__or3b_2
XFILLER_109_328 VGND VGND VPWR VPWR sky130_fd_sc_hd__fill_1
X_3879_ _5589_/Q _5557_/Q _3880_/S VGND VGND VPWR VPWR _3879_/X sky130_fd_sc_hd__mux2_1
X_5618_ _6013_/CLK _5618_/D VGND VGND VPWR VPWR _5618_/Q sky130_fd_sc_hd__dfxtp_2
XFILLER_3_617 VGND VGND VPWR VPWR sky130_fd_sc_hd__decap_3
X_5549_ _6045_/CLK _5549_/D VGND VGND VPWR VPWR _5549_/Q sky130_fd_sc_hd__dfxtp_2
XFILLER_105_556 VGND VGND VPWR VPWR sky130_fd_sc_hd__decap_3
Xfanout420 _4539_/Y VGND VGND VPWR VPWR wire421/A sky130_fd_sc_hd__clkdlybuf4s25_1
Xfanout464 _4332_/Y VGND VGND VPWR VPWR _4333_/B sky130_fd_sc_hd__clkdlybuf4s25_1
Xfanout453 _4367_/Y VGND VGND VPWR VPWR _4380_/A2 sky130_fd_sc_hd__clkdlybuf4s25_1
XFILLER_100_250 VGND VGND VPWR VPWR sky130_fd_sc_hd__fill_2
Xfanout497 wire500/A VGND VGND VPWR VPWR _4188_/A2 sky130_fd_sc_hd__clkdlybuf4s25_1
XFILLER_100_272 VGND VGND VPWR VPWR sky130_fd_sc_hd__decap_3
XFILLER_58_197 VGND VGND VPWR VPWR sky130_fd_sc_hd__decap_3
XFILLER_74_635 VGND VGND VPWR VPWR sky130_fd_sc_hd__decap_3
XPHY_EDGE_ROW_100_Left_216 VGND VGND VPWR VPWR sky130_fd_sc_hd__decap_3
XFILLER_27_540 VGND VGND VPWR VPWR sky130_fd_sc_hd__decap_3
XFILLER_64_44 VGND VGND VPWR VPWR sky130_fd_sc_hd__decap_3
XFILLER_73_156 VGND VGND VPWR VPWR sky130_fd_sc_hd__fill_2
XTAP_TAPCELL_ROW_64_1013 VGND VPWR sky130_fd_sc_hd__tapvpwrvgnd_1
XFILLER_42_565 VGND VGND VPWR VPWR sky130_fd_sc_hd__fill_2
XFILLER_14_289 VGND VGND VPWR VPWR sky130_fd_sc_hd__decap_3
XFILLER_42_598 VGND VGND VPWR VPWR sky130_fd_sc_hd__decap_3
XFILLER_9_39 VGND VGND VPWR VPWR sky130_fd_sc_hd__decap_3
XFILLER_80_54 VGND VGND VPWR VPWR sky130_fd_sc_hd__decap_3
XTAP_TAPCELL_ROW_40_733 VGND VPWR sky130_fd_sc_hd__tapvpwrvgnd_1
XFILLER_10_451 VGND VGND VPWR VPWR sky130_fd_sc_hd__fill_1
XFILLER_6_400 VGND VGND VPWR VPWR sky130_fd_sc_hd__decap_3
XFILLER_13_92 VGND VGND VPWR VPWR sky130_fd_sc_hd__decap_3
XFILLER_115_309 VGND VGND VPWR VPWR sky130_fd_sc_hd__decap_3
XFILLER_6_477 VGND VGND VPWR VPWR sky130_fd_sc_hd__decap_3
XTAP_TAPCELL_ROW_20_490 VGND VPWR sky130_fd_sc_hd__tapvpwrvgnd_1
XFILLER_108_383 VGND VGND VPWR VPWR sky130_fd_sc_hd__decap_3
XFILLER_6_488 VGND VGND VPWR VPWR sky130_fd_sc_hd__fill_1
XFILLER_89_63 VGND VGND VPWR VPWR sky130_fd_sc_hd__fill_1
XTAP_TAPCELL_ROW_75_1153 VGND VPWR sky130_fd_sc_hd__tapvpwrvgnd_1
Xload_slew804 _2589_/S VGND VGND VPWR VPWR _2582_/S sky130_fd_sc_hd__buf_4
XFILLER_2_672 VGND VGND VPWR VPWR sky130_fd_sc_hd__decap_3
Xload_slew826 _3070_/S VGND VGND VPWR VPWR _2510_/S sky130_fd_sc_hd__clkbuf_4
XFILLER_29_6 VGND VGND VPWR VPWR sky130_fd_sc_hd__decap_3
Xload_slew859 _2678_/S VGND VGND VPWR VPWR _2975_/S sky130_fd_sc_hd__clkbuf_4
XFILLER_37_337 VGND VGND VPWR VPWR sky130_fd_sc_hd__fill_1
XFILLER_92_421 VGND VGND VPWR VPWR sky130_fd_sc_hd__fill_2
XTAP_TAPCELL_ROW_48_822 VGND VPWR sky130_fd_sc_hd__tapvpwrvgnd_1
XFILLER_64_156 VGND VGND VPWR VPWR sky130_fd_sc_hd__decap_3
XFILLER_65_668 VGND VGND VPWR VPWR sky130_fd_sc_hd__decap_3
XFILLER_18_595 VGND VGND VPWR VPWR sky130_fd_sc_hd__fill_1
XFILLER_64_189 VGND VGND VPWR VPWR sky130_fd_sc_hd__decap_3
X_4920_ _5022_/A1 _4943_/A2 _4943_/B1 _4920_/B2 VGND VGND VPWR VPWR _5950_/D sky130_fd_sc_hd__a22o_2
XTAP_TAPCELL_ROW_86_1282 VGND VPWR sky130_fd_sc_hd__tapvpwrvgnd_1
XTAP_TAPCELL_ROW_28_590 VGND VPWR sky130_fd_sc_hd__tapvpwrvgnd_1
X_4851_ _4885_/A1 _4868_/A2 wire146/A _4851_/B2 VGND VGND VPWR VPWR _5885_/D sky130_fd_sc_hd__a22o_2
X_3802_ _5425_/Q _5073_/Q _3802_/S VGND VGND VPWR VPWR _3802_/X sky130_fd_sc_hd__mux2_1
XFILLER_20_237 VGND VGND VPWR VPWR sky130_fd_sc_hd__decap_3
X_4782_ _4795_/A_N _4782_/B VGND VGND VPWR VPWR _5820_/D sky130_fd_sc_hd__and2b_2
XFILLER_20_259 VGND VGND VPWR VPWR sky130_fd_sc_hd__decap_3
X_3733_ _5198_/Q _5166_/Q _3733_/S VGND VGND VPWR VPWR _3733_/X sky130_fd_sc_hd__mux2_1
XFILLER_109_18 VGND VGND VPWR VPWR sky130_fd_sc_hd__decap_3
XFILLER_9_271 VGND VGND VPWR VPWR sky130_fd_sc_hd__fill_1
X_3664_ _5579_/Q _5547_/Q _3665_/S VGND VGND VPWR VPWR _3664_/X sky130_fd_sc_hd__mux2_1
XFILLER_106_309 VGND VGND VPWR VPWR sky130_fd_sc_hd__decap_3
Xclkload41 _5879_/CLK VGND VGND VPWR VPWR clkload41/Y sky130_fd_sc_hd__clkinv_2
Xclkload30 _5963_/CLK VGND VGND VPWR VPWR clkload30/Y sky130_fd_sc_hd__bufinv_16
X_5403_ _5659_/CLK _5403_/D VGND VGND VPWR VPWR _5403_/Q sky130_fd_sc_hd__dfxtp_2
X_2615_ _5500_/Q _5468_/Q _3133_/S VGND VGND VPWR VPWR _2615_/X sky130_fd_sc_hd__mux2_1
X_3595_ _5704_/Q _5672_/Q _5640_/Q _5608_/Q _3609_/S _3820_/S1 VGND VGND VPWR VPWR
+ _3595_/X sky130_fd_sc_hd__mux4_2
XFILLER_0_609 VGND VGND VPWR VPWR sky130_fd_sc_hd__decap_3
X_5334_ _5797_/CLK _5334_/D VGND VGND VPWR VPWR _5334_/Q sky130_fd_sc_hd__dfxtp_2
X_2546_ _6041_/Q _5945_/Q _2604_/S VGND VGND VPWR VPWR _2546_/X sky130_fd_sc_hd__mux2_1
XFILLER_102_515 VGND VGND VPWR VPWR sky130_fd_sc_hd__decap_3
X_5265_ _6033_/CLK _5265_/D VGND VGND VPWR VPWR _5265_/Q sky130_fd_sc_hd__dfxtp_2
X_5196_ _6055_/CLK _5196_/D VGND VGND VPWR VPWR _5196_/Q sky130_fd_sc_hd__dfxtp_2
X_4216_ _4830_/A1 _4229_/A2 _4216_/B1 _4216_/B2 VGND VGND VPWR VPWR _5290_/D sky130_fd_sc_hd__a22o_2
XFILLER_18_26 VGND VGND VPWR VPWR sky130_fd_sc_hd__fill_2
XFILLER_28_304 VGND VGND VPWR VPWR sky130_fd_sc_hd__decap_3
XFILLER_56_602 VGND VGND VPWR VPWR sky130_fd_sc_hd__decap_3
X_4147_ _4695_/A1 wire508/X wire290/X _4147_/B2 VGND VGND VPWR VPWR _5226_/D sky130_fd_sc_hd__a22o_2
XFILLER_110_592 VGND VGND VPWR VPWR sky130_fd_sc_hd__decap_3
XFILLER_28_348 VGND VGND VPWR VPWR sky130_fd_sc_hd__decap_3
XFILLER_55_123 VGND VGND VPWR VPWR sky130_fd_sc_hd__decap_3
X_4078_ _4695_/A1 wire524/X wire306/X _4078_/B2 VGND VGND VPWR VPWR _5162_/D sky130_fd_sc_hd__a22o_2
X_3029_ _2700_/A _3012_/X _3028_/X _3185_/A1 VGND VGND VPWR VPWR _3029_/X sky130_fd_sc_hd__a22o_2
XFILLER_11_237 VGND VGND VPWR VPWR sky130_fd_sc_hd__fill_1
XFILLER_50_24 VGND VGND VPWR VPWR sky130_fd_sc_hd__decap_3
Xwire139 wire139/A VGND VGND VPWR VPWR wire139/X sky130_fd_sc_hd__clkbuf_4
Xclkload2 clkload2/A VGND VGND VPWR VPWR clkload2/X sky130_fd_sc_hd__clkbuf_8
XFILLER_109_158 VGND VGND VPWR VPWR sky130_fd_sc_hd__fill_1
XFILLER_109_169 VGND VGND VPWR VPWR sky130_fd_sc_hd__decap_3
XFILLER_105_331 VGND VGND VPWR VPWR sky130_fd_sc_hd__decap_3
XFILLER_59_11 VGND VGND VPWR VPWR sky130_fd_sc_hd__decap_3
XFILLER_59_55 VGND VGND VPWR VPWR sky130_fd_sc_hd__fill_1
XFILLER_115_50 VGND VGND VPWR VPWR sky130_fd_sc_hd__decap_3
XFILLER_115_72 VGND VGND VPWR VPWR sky130_fd_sc_hd__decap_3
Xfanout272 _4229_/B1 VGND VGND VPWR VPWR _4216_/B1 sky130_fd_sc_hd__clkdlybuf4s25_1
Xfanout261 _4263_/B1 VGND VGND VPWR VPWR wire262/A sky130_fd_sc_hd__clkdlybuf4s25_1
XFILLER_101_570 VGND VGND VPWR VPWR sky130_fd_sc_hd__decap_3
XFILLER_115_94 VGND VGND VPWR VPWR sky130_fd_sc_hd__decap_3
XFILLER_19_337 VGND VGND VPWR VPWR sky130_fd_sc_hd__decap_3
XFILLER_74_421 VGND VGND VPWR VPWR sky130_fd_sc_hd__fill_2
XFILLER_75_43 VGND VGND VPWR VPWR sky130_fd_sc_hd__decap_3
XFILLER_86_270 VGND VGND VPWR VPWR sky130_fd_sc_hd__fill_1
XTAP_TAPCELL_ROW_70_1094 VGND VPWR sky130_fd_sc_hd__tapvpwrvgnd_1
XFILLER_46_134 VGND VGND VPWR VPWR sky130_fd_sc_hd__decap_3
XFILLER_47_668 VGND VGND VPWR VPWR sky130_fd_sc_hd__decap_3
XFILLER_62_616 VGND VGND VPWR VPWR sky130_fd_sc_hd__fill_2
XTAP_TAPCELL_ROW_109_1558 VGND VPWR sky130_fd_sc_hd__tapvpwrvgnd_1
XFILLER_62_638 VGND VGND VPWR VPWR sky130_fd_sc_hd__decap_3
XFILLER_98_9 VGND VGND VPWR VPWR sky130_fd_sc_hd__decap_3
XFILLER_42_395 VGND VGND VPWR VPWR sky130_fd_sc_hd__decap_3
XFILLER_91_86 VGND VGND VPWR VPWR sky130_fd_sc_hd__fill_1
XTAP_TAPCELL_ROW_53_880 VGND VPWR sky130_fd_sc_hd__tapvpwrvgnd_1
XTAP_TAPCELL_ROW_53_891 VGND VPWR sky130_fd_sc_hd__tapvpwrvgnd_1
Xwire651 wire651/A VGND VGND VPWR VPWR wire651/X sky130_fd_sc_hd__clkbuf_4
XFILLER_115_106 VGND VGND VPWR VPWR sky130_fd_sc_hd__decap_3
X_3380_ _5502_/Q _5470_/Q _3707_/S VGND VGND VPWR VPWR _3380_/X sky130_fd_sc_hd__mux2_1
XFILLER_111_301 VGND VGND VPWR VPWR sky130_fd_sc_hd__decap_3
Xload_slew645 _3004_/A1 VGND VGND VPWR VPWR _3105_/A1 sky130_fd_sc_hd__buf_4
X_5050_ _6010_/CLK _5050_/D VGND VGND VPWR VPWR _5050_/Q sky130_fd_sc_hd__dfxtp_2
XFILLER_111_389 VGND VGND VPWR VPWR sky130_fd_sc_hd__decap_3
XFILLER_27_3 VGND VGND VPWR VPWR sky130_fd_sc_hd__decap_3
Xhold1409 _5596_/Q VGND VGND VPWR VPWR _4545_/B2 sky130_fd_sc_hd__dlygate4sd3_1
Xload_slew689 _3222_/B2 VGND VGND VPWR VPWR _3218_/A1 sky130_fd_sc_hd__buf_4
Xload_slew678 _3004_/B2 VGND VGND VPWR VPWR _2990_/A1 sky130_fd_sc_hd__clkbuf_4
Xload_slew667 _2572_/A VGND VGND VPWR VPWR _2700_/A sky130_fd_sc_hd__buf_6
X_4001_ _4312_/A1 _4017_/A2 _4017_/B1 _4001_/B2 VGND VGND VPWR VPWR _5092_/D sky130_fd_sc_hd__a22o_2
XTAP_TAPCELL_ROW_88_1300 VGND VPWR sky130_fd_sc_hd__tapvpwrvgnd_1
XTAP_TAPCELL_ROW_88_1311 VGND VPWR sky130_fd_sc_hd__tapvpwrvgnd_1
XFILLER_1_51 VGND VGND VPWR VPWR sky130_fd_sc_hd__decap_3
XFILLER_37_156 VGND VGND VPWR VPWR sky130_fd_sc_hd__fill_2
XFILLER_80_402 VGND VGND VPWR VPWR sky130_fd_sc_hd__fill_1
XFILLER_80_424 VGND VGND VPWR VPWR sky130_fd_sc_hd__decap_3
XFILLER_92_262 VGND VGND VPWR VPWR sky130_fd_sc_hd__fill_2
X_5952_ _6048_/CLK _5952_/D VGND VGND VPWR VPWR _5952_/Q sky130_fd_sc_hd__dfxtp_2
XFILLER_80_457 VGND VGND VPWR VPWR sky130_fd_sc_hd__fill_2
XFILLER_92_295 VGND VGND VPWR VPWR sky130_fd_sc_hd__decap_3
X_4903_ _4903_/A1 _4910_/A2 _4908_/B1 _4903_/B2 VGND VGND VPWR VPWR _5935_/D sky130_fd_sc_hd__a22o_2
XFILLER_21_502 VGND VGND VPWR VPWR sky130_fd_sc_hd__fill_2
XFILLER_33_362 VGND VGND VPWR VPWR sky130_fd_sc_hd__fill_2
X_5883_ _6042_/CLK _5883_/D VGND VGND VPWR VPWR _5883_/Q sky130_fd_sc_hd__dfxtp_2
X_4834_ _5038_/A1 wire371/A wire153/X _4834_/B2 VGND VGND VPWR VPWR _5870_/D sky130_fd_sc_hd__a22o_2
XFILLER_21_557 VGND VGND VPWR VPWR sky130_fd_sc_hd__decap_3
X_4765_ _4899_/A1 _4776_/A2 _4776_/B1 _4765_/B2 VGND VGND VPWR VPWR _5803_/D sky130_fd_sc_hd__a22o_2
X_3716_ _3827_/S _3716_/B VGND VGND VPWR VPWR _3716_/X sky130_fd_sc_hd__or2_2
XTAP_TAPCELL_ROW_99_1440 VGND VPWR sky130_fd_sc_hd__tapvpwrvgnd_1
X_4696_ _4899_/A1 _4707_/A2 _4707_/B1 _4696_/B2 VGND VGND VPWR VPWR _5739_/D sky130_fd_sc_hd__a22o_2
XFILLER_106_139 VGND VGND VPWR VPWR sky130_fd_sc_hd__fill_1
XFILLER_20_27 VGND VGND VPWR VPWR sky130_fd_sc_hd__fill_1
X_3647_ _3832_/C1 _3643_/X _3646_/X _3641_/X VGND VGND VPWR VPWR _3647_/X sky130_fd_sc_hd__a31o_2
XFILLER_115_651 VGND VGND VPWR VPWR sky130_fd_sc_hd__decap_3
X_3578_ _5127_/Q _5095_/Q _6023_/Q _5991_/Q _3580_/S _3929_/S1 VGND VGND VPWR VPWR
+ _3578_/X sky130_fd_sc_hd__mux4_2
XFILLER_115_673 VGND VGND VPWR VPWR sky130_fd_sc_hd__decap_3
X_5317_ _6000_/CLK _5317_/D VGND VGND VPWR VPWR _5317_/Q sky130_fd_sc_hd__dfxtp_2
X_2529_ _5497_/Q _5465_/Q _2529_/S VGND VGND VPWR VPWR _2529_/X sky130_fd_sc_hd__mux2_1
Xhold1910 _5484_/Q VGND VGND VPWR VPWR _4424_/B2 sky130_fd_sc_hd__dlygate4sd3_1
X_5248_ _6056_/CLK _5248_/D VGND VGND VPWR VPWR _5248_/Q sky130_fd_sc_hd__dfxtp_2
XFILLER_28_112 VGND VGND VPWR VPWR sky130_fd_sc_hd__decap_3
XFILLER_68_270 VGND VGND VPWR VPWR sky130_fd_sc_hd__fill_1
Xhold1921 _5805_/Q VGND VGND VPWR VPWR _4767_/B2 sky130_fd_sc_hd__dlygate4sd3_1
Xhold1932 _5130_/Q VGND VGND VPWR VPWR _4042_/B2 sky130_fd_sc_hd__dlygate4sd3_1
Xhold1943 _5175_/Q VGND VGND VPWR VPWR _4091_/B2 sky130_fd_sc_hd__dlygate4sd3_1
Xhold1954 _5944_/Q VGND VGND VPWR VPWR _4914_/B2 sky130_fd_sc_hd__dlygate4sd3_1
X_5179_ _5938_/CLK _5179_/D VGND VGND VPWR VPWR _5179_/Q sky130_fd_sc_hd__dfxtp_2
XFILLER_29_679 VGND VGND VPWR VPWR sky130_fd_sc_hd__fill_1
Xhold1965 _5725_/Q VGND VGND VPWR VPWR _4682_/B2 sky130_fd_sc_hd__dlygate4sd3_1
Xhold1976 _5374_/Q VGND VGND VPWR VPWR _4306_/B2 sky130_fd_sc_hd__dlygate4sd3_1
Xhold1987 _5378_/Q VGND VGND VPWR VPWR _4310_/B2 sky130_fd_sc_hd__dlygate4sd3_1
XTAP_TAPCELL_ROW_3_288 VGND VPWR sky130_fd_sc_hd__tapvpwrvgnd_1
Xhold1998 _5704_/Q VGND VGND VPWR VPWR _4659_/B2 sky130_fd_sc_hd__dlygate4sd3_1
XFILLER_45_57 VGND VGND VPWR VPWR sky130_fd_sc_hd__fill_2
XFILLER_12_502 VGND VGND VPWR VPWR sky130_fd_sc_hd__decap_3
XFILLER_24_362 VGND VGND VPWR VPWR sky130_fd_sc_hd__fill_2
XTAP_TAPCELL_ROW_104_1499 VGND VPWR sky130_fd_sc_hd__tapvpwrvgnd_1
XTAP_TAPCELL_ROW_50_850 VGND VPWR sky130_fd_sc_hd__tapvpwrvgnd_1
XFILLER_6_18 VGND VGND VPWR VPWR sky130_fd_sc_hd__decap_3
XFILLER_6_29 VGND VGND VPWR VPWR sky130_fd_sc_hd__decap_3
XFILLER_106_651 VGND VGND VPWR VPWR sky130_fd_sc_hd__decap_3
XFILLER_3_222 VGND VGND VPWR VPWR sky130_fd_sc_hd__fill_2
XFILLER_105_161 VGND VGND VPWR VPWR sky130_fd_sc_hd__decap_3
XFILLER_106_684 VGND VGND VPWR VPWR sky130_fd_sc_hd__decap_3
XFILLER_79_502 VGND VGND VPWR VPWR sky130_fd_sc_hd__fill_2
XTAP_TAPCELL_ROW_72_1112 VGND VPWR sky130_fd_sc_hd__tapvpwrvgnd_1
XFILLER_10_93 VGND VGND VPWR VPWR sky130_fd_sc_hd__decap_3
XFILLER_79_535 VGND VGND VPWR VPWR sky130_fd_sc_hd__decap_3
Xfanout1001 wire1003/A VGND VGND VPWR VPWR _5015_/A sky130_fd_sc_hd__clkdlybuf4s25_1
XFILLER_79_579 VGND VGND VPWR VPWR sky130_fd_sc_hd__decap_3
Xfanout1023 _3878_/S1 VGND VGND VPWR VPWR _3275_/S1 sky130_fd_sc_hd__clkdlybuf4s25_1
XFILLER_13_9 VGND VGND VPWR VPWR sky130_fd_sc_hd__decap_3
XFILLER_87_590 VGND VGND VPWR VPWR sky130_fd_sc_hd__fill_2
Xfanout1078 _3326_/S VGND VGND VPWR VPWR _3317_/S sky130_fd_sc_hd__clkbuf_2
Xfanout1067 _3743_/S VGND VGND VPWR VPWR _3727_/S sky130_fd_sc_hd__dlymetal6s4s_1
XTAP_TAPCELL_ROW_58_950 VGND VPWR sky130_fd_sc_hd__tapvpwrvgnd_1
XFILLER_19_167 VGND VGND VPWR VPWR sky130_fd_sc_hd__fill_1
XFILLER_34_104 VGND VGND VPWR VPWR sky130_fd_sc_hd__decap_3
XFILLER_35_638 VGND VGND VPWR VPWR sky130_fd_sc_hd__decap_3
XFILLER_15_340 VGND VGND VPWR VPWR sky130_fd_sc_hd__decap_3
XTAP_TAPCELL_ROW_83_1241 VGND VPWR sky130_fd_sc_hd__tapvpwrvgnd_1
XFILLER_30_321 VGND VGND VPWR VPWR sky130_fd_sc_hd__decap_3
XFILLER_35_90 VGND VGND VPWR VPWR sky130_fd_sc_hd__decap_3
XFILLER_96_6 VGND VGND VPWR VPWR sky130_fd_sc_hd__decap_3
X_2880_ wire641/A _2878_/X _2879_/X wire676/A VGND VGND VPWR VPWR _2880_/X sky130_fd_sc_hd__o22a_2
XFILLER_7_550 VGND VGND VPWR VPWR sky130_fd_sc_hd__decap_3
X_4550_ _5025_/A1 _4566_/A2 _4566_/B1 _4550_/B2 VGND VGND VPWR VPWR _5601_/D sky130_fd_sc_hd__a22o_2
XFILLER_7_561 VGND VGND VPWR VPWR sky130_fd_sc_hd__decap_3
X_4481_ _4515_/A1 wire437/X _4502_/B1 _4481_/B2 VGND VGND VPWR VPWR _5537_/D sky130_fd_sc_hd__a22o_2
X_3501_ _5795_/Q _5731_/Q _3501_/S VGND VGND VPWR VPWR _3501_/X sky130_fd_sc_hd__mux2_1
X_3432_ _5824_/Q _5440_/Q _6048_/Q _5952_/Q _3499_/S0 _3615_/S1 VGND VGND VPWR VPWR
+ _3433_/B sky130_fd_sc_hd__mux4_2
XFILLER_112_610 VGND VGND VPWR VPWR sky130_fd_sc_hd__decap_3
X_3363_ _5181_/Q _5149_/Q _3363_/S VGND VGND VPWR VPWR _3363_/X sky130_fd_sc_hd__mux2_1
XTAP_TAPCELL_ROW_94_1381 VGND VPWR sky130_fd_sc_hd__tapvpwrvgnd_1
XFILLER_112_643 VGND VGND VPWR VPWR sky130_fd_sc_hd__fill_1
XFILLER_112_654 VGND VGND VPWR VPWR sky130_fd_sc_hd__decap_3
X_5102_ _6030_/CLK _5102_/D VGND VGND VPWR VPWR _5102_/Q sky130_fd_sc_hd__dfxtp_2
XFILLER_112_687 VGND VGND VPWR VPWR sky130_fd_sc_hd__fill_1
XFILLER_85_516 VGND VGND VPWR VPWR sky130_fd_sc_hd__decap_3
Xhold1206 _5407_/Q VGND VGND VPWR VPWR _4341_/B2 sky130_fd_sc_hd__dlygate4sd3_1
Xload_slew442 _4467_/A2 VGND VGND VPWR VPWR _4459_/A2 sky130_fd_sc_hd__clkbuf_2
X_3294_ _3305_/A _3294_/B VGND VGND VPWR VPWR _3294_/X sky130_fd_sc_hd__or2_2
XFILLER_38_421 VGND VGND VPWR VPWR sky130_fd_sc_hd__fill_2
Xhold1217 _5980_/Q VGND VGND VPWR VPWR _4952_/B2 sky130_fd_sc_hd__dlygate4sd3_1
Xhold1228 _5775_/Q VGND VGND VPWR VPWR _4735_/B2 sky130_fd_sc_hd__dlygate4sd3_1
Xhold1239 _5187_/Q VGND VGND VPWR VPWR _4106_/B2 sky130_fd_sc_hd__dlygate4sd3_1
Xload_slew486 _4260_/A2 VGND VGND VPWR VPWR _4231_/B sky130_fd_sc_hd__buf_4
X_5033_ _5033_/A1 _5043_/A2 wire115/X _5033_/B2 VGND VGND VPWR VPWR _6057_/D sky130_fd_sc_hd__a22o_2
XFILLER_65_251 VGND VGND VPWR VPWR sky130_fd_sc_hd__decap_3
XTAP_TAPCELL_ROW_0_236 VGND VPWR sky130_fd_sc_hd__tapvpwrvgnd_1
XFILLER_25_148 VGND VGND VPWR VPWR sky130_fd_sc_hd__decap_3
XFILLER_53_457 VGND VGND VPWR VPWR sky130_fd_sc_hd__fill_1
XTAP_TAPCELL_ROW_0_247 VGND VPWR sky130_fd_sc_hd__tapvpwrvgnd_1
XTAP_TAPCELL_ROW_36_677 VGND VPWR sky130_fd_sc_hd__tapvpwrvgnd_1
X_5935_ _6063_/CLK _5935_/D VGND VGND VPWR VPWR _5935_/Q sky130_fd_sc_hd__dfxtp_2
XFILLER_15_49 VGND VGND VPWR VPWR sky130_fd_sc_hd__decap_3
X_5866_ _5866_/CLK _5866_/D VGND VGND VPWR VPWR _5866_/Q sky130_fd_sc_hd__dfxtp_2
Xclkbuf_leaf_60_clk clkbuf_4_14_0_clk/X VGND VGND VPWR VPWR _6017_/CLK sky130_fd_sc_hd__clkbuf_8
X_4817_ _4885_/A1 wire371/X wire153/A _4817_/B2 VGND VGND VPWR VPWR _5853_/D sky130_fd_sc_hd__a22o_2
X_5797_ _5797_/CLK _5797_/D VGND VGND VPWR VPWR _5797_/Q sky130_fd_sc_hd__dfxtp_2
X_4748_ _4984_/A1 _4762_/A2 _4762_/B1 _4748_/B2 VGND VGND VPWR VPWR _5786_/D sky130_fd_sc_hd__a22o_2
XFILLER_107_437 VGND VGND VPWR VPWR sky130_fd_sc_hd__decap_3
X_4679_ _4984_/A1 _4693_/A2 _4693_/B1 _4679_/B2 VGND VGND VPWR VPWR _5722_/D sky130_fd_sc_hd__a22o_2
XPHY_EDGE_ROW_1_Right_1 VGND VGND VPWR VPWR sky130_fd_sc_hd__decap_3
XFILLER_0_225 VGND VGND VPWR VPWR sky130_fd_sc_hd__decap_3
XFILLER_102_120 VGND VGND VPWR VPWR sky130_fd_sc_hd__decap_3
XFILLER_103_632 VGND VGND VPWR VPWR sky130_fd_sc_hd__decap_3
XFILLER_88_332 VGND VGND VPWR VPWR sky130_fd_sc_hd__decap_3
Xoutput59 _2939_/X VGND VGND VPWR VPWR rd1[18] sky130_fd_sc_hd__clkbuf_2
XTAP_TAPCELL_ROW_8_347 VGND VPWR sky130_fd_sc_hd__tapvpwrvgnd_1
XFILLER_103_676 VGND VGND VPWR VPWR sky130_fd_sc_hd__decap_3
XFILLER_102_197 VGND VGND VPWR VPWR sky130_fd_sc_hd__decap_3
XFILLER_56_56 VGND VGND VPWR VPWR sky130_fd_sc_hd__fill_2
Xhold1740 _5468_/Q VGND VGND VPWR VPWR _4408_/B2 sky130_fd_sc_hd__dlygate4sd3_1
Xhold1751 _5713_/Q VGND VGND VPWR VPWR _4668_/B2 sky130_fd_sc_hd__dlygate4sd3_1
Xhold1762 _5577_/Q VGND VGND VPWR VPWR _4523_/B2 sky130_fd_sc_hd__dlygate4sd3_1
XTAP_TAPCELL_ROW_106_1517 VGND VPWR sky130_fd_sc_hd__tapvpwrvgnd_1
Xhold1773 _5874_/Q VGND VGND VPWR VPWR _4838_/B2 sky130_fd_sc_hd__dlygate4sd3_1
Xhold1784 _5485_/Q VGND VGND VPWR VPWR _4425_/B2 sky130_fd_sc_hd__dlygate4sd3_1
Xhold1795 _5759_/Q VGND VGND VPWR VPWR _4719_/B2 sky130_fd_sc_hd__dlygate4sd3_1
XFILLER_17_649 VGND VGND VPWR VPWR sky130_fd_sc_hd__fill_1
XFILLER_112_62 VGND VGND VPWR VPWR sky130_fd_sc_hd__decap_3
XFILLER_44_468 VGND VGND VPWR VPWR sky130_fd_sc_hd__decap_3
XFILLER_25_682 VGND VGND VPWR VPWR sky130_fd_sc_hd__decap_3
XFILLER_12_354 VGND VGND VPWR VPWR sky130_fd_sc_hd__fill_2
XFILLER_40_641 VGND VGND VPWR VPWR sky130_fd_sc_hd__decap_3
XFILLER_72_88 VGND VGND VPWR VPWR sky130_fd_sc_hd__decap_3
Xclkbuf_leaf_51_clk clkload7/A VGND VGND VPWR VPWR _5802_/CLK sky130_fd_sc_hd__clkbuf_8
XFILLER_12_365 VGND VGND VPWR VPWR sky130_fd_sc_hd__decap_3
XFILLER_12_387 VGND VGND VPWR VPWR sky130_fd_sc_hd__fill_1
XFILLER_40_685 VGND VGND VPWR VPWR sky130_fd_sc_hd__decap_3
XFILLER_8_336 VGND VGND VPWR VPWR sky130_fd_sc_hd__decap_3
XFILLER_8_358 VGND VGND VPWR VPWR sky130_fd_sc_hd__decap_3
XFILLER_113_429 VGND VGND VPWR VPWR sky130_fd_sc_hd__fill_2
XFILLER_98_118 VGND VGND VPWR VPWR sky130_fd_sc_hd__decap_3
XFILLER_79_354 VGND VGND VPWR VPWR sky130_fd_sc_hd__fill_1
XFILLER_11_6 VGND VGND VPWR VPWR sky130_fd_sc_hd__decap_3
XFILLER_94_346 VGND VGND VPWR VPWR sky130_fd_sc_hd__decap_3
XFILLER_94_368 VGND VGND VPWR VPWR sky130_fd_sc_hd__fill_2
XFILLER_47_273 VGND VGND VPWR VPWR sky130_fd_sc_hd__fill_1
X_3981_ _4775_/A1 _3981_/A2 wire322/X _3981_/B2 VGND VGND VPWR VPWR _5077_/D sky130_fd_sc_hd__a22o_2
XFILLER_50_438 VGND VGND VPWR VPWR sky130_fd_sc_hd__fill_2
X_5720_ _5812_/CLK _5720_/D VGND VGND VPWR VPWR _5720_/Q sky130_fd_sc_hd__dfxtp_2
X_2932_ _3218_/B2 _2930_/X _2931_/X _3218_/A1 VGND VGND VPWR VPWR _2932_/X sky130_fd_sc_hd__o22a_2
XTAP_TAPCELL_ROW_33_647 VGND VPWR sky130_fd_sc_hd__tapvpwrvgnd_1
XTAP_TAPCELL_ROW_61_978 VGND VPWR sky130_fd_sc_hd__tapvpwrvgnd_1
Xclkbuf_leaf_42_clk clkbuf_4_14_0_clk/X VGND VGND VPWR VPWR _5866_/CLK sky130_fd_sc_hd__clkbuf_8
X_5651_ _5683_/CLK _5651_/D VGND VGND VPWR VPWR _5651_/Q sky130_fd_sc_hd__dfxtp_2
X_2863_ _5255_/Q _5223_/Q _2863_/S VGND VGND VPWR VPWR _2863_/X sky130_fd_sc_hd__mux2_1
XFILLER_30_184 VGND VGND VPWR VPWR sky130_fd_sc_hd__decap_3
X_5582_ _5838_/CLK _5582_/D VGND VGND VPWR VPWR _5582_/Q sky130_fd_sc_hd__dfxtp_2
X_4602_ _4773_/A1 wire414/X wire193/A _4602_/B2 VGND VGND VPWR VPWR _5651_/D sky130_fd_sc_hd__a22o_2
X_2794_ _5412_/Q _5060_/Q _2794_/S VGND VGND VPWR VPWR _2794_/X sky130_fd_sc_hd__mux2_1
X_4533_ _4533_/A1 _4535_/A2 _4535_/B1 _4533_/B2 VGND VGND VPWR VPWR _5587_/D sky130_fd_sc_hd__a22o_2
X_4464_ _4738_/A1 _4467_/A2 _4467_/B1 _4464_/B2 VGND VGND VPWR VPWR _5522_/D sky130_fd_sc_hd__a22o_2
XFILLER_98_630 VGND VGND VPWR VPWR sky130_fd_sc_hd__decap_3
Xfanout805 fanout820/X VGND VGND VPWR VPWR _2593_/S sky130_fd_sc_hd__clkbuf_4
X_4395_ _4738_/A1 _4398_/A2 _4398_/B1 _4395_/B2 VGND VGND VPWR VPWR _5458_/D sky130_fd_sc_hd__a22o_2
X_3415_ _5791_/Q _5727_/Q _3644_/S VGND VGND VPWR VPWR _3415_/X sky130_fd_sc_hd__mux2_1
XTAP_TAPCELL_ROW_5_306 VGND VPWR sky130_fd_sc_hd__tapvpwrvgnd_1
Xfanout827 _3194_/S VGND VGND VPWR VPWR _2885_/S sky130_fd_sc_hd__clkdlybuf4s25_1
X_3346_ _5244_/Q _5212_/Q _3622_/S VGND VGND VPWR VPWR _3347_/B sky130_fd_sc_hd__mux2_1
XFILLER_112_473 VGND VGND VPWR VPWR sky130_fd_sc_hd__decap_3
Xload_slew250 _4321_/B1 VGND VGND VPWR VPWR _4329_/B1 sky130_fd_sc_hd__buf_2
X_6065_ _6065_/CLK _6065_/D VGND VGND VPWR VPWR _6065_/Q sky130_fd_sc_hd__dfxtp_2
Xload_slew294 _4112_/B1 VGND VGND VPWR VPWR _4124_/B1 sky130_fd_sc_hd__buf_6
X_5016_ _5016_/A1 _5015_/B wire118/X _5016_/B2 VGND VGND VPWR VPWR _6040_/D sky130_fd_sc_hd__a22o_2
X_3277_ _5177_/Q _5145_/Q _3277_/S VGND VGND VPWR VPWR _3277_/X sky130_fd_sc_hd__mux2_1
XFILLER_14_619 VGND VGND VPWR VPWR sky130_fd_sc_hd__decap_3
XFILLER_41_449 VGND VGND VPWR VPWR sky130_fd_sc_hd__decap_3
X_5918_ _6046_/CLK _5918_/D VGND VGND VPWR VPWR _5918_/Q sky130_fd_sc_hd__dfxtp_2
XFILLER_22_630 VGND VGND VPWR VPWR sky130_fd_sc_hd__decap_3
Xclkbuf_leaf_33_clk clkload5/A VGND VGND VPWR VPWR _5999_/CLK sky130_fd_sc_hd__clkbuf_8
XFILLER_21_140 VGND VGND VPWR VPWR sky130_fd_sc_hd__decap_3
XFILLER_22_685 VGND VGND VPWR VPWR sky130_fd_sc_hd__decap_3
XTAP_TAPCELL_ROW_101_1458 VGND VPWR sky130_fd_sc_hd__tapvpwrvgnd_1
X_5849_ _6041_/CLK _5849_/D VGND VGND VPWR VPWR _5849_/Q sky130_fd_sc_hd__dfxtp_2
XFILLER_21_184 VGND VGND VPWR VPWR sky130_fd_sc_hd__decap_3
XFILLER_107_51 VGND VGND VPWR VPWR sky130_fd_sc_hd__decap_3
XFILLER_107_84 VGND VGND VPWR VPWR sky130_fd_sc_hd__decap_3
XFILLER_1_578 VGND VGND VPWR VPWR sky130_fd_sc_hd__decap_3
XFILLER_89_685 VGND VGND VPWR VPWR sky130_fd_sc_hd__decap_3
XTAP_TAPCELL_ROW_112_1598 VGND VPWR sky130_fd_sc_hd__tapvpwrvgnd_1
XFILLER_67_88 VGND VGND VPWR VPWR sky130_fd_sc_hd__decap_3
Xload_slew1000 _4811_/A VGND VGND VPWR VPWR _4913_/A sky130_fd_sc_hd__buf_4
XFILLER_57_571 VGND VGND VPWR VPWR sky130_fd_sc_hd__decap_3
Xhold1570 _5240_/Q VGND VGND VPWR VPWR _4163_/B2 sky130_fd_sc_hd__dlygate4sd3_1
Xload_slew1022 _3629_/S1 VGND VGND VPWR VPWR _3627_/S1 sky130_fd_sc_hd__buf_4
XFILLER_17_435 VGND VGND VPWR VPWR sky130_fd_sc_hd__decap_3
XFILLER_29_284 VGND VGND VPWR VPWR sky130_fd_sc_hd__decap_3
Xhold1581 _5264_/Q VGND VGND VPWR VPWR _4187_/B2 sky130_fd_sc_hd__dlygate4sd3_1
Xhold1592 _5456_/Q VGND VGND VPWR VPWR _4393_/B2 sky130_fd_sc_hd__dlygate4sd3_1
Xload_slew1055 _3919_/S1 VGND VGND VPWR VPWR _3940_/S1 sky130_fd_sc_hd__buf_4
Xload_slew1066 _3501_/S VGND VGND VPWR VPWR _3499_/S0 sky130_fd_sc_hd__buf_4
Xload_slew1077 _3325_/S VGND VGND VPWR VPWR _3300_/S sky130_fd_sc_hd__buf_4
XFILLER_83_54 VGND VGND VPWR VPWR sky130_fd_sc_hd__fill_2
XTAP_TAPCELL_ROW_67_1055 VGND VPWR sky130_fd_sc_hd__tapvpwrvgnd_1
Xload_slew1099 _3785_/S VGND VGND VPWR VPWR _3774_/S sky130_fd_sc_hd__buf_4
XTAP_TAPCELL_ROW_80_1211 VGND VPWR sky130_fd_sc_hd__tapvpwrvgnd_1
XFILLER_16_81 VGND VGND VPWR VPWR sky130_fd_sc_hd__decap_3
Xclkbuf_leaf_24_clk clkbuf_4_10_0_clk/X VGND VGND VPWR VPWR _6068_/CLK sky130_fd_sc_hd__clkbuf_8
XFILLER_13_685 VGND VGND VPWR VPWR sky130_fd_sc_hd__decap_3
XTAP_TAPCELL_ROW_30_606 VGND VPWR sky130_fd_sc_hd__tapvpwrvgnd_1
XFILLER_12_195 VGND VGND VPWR VPWR sky130_fd_sc_hd__fill_1
XFILLER_8_144 VGND VGND VPWR VPWR sky130_fd_sc_hd__decap_3
XTAP_TAPCELL_ROW_10_374 VGND VPWR sky130_fd_sc_hd__tapvpwrvgnd_1
XFILLER_4_350 VGND VGND VPWR VPWR sky130_fd_sc_hd__decap_3
XTAP_TAPCELL_ROW_78_1184 VGND VPWR sky130_fd_sc_hd__tapvpwrvgnd_1
XFILLER_113_215 VGND VGND VPWR VPWR sky130_fd_sc_hd__fill_1
XFILLER_4_383 VGND VGND VPWR VPWR sky130_fd_sc_hd__decap_3
XFILLER_99_449 VGND VGND VPWR VPWR sky130_fd_sc_hd__fill_2
XTAP_TAPCELL_ROW_91_1340 VGND VPWR sky130_fd_sc_hd__tapvpwrvgnd_1
XFILLER_79_140 VGND VGND VPWR VPWR sky130_fd_sc_hd__decap_3
X_4180_ _5033_/A1 _4192_/A2 _4180_/B1 _4180_/B2 VGND VGND VPWR VPWR _5257_/D sky130_fd_sc_hd__a22o_2
X_3200_ _5430_/Q _5078_/Q _3204_/S VGND VGND VPWR VPWR _3200_/X sky130_fd_sc_hd__mux2_1
X_3131_ _3131_/A _3131_/B VGND VGND VPWR VPWR _3131_/X sky130_fd_sc_hd__or2_2
XFILLER_94_132 VGND VGND VPWR VPWR sky130_fd_sc_hd__decap_3
XFILLER_94_165 VGND VGND VPWR VPWR sky130_fd_sc_hd__decap_3
XTAP_TAPCELL_ROW_38_706 VGND VPWR sky130_fd_sc_hd__tapvpwrvgnd_1
X_3062_ _5392_/Q _5360_/Q _5328_/Q _5296_/Q _3070_/S _3062_/S1 VGND VGND VPWR VPWR
+ _3062_/X sky130_fd_sc_hd__mux4_2
XFILLER_75_390 VGND VGND VPWR VPWR sky130_fd_sc_hd__fill_2
XFILLER_35_243 VGND VGND VPWR VPWR sky130_fd_sc_hd__fill_1
XFILLER_35_287 VGND VGND VPWR VPWR sky130_fd_sc_hd__decap_3
XFILLER_50_224 VGND VGND VPWR VPWR sky130_fd_sc_hd__decap_3
XTAP_TAPCELL_ROW_18_463 VGND VPWR sky130_fd_sc_hd__tapvpwrvgnd_1
XFILLER_23_449 VGND VGND VPWR VPWR sky130_fd_sc_hd__decap_3
Xclkbuf_leaf_15_clk clkbuf_4_8_0_clk/X VGND VGND VPWR VPWR _6027_/CLK sky130_fd_sc_hd__clkbuf_8
X_3964_ _5028_/A1 _3982_/A2 _3982_/B1 _3964_/B2 VGND VGND VPWR VPWR _5060_/D sky130_fd_sc_hd__a22o_2
X_5703_ _5815_/CLK _5703_/D VGND VGND VPWR VPWR _5703_/Q sky130_fd_sc_hd__dfxtp_2
X_3895_ _5429_/Q _5077_/Q _3895_/S VGND VGND VPWR VPWR _3895_/X sky130_fd_sc_hd__mux2_1
X_2915_ wire693/X _2912_/X _2914_/X VGND VGND VPWR VPWR _2915_/X sky130_fd_sc_hd__a21o_2
X_5634_ _5986_/CLK _5634_/D VGND VGND VPWR VPWR _5634_/Q sky130_fd_sc_hd__dfxtp_2
X_2846_ _5830_/Q _5446_/Q _3003_/S VGND VGND VPWR VPWR _2846_/X sky130_fd_sc_hd__mux2_1
X_5565_ _6050_/CLK _5565_/D VGND VGND VPWR VPWR _5565_/Q sky130_fd_sc_hd__dfxtp_2
X_2777_ _6051_/Q _5955_/Q _2777_/S VGND VGND VPWR VPWR _2777_/X sky130_fd_sc_hd__mux2_1
XFILLER_2_309 VGND VGND VPWR VPWR sky130_fd_sc_hd__fill_1
X_5496_ _6036_/CLK _5496_/D VGND VGND VPWR VPWR _5496_/Q sky130_fd_sc_hd__dfxtp_2
X_4516_ _4822_/A1 _4532_/A2 _4532_/B1 _4516_/B2 VGND VGND VPWR VPWR _5570_/D sky130_fd_sc_hd__a22o_2
X_4447_ _4515_/A1 _4468_/A2 _4453_/B1 _4447_/B2 VGND VGND VPWR VPWR _5505_/D sky130_fd_sc_hd__a22o_2
Xfanout613 _3944_/A1 VGND VGND VPWR VPWR _3235_/B sky130_fd_sc_hd__buf_4
Xfanout602 _3502_/A1 VGND VGND VPWR VPWR wire603/A sky130_fd_sc_hd__clkdlybuf4s25_1
XFILLER_85_110 VGND VGND VPWR VPWR sky130_fd_sc_hd__fill_2
XFILLER_86_633 VGND VGND VPWR VPWR sky130_fd_sc_hd__decap_3
Xfanout646 _2503_/Y VGND VGND VPWR VPWR wire647/A sky130_fd_sc_hd__clkdlybuf4s25_1
Xfanout635 _3196_/C1 VGND VGND VPWR VPWR _3106_/C1 sky130_fd_sc_hd__clkdlybuf4s25_1
X_4378_ _5025_/A1 wire459/X wire238/X _4378_/B2 VGND VGND VPWR VPWR _5441_/D sky130_fd_sc_hd__a22o_2
XFILLER_85_143 VGND VGND VPWR VPWR sky130_fd_sc_hd__fill_1
Xfanout679 _3111_/B2 VGND VGND VPWR VPWR _3004_/B2 sky130_fd_sc_hd__clkbuf_2
Xfanout668 fanout671/A VGND VGND VPWR VPWR _3118_/A1 sky130_fd_sc_hd__clkdlybuf4s25_1
X_3329_ wire628/X _3323_/X _3328_/X VGND VGND VPWR VPWR _3329_/X sky130_fd_sc_hd__a21o_2
XFILLER_100_465 VGND VGND VPWR VPWR sky130_fd_sc_hd__decap_3
XFILLER_37_47 VGND VGND VPWR VPWR sky130_fd_sc_hd__fill_1
X_6048_ _6048_/CLK _6048_/D VGND VGND VPWR VPWR _6048_/Q sky130_fd_sc_hd__dfxtp_2
XFILLER_14_416 VGND VGND VPWR VPWR sky130_fd_sc_hd__decap_3
XFILLER_54_585 VGND VGND VPWR VPWR sky130_fd_sc_hd__decap_3
XFILLER_53_57 VGND VGND VPWR VPWR sky130_fd_sc_hd__fill_1
XFILLER_81_393 VGND VGND VPWR VPWR sky130_fd_sc_hd__fill_2
XFILLER_108_510 VGND VGND VPWR VPWR sky130_fd_sc_hd__decap_3
XFILLER_6_615 VGND VGND VPWR VPWR sky130_fd_sc_hd__decap_3
XFILLER_108_543 VGND VGND VPWR VPWR sky130_fd_sc_hd__fill_2
XFILLER_5_169 VGND VGND VPWR VPWR sky130_fd_sc_hd__decap_3
XTAP_TAPCELL_ROW_114_1616 VGND VPWR sky130_fd_sc_hd__tapvpwrvgnd_1
XFILLER_78_32 VGND VGND VPWR VPWR sky130_fd_sc_hd__decap_3
XFILLER_78_76 VGND VGND VPWR VPWR sky130_fd_sc_hd__decap_3
XFILLER_103_281 VGND VGND VPWR VPWR sky130_fd_sc_hd__decap_3
XFILLER_76_154 VGND VGND VPWR VPWR sky130_fd_sc_hd__fill_1
Xhold2090 _5173_/Q VGND VGND VPWR VPWR _4089_/B2 sky130_fd_sc_hd__dlygate4sd3_1
XFILLER_45_541 VGND VGND VPWR VPWR sky130_fd_sc_hd__decap_3
XFILLER_17_265 VGND VGND VPWR VPWR sky130_fd_sc_hd__decap_3
XFILLER_45_574 VGND VGND VPWR VPWR sky130_fd_sc_hd__decap_3
XFILLER_60_522 VGND VGND VPWR VPWR sky130_fd_sc_hd__fill_1
XFILLER_72_393 VGND VGND VPWR VPWR sky130_fd_sc_hd__fill_1
XTAP_TAPCELL_ROW_15_433 VGND VPWR sky130_fd_sc_hd__tapvpwrvgnd_1
XFILLER_13_460 VGND VGND VPWR VPWR sky130_fd_sc_hd__decap_3
XTAP_TAPCELL_ROW_43_764 VGND VPWR sky130_fd_sc_hd__tapvpwrvgnd_1
XFILLER_9_420 VGND VGND VPWR VPWR sky130_fd_sc_hd__decap_3
X_2700_ _2700_/A _2700_/B VGND VGND VPWR VPWR _2712_/B sky130_fd_sc_hd__nand2_2
X_3680_ _3673_/X _3679_/X wire553/X VGND VGND VPWR VPWR _3680_/X sky130_fd_sc_hd__o21a_2
X_2631_ _2649_/A _2631_/B VGND VGND VPWR VPWR _2631_/X sky130_fd_sc_hd__or2_2
XFILLER_57_3 VGND VGND VPWR VPWR sky130_fd_sc_hd__fill_1
XFILLER_99_202 VGND VGND VPWR VPWR sky130_fd_sc_hd__decap_3
X_5350_ _5659_/CLK _5350_/D VGND VGND VPWR VPWR _5350_/Q sky130_fd_sc_hd__dfxtp_2
X_2562_ _5114_/Q _5082_/Q _6010_/Q _5978_/Q _2564_/S wire760/A VGND VGND VPWR VPWR
+ _2562_/X sky130_fd_sc_hd__mux4_2
X_5281_ _5578_/CLK _5281_/D VGND VGND VPWR VPWR _5281_/Q sky130_fd_sc_hd__dfxtp_2
X_4301_ _4507_/A1 _4327_/A2 wire248/X _4301_/B2 VGND VGND VPWR VPWR _5369_/D sky130_fd_sc_hd__a22o_2
XFILLER_114_568 VGND VGND VPWR VPWR sky130_fd_sc_hd__decap_3
X_4232_ _5016_/A1 _4260_/A2 _4260_/B1 _4232_/B2 VGND VGND VPWR VPWR _5304_/D sky130_fd_sc_hd__a22o_2
X_2493_ input9/X VGND VGND VPWR VPWR _2516_/B sky130_fd_sc_hd__inv_2
XFILLER_4_62 VGND VGND VPWR VPWR sky130_fd_sc_hd__decap_3
XFILLER_99_279 VGND VGND VPWR VPWR sky130_fd_sc_hd__fill_1
Xclkbuf_leaf_4_clk clkbuf_4_2_0_clk/X VGND VGND VPWR VPWR _6048_/CLK sky130_fd_sc_hd__clkbuf_8
X_4163_ _4506_/A1 _4162_/B _4191_/B1 _4163_/B2 VGND VGND VPWR VPWR _5240_/D sky130_fd_sc_hd__a22o_2
XFILLER_28_519 VGND VGND VPWR VPWR sky130_fd_sc_hd__fill_1
XFILLER_83_614 VGND VGND VPWR VPWR sky130_fd_sc_hd__fill_2
X_4094_ _4745_/A _4094_/B VGND VGND VPWR VPWR _4094_/Y sky130_fd_sc_hd__nor2_2
X_3114_ _5586_/Q _5554_/Q _3114_/S VGND VGND VPWR VPWR _3114_/X sky130_fd_sc_hd__mux2_1
XFILLER_36_530 VGND VGND VPWR VPWR sky130_fd_sc_hd__fill_2
X_3045_ _5391_/Q _5359_/Q _5327_/Q _5295_/Q _3145_/S _3202_/S1 VGND VGND VPWR VPWR
+ _3045_/X sky130_fd_sc_hd__mux4_2
XFILLER_51_500 VGND VGND VPWR VPWR sky130_fd_sc_hd__decap_3
XFILLER_63_393 VGND VGND VPWR VPWR sky130_fd_sc_hd__fill_2
X_4996_ _5030_/A1 _5008_/A2 _5008_/B1 _4996_/B2 VGND VGND VPWR VPWR _6022_/D sky130_fd_sc_hd__a22o_2
X_3947_ input2/X input1/X VGND VGND VPWR VPWR _4844_/A sky130_fd_sc_hd__nand2b_2
X_3878_ _5397_/Q _5365_/Q _5333_/Q _5301_/Q _3841_/S _3878_/S1 VGND VGND VPWR VPWR
+ _3878_/X sky130_fd_sc_hd__mux4_2
X_5617_ _6053_/CLK _5617_/D VGND VGND VPWR VPWR _5617_/Q sky130_fd_sc_hd__dfxtp_2
X_2829_ _5414_/Q _5062_/Q _3099_/S VGND VGND VPWR VPWR _2830_/B sky130_fd_sc_hd__mux2_1
XFILLER_105_502 VGND VGND VPWR VPWR sky130_fd_sc_hd__fill_2
XFILLER_3_607 VGND VGND VPWR VPWR sky130_fd_sc_hd__decap_3
X_5548_ _6017_/CLK _5548_/D VGND VGND VPWR VPWR _5548_/Q sky130_fd_sc_hd__dfxtp_2
XFILLER_105_513 VGND VGND VPWR VPWR sky130_fd_sc_hd__fill_1
XFILLER_3_629 VGND VGND VPWR VPWR sky130_fd_sc_hd__decap_3
X_5479_ _5514_/CLK _5479_/D VGND VGND VPWR VPWR _5479_/Q sky130_fd_sc_hd__dfxtp_2
Xfanout432 _4504_/Y VGND VGND VPWR VPWR _4537_/A2 sky130_fd_sc_hd__clkdlybuf4s25_1
XFILLER_113_590 VGND VGND VPWR VPWR sky130_fd_sc_hd__decap_3
XFILLER_48_57 VGND VGND VPWR VPWR sky130_fd_sc_hd__fill_1
Xfanout443 _4436_/Y VGND VGND VPWR VPWR _4437_/B sky130_fd_sc_hd__clkdlybuf4s25_1
XFILLER_74_603 VGND VGND VPWR VPWR sky130_fd_sc_hd__decap_3
XFILLER_86_474 VGND VGND VPWR VPWR sky130_fd_sc_hd__fill_2
Xfanout487 _4230_/Y VGND VGND VPWR VPWR _4263_/A2 sky130_fd_sc_hd__clkdlybuf4s25_1
Xfanout476 _4264_/Y VGND VGND VPWR VPWR _4295_/A2 sky130_fd_sc_hd__clkdlybuf4s25_1
XFILLER_100_284 VGND VGND VPWR VPWR sky130_fd_sc_hd__decap_3
XFILLER_73_135 VGND VGND VPWR VPWR sky130_fd_sc_hd__decap_3
XFILLER_104_85 VGND VGND VPWR VPWR sky130_fd_sc_hd__decap_3
XFILLER_27_596 VGND VGND VPWR VPWR sky130_fd_sc_hd__decap_3
XFILLER_64_56 VGND VGND VPWR VPWR sky130_fd_sc_hd__decap_3
XTAP_TAPCELL_ROW_64_1014 VGND VPWR sky130_fd_sc_hd__tapvpwrvgnd_1
XFILLER_14_235 VGND VGND VPWR VPWR sky130_fd_sc_hd__decap_3
XFILLER_9_18 VGND VGND VPWR VPWR sky130_fd_sc_hd__decap_3
XFILLER_42_577 VGND VGND VPWR VPWR sky130_fd_sc_hd__decap_3
XTAP_TAPCELL_ROW_40_734 VGND VPWR sky130_fd_sc_hd__tapvpwrvgnd_1
XFILLER_10_496 VGND VGND VPWR VPWR sky130_fd_sc_hd__decap_3
XTAP_TAPCELL_ROW_20_491 VGND VPWR sky130_fd_sc_hd__tapvpwrvgnd_1
XFILLER_89_53 VGND VGND VPWR VPWR sky130_fd_sc_hd__decap_3
XFILLER_2_640 VGND VGND VPWR VPWR sky130_fd_sc_hd__decap_3
XFILLER_2_651 VGND VGND VPWR VPWR sky130_fd_sc_hd__decap_3
XTAP_TAPCELL_ROW_75_1154 VGND VPWR sky130_fd_sc_hd__tapvpwrvgnd_1
XFILLER_111_505 VGND VGND VPWR VPWR sky130_fd_sc_hd__decap_3
XFILLER_2_684 VGND VGND VPWR VPWR sky130_fd_sc_hd__decap_3
XFILLER_96_216 VGND VGND VPWR VPWR sky130_fd_sc_hd__decap_3
Xload_slew838 _3188_/S VGND VGND VPWR VPWR _3145_/S sky130_fd_sc_hd__buf_4
Xload_slew816 _2627_/S VGND VGND VPWR VPWR _3114_/S sky130_fd_sc_hd__clkbuf_4
Xload_slew849 _2863_/S VGND VGND VPWR VPWR _2980_/S sky130_fd_sc_hd__clkbuf_4
XFILLER_65_603 VGND VGND VPWR VPWR sky130_fd_sc_hd__fill_1
XFILLER_77_452 VGND VGND VPWR VPWR sky130_fd_sc_hd__fill_2
XTAP_TAPCELL_ROW_48_823 VGND VPWR sky130_fd_sc_hd__tapvpwrvgnd_1
XFILLER_33_511 VGND VGND VPWR VPWR sky130_fd_sc_hd__decap_3
XFILLER_80_628 VGND VGND VPWR VPWR sky130_fd_sc_hd__decap_3
XFILLER_33_555 VGND VGND VPWR VPWR sky130_fd_sc_hd__decap_3
XFILLER_45_393 VGND VGND VPWR VPWR sky130_fd_sc_hd__fill_2
XTAP_TAPCELL_ROW_28_580 VGND VPWR sky130_fd_sc_hd__tapvpwrvgnd_1
XTAP_TAPCELL_ROW_28_591 VGND VPWR sky130_fd_sc_hd__tapvpwrvgnd_1
X_4850_ _5020_/A1 _4873_/A2 wire146/X _4850_/B2 VGND VGND VPWR VPWR _5884_/D sky130_fd_sc_hd__a22o_2
XTAP_TAPCELL_ROW_86_1283 VGND VPWR sky130_fd_sc_hd__tapvpwrvgnd_1
X_3801_ _5809_/Q _5745_/Q _3802_/S VGND VGND VPWR VPWR _3801_/X sky130_fd_sc_hd__mux2_1
X_4781_ _4805_/A_N _4781_/B VGND VGND VPWR VPWR _5819_/D sky130_fd_sc_hd__and2b_2
X_3732_ _5262_/Q _5230_/Q _3733_/S VGND VGND VPWR VPWR _3732_/X sky130_fd_sc_hd__mux2_1
Xclkload20 _5659_/CLK VGND VGND VPWR VPWR clkload20/X sky130_fd_sc_hd__clkbuf_4
X_3663_ _5387_/Q _5355_/Q _5323_/Q _5291_/Q _3790_/S _3772_/S1 VGND VGND VPWR VPWR
+ _3663_/X sky130_fd_sc_hd__mux4_2
Xclkload42 _5704_/CLK VGND VGND VPWR VPWR clkload42/Y sky130_fd_sc_hd__clkinv_2
Xclkload31 _6032_/CLK VGND VGND VPWR VPWR clkload31/X sky130_fd_sc_hd__clkbuf_8
X_5402_ _6010_/CLK _5402_/D VGND VGND VPWR VPWR _5402_/Q sky130_fd_sc_hd__dfxtp_2
X_2614_ _5564_/Q _5532_/Q _3122_/S VGND VGND VPWR VPWR _2614_/X sky130_fd_sc_hd__mux2_1
X_5333_ _5589_/CLK _5333_/D VGND VGND VPWR VPWR _5333_/Q sky130_fd_sc_hd__dfxtp_2
X_3594_ _3582_/X _3592_/X _3593_/X _3946_/B1 VGND VGND VPWR VPWR _3594_/X sky130_fd_sc_hd__o31a_2
X_2545_ _5817_/Q _5433_/Q _2604_/S VGND VGND VPWR VPWR _2545_/X sky130_fd_sc_hd__mux2_1
XFILLER_102_527 VGND VGND VPWR VPWR sky130_fd_sc_hd__decap_3
XFILLER_114_376 VGND VGND VPWR VPWR sky130_fd_sc_hd__fill_1
X_5264_ _5547_/CLK _5264_/D VGND VGND VPWR VPWR _5264_/Q sky130_fd_sc_hd__dfxtp_2
X_5195_ _5547_/CLK _5195_/D VGND VGND VPWR VPWR _5195_/Q sky130_fd_sc_hd__dfxtp_2
X_4215_ _4660_/A1 wire489/X wire269/X _4215_/B2 VGND VGND VPWR VPWR _5289_/D sky130_fd_sc_hd__a22o_2
XFILLER_110_560 VGND VGND VPWR VPWR sky130_fd_sc_hd__fill_1
X_4146_ _5033_/A1 _4158_/A2 _4146_/B1 _4146_/B2 VGND VGND VPWR VPWR _5225_/D sky130_fd_sc_hd__a22o_2
XFILLER_110_571 VGND VGND VPWR VPWR sky130_fd_sc_hd__decap_3
XFILLER_55_113 VGND VGND VPWR VPWR sky130_fd_sc_hd__fill_2
XFILLER_56_625 VGND VGND VPWR VPWR sky130_fd_sc_hd__fill_2
XFILLER_68_485 VGND VGND VPWR VPWR sky130_fd_sc_hd__fill_1
XFILLER_83_433 VGND VGND VPWR VPWR sky130_fd_sc_hd__decap_3
X_4077_ _5033_/A1 _4089_/A2 _4077_/B1 _4077_/B2 VGND VGND VPWR VPWR _5161_/D sky130_fd_sc_hd__a22o_2
XFILLER_83_477 VGND VGND VPWR VPWR sky130_fd_sc_hd__decap_3
X_3028_ _3028_/A1 _3025_/X _3027_/X VGND VGND VPWR VPWR _3028_/X sky130_fd_sc_hd__a21o_2
XFILLER_24_544 VGND VGND VPWR VPWR sky130_fd_sc_hd__decap_3
XFILLER_34_26 VGND VGND VPWR VPWR sky130_fd_sc_hd__fill_2
XFILLER_36_393 VGND VGND VPWR VPWR sky130_fd_sc_hd__decap_3
XFILLER_70_149 VGND VGND VPWR VPWR sky130_fd_sc_hd__decap_3
X_4979_ _5013_/A1 _4979_/A2 _4979_/B1 _4979_/B2 VGND VGND VPWR VPWR _6007_/D sky130_fd_sc_hd__a22o_2
Xwire118 wire118/A VGND VGND VPWR VPWR wire118/X sky130_fd_sc_hd__clkbuf_4
Xclkload3 clkload3/A VGND VGND VPWR VPWR clkload3/X sky130_fd_sc_hd__clkbuf_8
XFILLER_50_58 VGND VGND VPWR VPWR sky130_fd_sc_hd__decap_3
XFILLER_105_310 VGND VGND VPWR VPWR sky130_fd_sc_hd__decap_3
XFILLER_3_404 VGND VGND VPWR VPWR sky130_fd_sc_hd__fill_1
XFILLER_105_365 VGND VGND VPWR VPWR sky130_fd_sc_hd__decap_3
Xfanout251 _4331_/B1 VGND VGND VPWR VPWR _4318_/B1 sky130_fd_sc_hd__clkdlybuf4s25_1
XFILLER_101_582 VGND VGND VPWR VPWR sky130_fd_sc_hd__decap_3
XTAP_TAPCELL_ROW_70_1084 VGND VPWR sky130_fd_sc_hd__tapvpwrvgnd_1
XTAP_TAPCELL_ROW_70_1095 VGND VPWR sky130_fd_sc_hd__tapvpwrvgnd_1
Xfanout295 wire298/A VGND VGND VPWR VPWR _4120_/B1 sky130_fd_sc_hd__clkdlybuf4s25_1
Xfanout284 wire292/X VGND VGND VPWR VPWR _4134_/B1 sky130_fd_sc_hd__clkdlybuf4s25_1
XFILLER_19_349 VGND VGND VPWR VPWR sky130_fd_sc_hd__decap_3
XTAP_TAPCELL_ROW_109_1559 VGND VPWR sky130_fd_sc_hd__tapvpwrvgnd_1
XFILLER_61_105 VGND VGND VPWR VPWR sky130_fd_sc_hd__fill_1
XFILLER_15_522 VGND VGND VPWR VPWR sky130_fd_sc_hd__decap_3
XFILLER_15_544 VGND VGND VPWR VPWR sky130_fd_sc_hd__fill_1
XFILLER_61_149 VGND VGND VPWR VPWR sky130_fd_sc_hd__decap_3
XFILLER_91_21 VGND VGND VPWR VPWR sky130_fd_sc_hd__fill_1
XFILLER_15_588 VGND VGND VPWR VPWR sky130_fd_sc_hd__decap_3
XFILLER_91_43 VGND VGND VPWR VPWR sky130_fd_sc_hd__decap_3
XTAP_TAPCELL_ROW_25_550 VGND VPWR sky130_fd_sc_hd__tapvpwrvgnd_1
XFILLER_30_536 VGND VGND VPWR VPWR sky130_fd_sc_hd__decap_3
XTAP_TAPCELL_ROW_53_881 VGND VPWR sky130_fd_sc_hd__tapvpwrvgnd_1
XFILLER_10_271 VGND VGND VPWR VPWR sky130_fd_sc_hd__decap_3
Xwire630 wire630/A VGND VGND VPWR VPWR wire630/X sky130_fd_sc_hd__buf_4
Xwire641 wire641/A VGND VGND VPWR VPWR wire641/X sky130_fd_sc_hd__clkbuf_4
XFILLER_109_660 VGND VGND VPWR VPWR sky130_fd_sc_hd__decap_3
XFILLER_6_253 VGND VGND VPWR VPWR sky130_fd_sc_hd__decap_3
Xwire685 wire685/A VGND VGND VPWR VPWR wire685/X sky130_fd_sc_hd__clkbuf_4
XFILLER_109_682 VGND VGND VPWR VPWR sky130_fd_sc_hd__decap_3
XFILLER_108_181 VGND VGND VPWR VPWR sky130_fd_sc_hd__decap_3
XFILLER_97_503 VGND VGND VPWR VPWR sky130_fd_sc_hd__fill_1
XFILLER_97_547 VGND VGND VPWR VPWR sky130_fd_sc_hd__decap_3
Xload_slew657 fanout656/X VGND VGND VPWR VPWR _2936_/A1 sky130_fd_sc_hd__buf_4
Xload_slew624 _3709_/A1 VGND VGND VPWR VPWR _3385_/A sky130_fd_sc_hd__buf_4
X_4000_ _4517_/A1 _4018_/A2 _4005_/B1 _4000_/B2 VGND VGND VPWR VPWR _5091_/D sky130_fd_sc_hd__a22o_2
XFILLER_1_30 VGND VGND VPWR VPWR sky130_fd_sc_hd__decap_3
XFILLER_37_124 VGND VGND VPWR VPWR sky130_fd_sc_hd__decap_3
XTAP_TAPCELL_ROW_88_1301 VGND VPWR sky130_fd_sc_hd__tapvpwrvgnd_1
XFILLER_1_63 VGND VGND VPWR VPWR sky130_fd_sc_hd__decap_3
XFILLER_25_319 VGND VGND VPWR VPWR sky130_fd_sc_hd__fill_2
XFILLER_37_179 VGND VGND VPWR VPWR sky130_fd_sc_hd__decap_3
X_5951_ _6065_/CLK _5951_/D VGND VGND VPWR VPWR _5951_/Q sky130_fd_sc_hd__dfxtp_2
XFILLER_18_393 VGND VGND VPWR VPWR sky130_fd_sc_hd__decap_3
X_4902_ _5038_/A1 _4902_/A2 wire139/X _4902_/B2 VGND VGND VPWR VPWR _5934_/D sky130_fd_sc_hd__a22o_2
X_5882_ _5914_/CLK _5882_/D VGND VGND VPWR VPWR _5882_/Q sky130_fd_sc_hd__dfxtp_2
XFILLER_33_396 VGND VGND VPWR VPWR sky130_fd_sc_hd__decap_3
X_4833_ _5037_/A1 _4841_/A2 _4841_/B1 _4833_/B2 VGND VGND VPWR VPWR _5869_/D sky130_fd_sc_hd__a22o_2
X_4764_ _5000_/A1 _4777_/A2 _4777_/B1 _4764_/B2 VGND VGND VPWR VPWR _5802_/D sky130_fd_sc_hd__a22o_2
X_3715_ _5933_/Q _5901_/Q _5869_/Q _5773_/Q _3712_/S _3717_/S1 VGND VGND VPWR VPWR
+ _3716_/B sky130_fd_sc_hd__mux4_2
XTAP_TAPCELL_ROW_99_1441 VGND VPWR sky130_fd_sc_hd__tapvpwrvgnd_1
X_4695_ _4695_/A1 _4708_/A2 _4708_/B1 _4695_/B2 VGND VGND VPWR VPWR _5738_/D sky130_fd_sc_hd__a22o_2
X_3646_ _3404_/A _3644_/X _3645_/X _3414_/A VGND VGND VPWR VPWR _3646_/X sky130_fd_sc_hd__o22a_2
XFILLER_115_641 VGND VGND VPWR VPWR sky130_fd_sc_hd__decap_3
X_3577_ _3928_/A1 _3574_/X _3576_/X VGND VGND VPWR VPWR _3577_/X sky130_fd_sc_hd__a21o_2
XFILLER_0_418 VGND VGND VPWR VPWR sky130_fd_sc_hd__fill_2
XFILLER_115_663 VGND VGND VPWR VPWR sky130_fd_sc_hd__decap_3
XFILLER_115_685 VGND VGND VPWR VPWR sky130_fd_sc_hd__decap_3
X_5316_ _5400_/CLK _5316_/D VGND VGND VPWR VPWR _5316_/Q sky130_fd_sc_hd__dfxtp_2
X_2528_ _5561_/Q _5529_/Q _2529_/S VGND VGND VPWR VPWR _2528_/X sky130_fd_sc_hd__mux2_1
XFILLER_114_173 VGND VGND VPWR VPWR sky130_fd_sc_hd__decap_3
XFILLER_88_547 VGND VGND VPWR VPWR sky130_fd_sc_hd__fill_2
X_5247_ _5802_/CLK _5247_/D VGND VGND VPWR VPWR _5247_/Q sky130_fd_sc_hd__dfxtp_2
XFILLER_102_357 VGND VGND VPWR VPWR sky130_fd_sc_hd__decap_3
Xhold1900 _5720_/Q VGND VGND VPWR VPWR _4677_/B2 sky130_fd_sc_hd__dlygate4sd3_1
Xhold1911 _5921_/Q VGND VGND VPWR VPWR _4889_/B2 sky130_fd_sc_hd__dlygate4sd3_1
XFILLER_28_102 VGND VGND VPWR VPWR sky130_fd_sc_hd__fill_2
Xhold1922 _5074_/Q VGND VGND VPWR VPWR _3978_/B2 sky130_fd_sc_hd__dlygate4sd3_1
Xhold1933 _5447_/Q VGND VGND VPWR VPWR _4384_/B2 sky130_fd_sc_hd__dlygate4sd3_1
Xhold1944 _5554_/Q VGND VGND VPWR VPWR _4498_/B2 sky130_fd_sc_hd__dlygate4sd3_1
X_5178_ _6010_/CLK _5178_/D VGND VGND VPWR VPWR _5178_/Q sky130_fd_sc_hd__dfxtp_2
XFILLER_28_135 VGND VGND VPWR VPWR sky130_fd_sc_hd__decap_3
XFILLER_29_669 VGND VGND VPWR VPWR sky130_fd_sc_hd__decap_3
Xhold1955 _5160_/Q VGND VGND VPWR VPWR _4076_/B2 sky130_fd_sc_hd__dlygate4sd3_1
Xhold1966 _5059_/Q VGND VGND VPWR VPWR _3963_/B2 sky130_fd_sc_hd__dlygate4sd3_1
Xhold1977 _5166_/Q VGND VGND VPWR VPWR _4082_/B2 sky130_fd_sc_hd__dlygate4sd3_1
Xhold1988 _5250_/Q VGND VGND VPWR VPWR _4173_/B2 sky130_fd_sc_hd__dlygate4sd3_1
X_4129_ _4506_/A1 _4128_/B _4157_/B1 _4129_/B2 VGND VGND VPWR VPWR _5208_/D sky130_fd_sc_hd__a22o_2
XFILLER_43_116 VGND VGND VPWR VPWR sky130_fd_sc_hd__fill_1
XFILLER_83_252 VGND VGND VPWR VPWR sky130_fd_sc_hd__decap_3
XTAP_TAPCELL_ROW_3_289 VGND VPWR sky130_fd_sc_hd__tapvpwrvgnd_1
Xhold1999 _5940_/Q VGND VGND VPWR VPWR _4908_/B2 sky130_fd_sc_hd__dlygate4sd3_1
XFILLER_71_447 VGND VGND VPWR VPWR sky130_fd_sc_hd__fill_1
XFILLER_12_525 VGND VGND VPWR VPWR sky130_fd_sc_hd__fill_2
XFILLER_52_683 VGND VGND VPWR VPWR sky130_fd_sc_hd__decap_3
XFILLER_61_57 VGND VGND VPWR VPWR sky130_fd_sc_hd__decap_3
XTAP_TAPCELL_ROW_50_851 VGND VPWR sky130_fd_sc_hd__tapvpwrvgnd_1
XPHY_EDGE_ROW_5_Left_121 VGND VGND VPWR VPWR sky130_fd_sc_hd__decap_3
XFILLER_106_663 VGND VGND VPWR VPWR sky130_fd_sc_hd__decap_3
XTAP_TAPCELL_ROW_72_1113 VGND VPWR sky130_fd_sc_hd__tapvpwrvgnd_1
Xfanout1013 input13/X VGND VGND VPWR VPWR _3509_/A1 sky130_fd_sc_hd__clkdlybuf4s25_1
Xfanout1002 input16/X VGND VGND VPWR VPWR wire1003/A sky130_fd_sc_hd__clkdlybuf4s25_1
XFILLER_94_506 VGND VGND VPWR VPWR sky130_fd_sc_hd__decap_3
Xfanout1046 _3686_/S1 VGND VGND VPWR VPWR _3648_/S1 sky130_fd_sc_hd__buf_6
Xfanout1035 wire1038/A VGND VGND VPWR VPWR _3469_/S1 sky130_fd_sc_hd__clkdlybuf4s25_1
XFILLER_19_113 VGND VGND VPWR VPWR sky130_fd_sc_hd__fill_1
XFILLER_47_433 VGND VGND VPWR VPWR sky130_fd_sc_hd__decap_3
XFILLER_47_444 VGND VGND VPWR VPWR sky130_fd_sc_hd__decap_3
XTAP_TAPCELL_ROW_58_940 VGND VPWR sky130_fd_sc_hd__tapvpwrvgnd_1
XTAP_TAPCELL_ROW_58_951 VGND VPWR sky130_fd_sc_hd__tapvpwrvgnd_1
XFILLER_35_617 VGND VGND VPWR VPWR sky130_fd_sc_hd__decap_3
XFILLER_28_680 VGND VGND VPWR VPWR sky130_fd_sc_hd__decap_3
XFILLER_34_149 VGND VGND VPWR VPWR sky130_fd_sc_hd__decap_3
XFILLER_15_352 VGND VGND VPWR VPWR sky130_fd_sc_hd__fill_1
XTAP_TAPCELL_ROW_83_1242 VGND VPWR sky130_fd_sc_hd__tapvpwrvgnd_1
XFILLER_35_80 VGND VGND VPWR VPWR sky130_fd_sc_hd__fill_2
XFILLER_30_344 VGND VGND VPWR VPWR sky130_fd_sc_hd__decap_3
XFILLER_89_6 VGND VGND VPWR VPWR sky130_fd_sc_hd__decap_3
X_3500_ _5411_/Q _5059_/Q _3501_/S VGND VGND VPWR VPWR _3500_/X sky130_fd_sc_hd__mux2_1
Xwire482 wire482/A VGND VGND VPWR VPWR wire482/X sky130_fd_sc_hd__clkbuf_4
X_4480_ _4514_/A1 _4501_/A2 _4494_/B1 _4480_/B2 VGND VGND VPWR VPWR _5536_/D sky130_fd_sc_hd__a22o_2
X_3431_ _5920_/Q _5888_/Q _5856_/Q _5760_/Q _3499_/S0 _3615_/S1 VGND VGND VPWR VPWR
+ _3431_/X sky130_fd_sc_hd__mux4_2
X_3362_ _5245_/Q _5213_/Q _3363_/S VGND VGND VPWR VPWR _3362_/X sky130_fd_sc_hd__mux2_1
XTAP_TAPCELL_ROW_94_1382 VGND VPWR sky130_fd_sc_hd__tapvpwrvgnd_1
XFILLER_112_622 VGND VGND VPWR VPWR sky130_fd_sc_hd__decap_3
Xload_slew410 _4625_/A2 VGND VGND VPWR VPWR _4640_/A2 sky130_fd_sc_hd__buf_4
X_5101_ _6029_/CLK _5101_/D VGND VGND VPWR VPWR _5101_/Q sky130_fd_sc_hd__dfxtp_2
XFILLER_112_666 VGND VGND VPWR VPWR sky130_fd_sc_hd__decap_3
Xhold1207 _5330_/Q VGND VGND VPWR VPWR _4258_/B2 sky130_fd_sc_hd__dlygate4sd3_1
Xload_slew454 _4380_/A2 VGND VGND VPWR VPWR _4396_/A2 sky130_fd_sc_hd__clkbuf_4
X_3293_ _5914_/Q _5882_/Q _5850_/Q _5754_/Q _3325_/S _3304_/S1 VGND VGND VPWR VPWR
+ _3294_/B sky130_fd_sc_hd__mux4_2
XFILLER_38_400 VGND VGND VPWR VPWR sky130_fd_sc_hd__decap_3
XFILLER_85_528 VGND VGND VPWR VPWR sky130_fd_sc_hd__decap_3
Xhold1218 _5932_/Q VGND VGND VPWR VPWR _4900_/B2 sky130_fd_sc_hd__dlygate4sd3_1
Xhold1229 _5878_/Q VGND VGND VPWR VPWR _4842_/B2 sky130_fd_sc_hd__dlygate4sd3_1
Xload_slew498 _4188_/A2 VGND VGND VPWR VPWR _4162_/B sky130_fd_sc_hd__buf_4
X_5032_ _5032_/A1 wire334/A _5047_/B1 _5032_/B2 VGND VGND VPWR VPWR _6056_/D sky130_fd_sc_hd__a22o_2
XFILLER_25_105 VGND VGND VPWR VPWR sky130_fd_sc_hd__decap_3
XFILLER_93_583 VGND VGND VPWR VPWR sky130_fd_sc_hd__decap_3
XPHY_EDGE_ROW_69_Left_185 VGND VGND VPWR VPWR sky130_fd_sc_hd__decap_3
XFILLER_25_116 VGND VGND VPWR VPWR sky130_fd_sc_hd__fill_1
XFILLER_53_447 VGND VGND VPWR VPWR sky130_fd_sc_hd__fill_1
XTAP_TAPCELL_ROW_0_237 VGND VPWR sky130_fd_sc_hd__tapvpwrvgnd_1
XTAP_TAPCELL_ROW_0_248 VGND VPWR sky130_fd_sc_hd__tapvpwrvgnd_1
XTAP_TAPCELL_ROW_36_678 VGND VPWR sky130_fd_sc_hd__tapvpwrvgnd_1
X_5934_ _5934_/CLK _5934_/D VGND VGND VPWR VPWR _5934_/Q sky130_fd_sc_hd__dfxtp_2
X_5865_ clkload9/A _5865_/D VGND VGND VPWR VPWR _5865_/Q sky130_fd_sc_hd__dfxtp_2
XFILLER_33_182 VGND VGND VPWR VPWR sky130_fd_sc_hd__decap_3
X_4816_ _5020_/A1 wire371/X wire153/X _4816_/B2 VGND VGND VPWR VPWR _5852_/D sky130_fd_sc_hd__a22o_2
X_5796_ _5956_/CLK _5796_/D VGND VGND VPWR VPWR _5796_/Q sky130_fd_sc_hd__dfxtp_2
X_4747_ _4747_/A1 _4775_/A2 _4768_/B1 _4747_/B2 VGND VGND VPWR VPWR _5785_/D sky130_fd_sc_hd__a22o_2
XFILLER_110_9 VGND VGND VPWR VPWR sky130_fd_sc_hd__decap_3
XPHY_EDGE_ROW_78_Left_194 VGND VGND VPWR VPWR sky130_fd_sc_hd__decap_3
X_4678_ _4747_/A1 _4706_/A2 _4699_/B1 _4678_/B2 VGND VGND VPWR VPWR _5721_/D sky130_fd_sc_hd__a22o_2
X_3629_ _5705_/Q _5673_/Q _5641_/Q _5609_/Q _3631_/S _3629_/S1 VGND VGND VPWR VPWR
+ _3629_/X sky130_fd_sc_hd__mux4_2
XFILLER_103_611 VGND VGND VPWR VPWR sky130_fd_sc_hd__decap_3
XFILLER_115_493 VGND VGND VPWR VPWR sky130_fd_sc_hd__decap_3
XTAP_TAPCELL_ROW_8_348 VGND VPWR sky130_fd_sc_hd__tapvpwrvgnd_1
XFILLER_48_219 VGND VGND VPWR VPWR sky130_fd_sc_hd__decap_3
XFILLER_56_46 VGND VGND VPWR VPWR sky130_fd_sc_hd__fill_2
Xhold1730 _5452_/Q VGND VGND VPWR VPWR _4389_/B2 sky130_fd_sc_hd__dlygate4sd3_1
Xhold1741 _5732_/Q VGND VGND VPWR VPWR _4689_/B2 sky130_fd_sc_hd__dlygate4sd3_1
Xhold1752 _5075_/Q VGND VGND VPWR VPWR _3979_/B2 sky130_fd_sc_hd__dlygate4sd3_1
XFILLER_29_466 VGND VGND VPWR VPWR sky130_fd_sc_hd__fill_1
XFILLER_44_414 VGND VGND VPWR VPWR sky130_fd_sc_hd__decap_3
XTAP_TAPCELL_ROW_106_1518 VGND VPWR sky130_fd_sc_hd__tapvpwrvgnd_1
XTAP_TAPCELL_ROW_55_910 VGND VPWR sky130_fd_sc_hd__tapvpwrvgnd_1
Xhold1763 _5296_/Q VGND VGND VPWR VPWR _4222_/B2 sky130_fd_sc_hd__dlygate4sd3_1
Xhold1774 _5966_/Q VGND VGND VPWR VPWR _4936_/B2 sky130_fd_sc_hd__dlygate4sd3_1
Xhold1785 _5113_/Q VGND VGND VPWR VPWR _4025_/B2 sky130_fd_sc_hd__dlygate4sd3_1
Xhold1796 _5741_/Q VGND VGND VPWR VPWR _4698_/B2 sky130_fd_sc_hd__dlygate4sd3_1
XFILLER_112_41 VGND VGND VPWR VPWR sky130_fd_sc_hd__decap_3
XFILLER_112_74 VGND VGND VPWR VPWR sky130_fd_sc_hd__decap_3
XFILLER_112_85 VGND VGND VPWR VPWR sky130_fd_sc_hd__decap_3
XFILLER_12_333 VGND VGND VPWR VPWR sky130_fd_sc_hd__fill_1
XFILLER_40_653 VGND VGND VPWR VPWR sky130_fd_sc_hd__decap_3
XFILLER_8_326 VGND VGND VPWR VPWR sky130_fd_sc_hd__fill_2
XFILLER_4_565 VGND VGND VPWR VPWR sky130_fd_sc_hd__decap_3
XFILLER_97_42 VGND VGND VPWR VPWR sky130_fd_sc_hd__fill_1
XFILLER_47_263 VGND VGND VPWR VPWR sky130_fd_sc_hd__fill_2
XFILLER_90_531 VGND VGND VPWR VPWR sky130_fd_sc_hd__fill_1
X_3980_ _5044_/A1 _3982_/A2 _3982_/B1 _3980_/B2 VGND VGND VPWR VPWR _5076_/D sky130_fd_sc_hd__a22o_2
XFILLER_90_586 VGND VGND VPWR VPWR sky130_fd_sc_hd__fill_2
X_2931_ _5258_/Q _5226_/Q _3217_/S VGND VGND VPWR VPWR _2931_/X sky130_fd_sc_hd__mux2_1
XTAP_TAPCELL_ROW_33_648 VGND VPWR sky130_fd_sc_hd__tapvpwrvgnd_1
XTAP_TAPCELL_ROW_61_979 VGND VPWR sky130_fd_sc_hd__tapvpwrvgnd_1
Xclkbuf_0_clk clk VGND VGND VPWR VPWR clkbuf_0_clk/X sky130_fd_sc_hd__clkbuf_16
X_5650_ _6013_/CLK _5650_/D VGND VGND VPWR VPWR _5650_/Q sky130_fd_sc_hd__dfxtp_2
X_4601_ _4601_/A1 _4606_/A2 _4606_/B1 _4601_/B2 VGND VGND VPWR VPWR _5650_/D sky130_fd_sc_hd__a22o_2
X_2862_ _5191_/Q _5159_/Q _2863_/S VGND VGND VPWR VPWR _2862_/X sky130_fd_sc_hd__mux2_1
X_5581_ _6045_/CLK _5581_/D VGND VGND VPWR VPWR _5581_/Q sky130_fd_sc_hd__dfxtp_2
X_2793_ _3198_/A _2793_/B VGND VGND VPWR VPWR _2793_/X sky130_fd_sc_hd__or2_2
XTAP_TAPCELL_ROW_96_1400 VGND VPWR sky130_fd_sc_hd__tapvpwrvgnd_1
XFILLER_7_51 VGND VGND VPWR VPWR sky130_fd_sc_hd__decap_3
X_4532_ _4738_/A1 _4532_/A2 _4532_/B1 _4532_/B2 VGND VGND VPWR VPWR _5586_/D sky130_fd_sc_hd__a22o_2
Xwire290 wire290/A VGND VGND VPWR VPWR wire290/X sky130_fd_sc_hd__clkbuf_4
X_4463_ _4531_/A1 _4469_/A2 _4469_/B1 _4463_/B2 VGND VGND VPWR VPWR _5521_/D sky130_fd_sc_hd__a22o_2
XFILLER_104_408 VGND VGND VPWR VPWR sky130_fd_sc_hd__decap_3
X_3414_ _3414_/A _3414_/B VGND VGND VPWR VPWR _3414_/X sky130_fd_sc_hd__or2_2
XFILLER_98_642 VGND VGND VPWR VPWR sky130_fd_sc_hd__fill_2
XPHY_EDGE_ROW_15_Right_15 VGND VGND VPWR VPWR sky130_fd_sc_hd__decap_3
Xfanout806 _3104_/S VGND VGND VPWR VPWR _2988_/S sky130_fd_sc_hd__dlymetal6s4s_1
X_4394_ _4771_/A1 wire459/X _4400_/B1 _4394_/B2 VGND VGND VPWR VPWR _5457_/D sky130_fd_sc_hd__a22o_2
XFILLER_97_130 VGND VGND VPWR VPWR sky130_fd_sc_hd__decap_3
XTAP_TAPCELL_ROW_5_307 VGND VPWR sky130_fd_sc_hd__tapvpwrvgnd_1
Xload_slew240 _4385_/B1 VGND VGND VPWR VPWR _4400_/B1 sky130_fd_sc_hd__clkbuf_4
Xfanout839 _3204_/S VGND VGND VPWR VPWR _3199_/S sky130_fd_sc_hd__clkbuf_2
Xfanout817 _3110_/S VGND VGND VPWR VPWR _2638_/S sky130_fd_sc_hd__clkbuf_2
X_3345_ _5116_/Q _5084_/Q _6012_/Q _5980_/Q _3622_/S _3893_/S1 VGND VGND VPWR VPWR
+ _3345_/X sky130_fd_sc_hd__mux4_2
Xload_slew273 _4216_/B1 VGND VGND VPWR VPWR _4226_/B1 sky130_fd_sc_hd__buf_4
X_6064_ _6064_/CLK _6064_/D VGND VGND VPWR VPWR _6064_/Q sky130_fd_sc_hd__dfxtp_2
X_3276_ _5241_/Q _5209_/Q _3277_/S VGND VGND VPWR VPWR _3276_/X sky130_fd_sc_hd__mux2_1
X_5015_ _5015_/A _5015_/B VGND VGND VPWR VPWR _5015_/Y sky130_fd_sc_hd__nor2_2
XFILLER_38_241 VGND VGND VPWR VPWR sky130_fd_sc_hd__decap_3
XFILLER_66_550 VGND VGND VPWR VPWR sky130_fd_sc_hd__decap_3
XFILLER_38_274 VGND VGND VPWR VPWR sky130_fd_sc_hd__decap_3
XFILLER_93_380 VGND VGND VPWR VPWR sky130_fd_sc_hd__decap_3
XPHY_EDGE_ROW_24_Right_24 VGND VGND VPWR VPWR sky130_fd_sc_hd__decap_3
X_5917_ _5922_/CLK _5917_/D VGND VGND VPWR VPWR _5917_/Q sky130_fd_sc_hd__dfxtp_2
XFILLER_22_642 VGND VGND VPWR VPWR sky130_fd_sc_hd__fill_2
XFILLER_21_152 VGND VGND VPWR VPWR sky130_fd_sc_hd__decap_3
XTAP_TAPCELL_ROW_101_1459 VGND VPWR sky130_fd_sc_hd__tapvpwrvgnd_1
X_5848_ _6064_/CLK _5848_/D VGND VGND VPWR VPWR _5848_/Q sky130_fd_sc_hd__dfxtp_2
XFILLER_21_196 VGND VGND VPWR VPWR sky130_fd_sc_hd__decap_3
XPHY_EDGE_ROW_86_Left_202 VGND VGND VPWR VPWR sky130_fd_sc_hd__decap_3
X_5779_ _6067_/CLK _5779_/D VGND VGND VPWR VPWR _5779_/Q sky130_fd_sc_hd__dfxtp_2
XFILLER_107_213 VGND VGND VPWR VPWR sky130_fd_sc_hd__fill_1
XFILLER_107_279 VGND VGND VPWR VPWR sky130_fd_sc_hd__fill_1
XPHY_EDGE_ROW_33_Right_33 VGND VGND VPWR VPWR sky130_fd_sc_hd__decap_3
XFILLER_107_30 VGND VGND VPWR VPWR sky130_fd_sc_hd__decap_3
XFILLER_107_63 VGND VGND VPWR VPWR sky130_fd_sc_hd__decap_3
XFILLER_88_141 VGND VGND VPWR VPWR sky130_fd_sc_hd__decap_3
XFILLER_103_474 VGND VGND VPWR VPWR sky130_fd_sc_hd__decap_3
XFILLER_88_163 VGND VGND VPWR VPWR sky130_fd_sc_hd__decap_3
XPHY_EDGE_ROW_95_Left_211 VGND VGND VPWR VPWR sky130_fd_sc_hd__decap_3
XTAP_TAPCELL_ROW_112_1588 VGND VPWR sky130_fd_sc_hd__tapvpwrvgnd_1
XTAP_TAPCELL_ROW_112_1599 VGND VPWR sky130_fd_sc_hd__tapvpwrvgnd_1
XFILLER_57_561 VGND VGND VPWR VPWR sky130_fd_sc_hd__fill_2
Xhold1560 _6055_/Q VGND VGND VPWR VPWR _5031_/B2 sky130_fd_sc_hd__dlygate4sd3_1
Xhold1571 _5550_/Q VGND VGND VPWR VPWR _4494_/B2 sky130_fd_sc_hd__dlygate4sd3_1
Xload_slew1034 _3820_/S1 VGND VGND VPWR VPWR _3705_/S1 sky130_fd_sc_hd__buf_4
XFILLER_44_200 VGND VGND VPWR VPWR sky130_fd_sc_hd__fill_1
XFILLER_57_583 VGND VGND VPWR VPWR sky130_fd_sc_hd__decap_3
XFILLER_84_391 VGND VGND VPWR VPWR sky130_fd_sc_hd__decap_3
XPHY_EDGE_ROW_42_Right_42 VGND VGND VPWR VPWR sky130_fd_sc_hd__decap_3
Xhold1582 _5715_/Q VGND VGND VPWR VPWR _4670_/B2 sky130_fd_sc_hd__dlygate4sd3_1
Xhold1593 _5530_/Q VGND VGND VPWR VPWR _4474_/B2 sky130_fd_sc_hd__dlygate4sd3_1
Xload_slew1045 _3866_/S1 VGND VGND VPWR VPWR _3868_/S1 sky130_fd_sc_hd__buf_4
XFILLER_17_458 VGND VGND VPWR VPWR sky130_fd_sc_hd__decap_3
XFILLER_32_406 VGND VGND VPWR VPWR sky130_fd_sc_hd__decap_3
XTAP_TAPCELL_ROW_67_1056 VGND VPWR sky130_fd_sc_hd__tapvpwrvgnd_1
Xload_slew1089 _3379_/S VGND VGND VPWR VPWR _3609_/S sky130_fd_sc_hd__buf_4
XFILLER_16_60 VGND VGND VPWR VPWR sky130_fd_sc_hd__decap_3
XFILLER_32_417 VGND VGND VPWR VPWR sky130_fd_sc_hd__decap_3
XFILLER_13_642 VGND VGND VPWR VPWR sky130_fd_sc_hd__decap_3
XTAP_TAPCELL_ROW_80_1212 VGND VPWR sky130_fd_sc_hd__tapvpwrvgnd_1
XFILLER_12_141 VGND VGND VPWR VPWR sky130_fd_sc_hd__decap_3
XFILLER_40_461 VGND VGND VPWR VPWR sky130_fd_sc_hd__decap_3
XFILLER_9_613 VGND VGND VPWR VPWR sky130_fd_sc_hd__decap_3
XTAP_TAPCELL_ROW_30_607 VGND VPWR sky130_fd_sc_hd__tapvpwrvgnd_1
XFILLER_8_134 VGND VGND VPWR VPWR sky130_fd_sc_hd__decap_3
XFILLER_8_167 VGND VGND VPWR VPWR sky130_fd_sc_hd__decap_3
XFILLER_9_679 VGND VGND VPWR VPWR sky130_fd_sc_hd__decap_3
XPHY_EDGE_ROW_51_Right_51 VGND VGND VPWR VPWR sky130_fd_sc_hd__decap_3
XFILLER_8_189 VGND VGND VPWR VPWR sky130_fd_sc_hd__decap_3
XTAP_TAPCELL_ROW_10_364 VGND VPWR sky130_fd_sc_hd__tapvpwrvgnd_1
XTAP_TAPCELL_ROW_10_375 VGND VPWR sky130_fd_sc_hd__tapvpwrvgnd_1
XTAP_TAPCELL_ROW_78_1185 VGND VPWR sky130_fd_sc_hd__tapvpwrvgnd_1
XFILLER_99_439 VGND VGND VPWR VPWR sky130_fd_sc_hd__decap_3
XTAP_TAPCELL_ROW_91_1341 VGND VPWR sky130_fd_sc_hd__tapvpwrvgnd_1
XFILLER_95_612 VGND VGND VPWR VPWR sky130_fd_sc_hd__decap_3
X_3130_ _5395_/Q _5363_/Q _5331_/Q _5299_/Q _2772_/S _3164_/S1 VGND VGND VPWR VPWR
+ _3131_/B sky130_fd_sc_hd__mux4_2
XFILLER_79_185 VGND VGND VPWR VPWR sky130_fd_sc_hd__fill_1
XFILLER_94_144 VGND VGND VPWR VPWR sky130_fd_sc_hd__decap_3
XFILLER_94_177 VGND VGND VPWR VPWR sky130_fd_sc_hd__decap_3
XPHY_EDGE_ROW_60_Right_60 VGND VGND VPWR VPWR sky130_fd_sc_hd__decap_3
XTAP_TAPCELL_ROW_38_707 VGND VPWR sky130_fd_sc_hd__tapvpwrvgnd_1
X_3061_ _2499_/A _3059_/X _3060_/X _3195_/A1 VGND VGND VPWR VPWR _3061_/X sky130_fd_sc_hd__o22a_2
XFILLER_63_575 VGND VGND VPWR VPWR sky130_fd_sc_hd__fill_2
XTAP_TAPCELL_ROW_18_464 VGND VPWR sky130_fd_sc_hd__tapvpwrvgnd_1
XFILLER_90_394 VGND VGND VPWR VPWR sky130_fd_sc_hd__fill_1
X_3963_ _5027_/A1 _3981_/A2 wire322/X _3963_/B2 VGND VGND VPWR VPWR _5059_/D sky130_fd_sc_hd__a22o_2
X_5702_ _5790_/CLK _5702_/D VGND VGND VPWR VPWR _5702_/Q sky130_fd_sc_hd__dfxtp_2
X_3894_ _5813_/Q _5749_/Q _3895_/S VGND VGND VPWR VPWR _3894_/X sky130_fd_sc_hd__mux2_1
X_2914_ _2611_/A _2911_/X _2913_/X wire659/X VGND VGND VPWR VPWR _2914_/X sky130_fd_sc_hd__a22o_2
XFILLER_12_18 VGND VGND VPWR VPWR sky130_fd_sc_hd__fill_2
X_5633_ _5825_/CLK _5633_/D VGND VGND VPWR VPWR _5633_/Q sky130_fd_sc_hd__dfxtp_2
X_2845_ _6054_/Q _5958_/Q _3003_/S VGND VGND VPWR VPWR _2845_/X sky130_fd_sc_hd__mux2_1
XFILLER_12_29 VGND VGND VPWR VPWR sky130_fd_sc_hd__decap_3
X_5564_ _5683_/CLK _5564_/D VGND VGND VPWR VPWR _5564_/Q sky130_fd_sc_hd__dfxtp_2
X_4515_ _4515_/A1 wire431/X _4536_/B1 _4515_/B2 VGND VGND VPWR VPWR _5569_/D sky130_fd_sc_hd__a22o_2
X_2776_ _5827_/Q _5443_/Q _2777_/S VGND VGND VPWR VPWR _2776_/X sky130_fd_sc_hd__mux2_1
XPHY_EDGE_ROW_103_Right_103 VGND VGND VPWR VPWR sky130_fd_sc_hd__decap_3
X_5495_ _5879_/CLK _5495_/D VGND VGND VPWR VPWR _5495_/Q sky130_fd_sc_hd__dfxtp_2
XFILLER_104_205 VGND VGND VPWR VPWR sky130_fd_sc_hd__fill_1
X_4446_ _4514_/A1 _4465_/A2 _4465_/B1 _4446_/B2 VGND VGND VPWR VPWR _5504_/D sky130_fd_sc_hd__a22o_2
X_4377_ _4754_/A1 _4380_/A2 _4396_/B1 _4377_/B2 VGND VGND VPWR VPWR _5440_/D sky130_fd_sc_hd__a22o_2
XFILLER_86_601 VGND VGND VPWR VPWR sky130_fd_sc_hd__decap_3
Xfanout658 _3027_/B2 VGND VGND VPWR VPWR wire659/A sky130_fd_sc_hd__dlymetal6s4s_1
Xfanout636 _3196_/C1 VGND VGND VPWR VPWR _3230_/B2 sky130_fd_sc_hd__clkdlybuf4s25_1
Xfanout625 _3233_/Y VGND VGND VPWR VPWR _3928_/A1 sky130_fd_sc_hd__clkdlybuf4s25_1
X_3328_ _3562_/A _3324_/X _3327_/X _3898_/A1 VGND VGND VPWR VPWR _3328_/X sky130_fd_sc_hd__o211a_2
XFILLER_86_656 VGND VGND VPWR VPWR sky130_fd_sc_hd__fill_1
XFILLER_98_494 VGND VGND VPWR VPWR sky130_fd_sc_hd__decap_3
Xfanout669 _2498_/Y VGND VGND VPWR VPWR _3073_/A1 sky130_fd_sc_hd__clkdlybuf4s25_1
XFILLER_100_477 VGND VGND VPWR VPWR sky130_fd_sc_hd__decap_3
X_6047_ _6065_/CLK _6047_/D VGND VGND VPWR VPWR _6047_/Q sky130_fd_sc_hd__dfxtp_2
X_3259_ _5240_/Q _5208_/Q _3508_/S VGND VGND VPWR VPWR _3259_/X sky130_fd_sc_hd__mux2_1
XFILLER_39_594 VGND VGND VPWR VPWR sky130_fd_sc_hd__decap_3
XFILLER_54_531 VGND VGND VPWR VPWR sky130_fd_sc_hd__fill_1
XFILLER_54_597 VGND VGND VPWR VPWR sky130_fd_sc_hd__decap_3
XFILLER_10_623 VGND VGND VPWR VPWR sky130_fd_sc_hd__fill_1
XFILLER_10_645 VGND VGND VPWR VPWR sky130_fd_sc_hd__fill_1
XFILLER_6_627 VGND VGND VPWR VPWR sky130_fd_sc_hd__decap_3
XFILLER_108_522 VGND VGND VPWR VPWR sky130_fd_sc_hd__decap_3
XTAP_TAPCELL_ROW_114_1617 VGND VPWR sky130_fd_sc_hd__tapvpwrvgnd_1
XFILLER_1_354 VGND VGND VPWR VPWR sky130_fd_sc_hd__decap_3
XFILLER_78_88 VGND VGND VPWR VPWR sky130_fd_sc_hd__fill_2
XFILLER_92_626 VGND VGND VPWR VPWR sky130_fd_sc_hd__fill_1
XFILLER_94_32 VGND VGND VPWR VPWR sky130_fd_sc_hd__decap_3
Xhold2080 _5928_/Q VGND VGND VPWR VPWR _4896_/B2 sky130_fd_sc_hd__dlygate4sd3_1
XFILLER_92_637 VGND VGND VPWR VPWR sky130_fd_sc_hd__decap_3
XFILLER_92_648 VGND VGND VPWR VPWR sky130_fd_sc_hd__fill_2
XFILLER_92_659 VGND VGND VPWR VPWR sky130_fd_sc_hd__decap_3
Xhold2091 _5251_/Q VGND VGND VPWR VPWR _4174_/B2 sky130_fd_sc_hd__dlygate4sd3_1
XFILLER_91_169 VGND VGND VPWR VPWR sky130_fd_sc_hd__decap_3
Xhold1390 _5942_/Q VGND VGND VPWR VPWR _4910_/B2 sky130_fd_sc_hd__dlygate4sd3_1
XFILLER_45_597 VGND VGND VPWR VPWR sky130_fd_sc_hd__fill_2
XTAP_TAPCELL_ROW_15_434 VGND VPWR sky130_fd_sc_hd__tapvpwrvgnd_1
XFILLER_60_589 VGND VGND VPWR VPWR sky130_fd_sc_hd__decap_3
XTAP_TAPCELL_ROW_43_765 VGND VPWR sky130_fd_sc_hd__tapvpwrvgnd_1
XFILLER_9_432 VGND VGND VPWR VPWR sky130_fd_sc_hd__decap_3
XFILLER_71_6 VGND VGND VPWR VPWR sky130_fd_sc_hd__fill_1
XFILLER_9_465 VGND VGND VPWR VPWR sky130_fd_sc_hd__decap_3
X_2630_ _5917_/Q _5885_/Q _5853_/Q _5757_/Q _2998_/S _2996_/S1 VGND VGND VPWR VPWR
+ _2631_/B sky130_fd_sc_hd__mux4_2
X_2561_ _2561_/A _2561_/B wire559/A VGND VGND VPWR VPWR _2574_/C sky130_fd_sc_hd__or3b_2
XFILLER_114_536 VGND VGND VPWR VPWR sky130_fd_sc_hd__fill_1
XFILLER_5_671 VGND VGND VPWR VPWR sky130_fd_sc_hd__fill_1
XFILLER_5_682 VGND VGND VPWR VPWR sky130_fd_sc_hd__decap_3
X_5280_ _6019_/CLK _5280_/D VGND VGND VPWR VPWR _5280_/Q sky130_fd_sc_hd__dfxtp_2
X_4300_ _5016_/A1 _4328_/A2 _4328_/B1 _4300_/B2 VGND VGND VPWR VPWR _5368_/D sky130_fd_sc_hd__a22o_2
X_2492_ _2492_/A VGND VGND VPWR VPWR _2492_/Y sky130_fd_sc_hd__inv_2
XFILLER_4_41 VGND VGND VPWR VPWR sky130_fd_sc_hd__decap_3
X_4231_ _4811_/A _4231_/B VGND VGND VPWR VPWR _4231_/Y sky130_fd_sc_hd__nor2_2
XFILLER_67_100 VGND VGND VPWR VPWR sky130_fd_sc_hd__decap_3
XFILLER_68_634 VGND VGND VPWR VPWR sky130_fd_sc_hd__decap_3
XFILLER_68_645 VGND VGND VPWR VPWR sky130_fd_sc_hd__decap_3
X_4162_ _4745_/A _4162_/B VGND VGND VPWR VPWR _4162_/Y sky130_fd_sc_hd__nor2_2
X_4093_ _4161_/B _5014_/A VGND VGND VPWR VPWR _4093_/Y sky130_fd_sc_hd__nor2_2
X_3113_ _5394_/Q _5362_/Q _5330_/Q _5298_/Q _3115_/S _3113_/S1 VGND VGND VPWR VPWR
+ _3113_/X sky130_fd_sc_hd__mux4_2
X_3044_ _3044_/A _3044_/B VGND VGND VPWR VPWR _3044_/X sky130_fd_sc_hd__or2_2
XFILLER_36_542 VGND VGND VPWR VPWR sky130_fd_sc_hd__decap_3
XFILLER_70_309 VGND VGND VPWR VPWR sky130_fd_sc_hd__fill_2
XFILLER_91_681 VGND VGND VPWR VPWR sky130_fd_sc_hd__decap_3
XFILLER_23_225 VGND VGND VPWR VPWR sky130_fd_sc_hd__decap_3
X_4995_ _4995_/A1 _4981_/B _5012_/B1 _4995_/B2 VGND VGND VPWR VPWR _6021_/D sky130_fd_sc_hd__a22o_2
X_3946_ _3939_/X _3945_/X _3946_/B1 VGND VGND VPWR VPWR _3946_/X sky130_fd_sc_hd__o21a_2
X_3877_ _3865_/X _3875_/X _3876_/X wire553/X VGND VGND VPWR VPWR _3877_/X sky130_fd_sc_hd__o31a_2
X_5616_ _5867_/CLK _5616_/D VGND VGND VPWR VPWR _5616_/Q sky130_fd_sc_hd__dfxtp_2
X_2828_ _5798_/Q _5734_/Q _3099_/S VGND VGND VPWR VPWR _2828_/X sky130_fd_sc_hd__mux2_1
X_5547_ _5547_/CLK _5547_/D VGND VGND VPWR VPWR _5547_/Q sky130_fd_sc_hd__dfxtp_2
X_2759_ _5699_/Q _5667_/Q _5635_/Q _5603_/Q _2777_/S _3013_/S1 VGND VGND VPWR VPWR
+ _2759_/X sky130_fd_sc_hd__mux4_2
X_5478_ _5659_/CLK _5478_/D VGND VGND VPWR VPWR _5478_/Q sky130_fd_sc_hd__dfxtp_2
XFILLER_3_9 VGND VGND VPWR VPWR sky130_fd_sc_hd__decap_3
X_4429_ _4531_/A1 _4435_/A2 _4435_/B1 _4429_/B2 VGND VGND VPWR VPWR _5489_/D sky130_fd_sc_hd__a22o_2
Xfanout422 _4539_/Y VGND VGND VPWR VPWR _4571_/A2 sky130_fd_sc_hd__clkdlybuf4s25_1
Xfanout411 _4607_/Y VGND VGND VPWR VPWR _4608_/B sky130_fd_sc_hd__clkdlybuf4s25_1
XFILLER_59_634 VGND VGND VPWR VPWR sky130_fd_sc_hd__decap_3
XFILLER_59_645 VGND VGND VPWR VPWR sky130_fd_sc_hd__fill_1
Xfanout466 _4332_/Y VGND VGND VPWR VPWR _4365_/A2 sky130_fd_sc_hd__clkdlybuf4s25_1
Xfanout455 fanout458/A VGND VGND VPWR VPWR _4398_/A2 sky130_fd_sc_hd__clkdlybuf4s25_1
Xfanout433 _4470_/Y VGND VGND VPWR VPWR _4494_/A2 sky130_fd_sc_hd__clkdlybuf4s25_1
XFILLER_100_241 VGND VGND VPWR VPWR sky130_fd_sc_hd__decap_3
Xfanout499 fanout501/X VGND VGND VPWR VPWR wire500/A sky130_fd_sc_hd__clkdlybuf4s25_1
Xfanout488 _4196_/Y VGND VGND VPWR VPWR wire489/A sky130_fd_sc_hd__clkdlybuf4s25_1
XFILLER_27_520 VGND VGND VPWR VPWR sky130_fd_sc_hd__decap_3
XFILLER_86_497 VGND VGND VPWR VPWR sky130_fd_sc_hd__decap_3
XFILLER_73_147 VGND VGND VPWR VPWR sky130_fd_sc_hd__decap_3
XTAP_TAPCELL_ROW_64_1015 VGND VPWR sky130_fd_sc_hd__tapvpwrvgnd_1
XFILLER_14_247 VGND VGND VPWR VPWR sky130_fd_sc_hd__decap_3
XFILLER_14_269 VGND VGND VPWR VPWR sky130_fd_sc_hd__decap_3
XFILLER_42_589 VGND VGND VPWR VPWR sky130_fd_sc_hd__decap_3
XTAP_TAPCELL_ROW_40_724 VGND VPWR sky130_fd_sc_hd__tapvpwrvgnd_1
XTAP_TAPCELL_ROW_40_735 VGND VPWR sky130_fd_sc_hd__tapvpwrvgnd_1
XFILLER_6_413 VGND VGND VPWR VPWR sky130_fd_sc_hd__decap_3
XFILLER_6_424 VGND VGND VPWR VPWR sky130_fd_sc_hd__fill_2
XTAP_TAPCELL_ROW_20_492 VGND VPWR sky130_fd_sc_hd__tapvpwrvgnd_1
XPHY_EDGE_ROW_23_Left_139 VGND VGND VPWR VPWR sky130_fd_sc_hd__decap_3
XTAP_TAPCELL_ROW_75_1144 VGND VPWR sky130_fd_sc_hd__tapvpwrvgnd_1
XTAP_TAPCELL_ROW_75_1155 VGND VPWR sky130_fd_sc_hd__tapvpwrvgnd_1
XFILLER_2_663 VGND VGND VPWR VPWR sky130_fd_sc_hd__decap_3
Xload_slew828 _2885_/S VGND VGND VPWR VPWR _3069_/S sky130_fd_sc_hd__buf_4
XFILLER_49_166 VGND VGND VPWR VPWR sky130_fd_sc_hd__fill_2
XFILLER_65_615 VGND VGND VPWR VPWR sky130_fd_sc_hd__fill_1
XFILLER_49_199 VGND VGND VPWR VPWR sky130_fd_sc_hd__fill_2
XTAP_TAPCELL_ROW_48_824 VGND VPWR sky130_fd_sc_hd__tapvpwrvgnd_1
XFILLER_18_553 VGND VGND VPWR VPWR sky130_fd_sc_hd__fill_2
XFILLER_64_147 VGND VGND VPWR VPWR sky130_fd_sc_hd__decap_3
XPHY_EDGE_ROW_32_Left_148 VGND VGND VPWR VPWR sky130_fd_sc_hd__decap_3
XFILLER_73_681 VGND VGND VPWR VPWR sky130_fd_sc_hd__decap_3
XTAP_TAPCELL_ROW_28_581 VGND VPWR sky130_fd_sc_hd__tapvpwrvgnd_1
XTAP_TAPCELL_ROW_86_1284 VGND VPWR sky130_fd_sc_hd__tapvpwrvgnd_1
X_4780_ _4805_/A_N _4780_/B VGND VGND VPWR VPWR _5818_/D sky130_fd_sc_hd__and2b_2
X_3800_ _3800_/A _3800_/B VGND VGND VPWR VPWR _3800_/X sky130_fd_sc_hd__or2_2
XFILLER_60_375 VGND VGND VPWR VPWR sky130_fd_sc_hd__decap_3
X_3731_ _5134_/Q _5102_/Q _6030_/Q _5998_/Q _3733_/S _3742_/S1 VGND VGND VPWR VPWR
+ _3731_/X sky130_fd_sc_hd__mux4_2
Xclkload10 _6041_/CLK VGND VGND VPWR VPWR clkload10/Y sky130_fd_sc_hd__clkinv_2
X_3662_ _3738_/A _3659_/X _3661_/X _3781_/C1 VGND VGND VPWR VPWR _3662_/X sky130_fd_sc_hd__a211o_2
XPHY_EDGE_ROW_41_Left_157 VGND VGND VPWR VPWR sky130_fd_sc_hd__decap_3
Xclkload43 _6023_/CLK VGND VGND VPWR VPWR clkload43/Y sky130_fd_sc_hd__bufinv_16
Xclkload32 _5547_/CLK VGND VGND VPWR VPWR clkload32/X sky130_fd_sc_hd__clkbuf_8
Xclkload21 _5805_/CLK VGND VGND VPWR VPWR clkload21/X sky130_fd_sc_hd__clkbuf_8
X_5401_ _5785_/CLK _5401_/D VGND VGND VPWR VPWR _5401_/Q sky130_fd_sc_hd__dfxtp_2
X_3593_ _3939_/A1 _3584_/X _3587_/X _3922_/B1 _3577_/X VGND VGND VPWR VPWR _3593_/X
+ sky130_fd_sc_hd__a32o_2
X_2613_ _5372_/Q _5340_/Q _5308_/Q _5276_/Q _3133_/S _3024_/S1 VGND VGND VPWR VPWR
+ _2613_/X sky130_fd_sc_hd__mux4_2
X_5332_ _5400_/CLK _5332_/D VGND VGND VPWR VPWR _5332_/Q sky130_fd_sc_hd__dfxtp_2
X_2544_ _2611_/A _2544_/B VGND VGND VPWR VPWR _2544_/X sky130_fd_sc_hd__and2_2
X_5263_ _5797_/CLK _5263_/D VGND VGND VPWR VPWR _5263_/Q sky130_fd_sc_hd__dfxtp_2
X_5194_ _5258_/CLK _5194_/D VGND VGND VPWR VPWR _5194_/Q sky130_fd_sc_hd__dfxtp_2
X_4214_ _5032_/A1 _4227_/A2 _4227_/B1 _4214_/B2 VGND VGND VPWR VPWR _5288_/D sky130_fd_sc_hd__a22o_2
XFILLER_18_17 VGND VGND VPWR VPWR sky130_fd_sc_hd__decap_3
X_4145_ _4998_/A1 _4145_/A2 _4158_/B1 _4145_/B2 VGND VGND VPWR VPWR _5224_/D sky130_fd_sc_hd__a22o_2
XFILLER_110_583 VGND VGND VPWR VPWR sky130_fd_sc_hd__decap_3
XFILLER_56_648 VGND VGND VPWR VPWR sky130_fd_sc_hd__decap_3
XPHY_EDGE_ROW_50_Left_166 VGND VGND VPWR VPWR sky130_fd_sc_hd__decap_3
XFILLER_83_445 VGND VGND VPWR VPWR sky130_fd_sc_hd__decap_3
X_4076_ _4998_/A1 _4076_/A2 _4077_/B1 _4076_/B2 VGND VGND VPWR VPWR _5160_/D sky130_fd_sc_hd__a22o_2
X_3027_ _3027_/A1 _3024_/X _3026_/X _3027_/B2 VGND VGND VPWR VPWR _3027_/X sky130_fd_sc_hd__a22o_2
XFILLER_24_523 VGND VGND VPWR VPWR sky130_fd_sc_hd__decap_3
XFILLER_24_556 VGND VGND VPWR VPWR sky130_fd_sc_hd__fill_1
XFILLER_24_589 VGND VGND VPWR VPWR sky130_fd_sc_hd__decap_3
X_4978_ _5012_/A1 _4978_/A2 _4978_/B1 _4978_/B2 VGND VGND VPWR VPWR _6006_/D sky130_fd_sc_hd__a22o_2
Xclkload4 clkload4/A VGND VGND VPWR VPWR clkload4/X sky130_fd_sc_hd__clkbuf_8
X_3929_ _5943_/Q _5911_/Q _5879_/Q _5783_/Q _3929_/S0 _3929_/S1 VGND VGND VPWR VPWR
+ _3930_/B sky130_fd_sc_hd__mux4_2
XFILLER_109_138 VGND VGND VPWR VPWR sky130_fd_sc_hd__decap_3
XFILLER_1_6 VGND VGND VPWR VPWR sky130_fd_sc_hd__decap_3
XFILLER_3_449 VGND VGND VPWR VPWR sky130_fd_sc_hd__fill_1
Xfanout241 _4333_/Y VGND VGND VPWR VPWR wire242/A sky130_fd_sc_hd__clkdlybuf4s25_1
Xfanout230 _4435_/B1 VGND VGND VPWR VPWR _4419_/B1 sky130_fd_sc_hd__clkdlybuf4s25_1
XFILLER_115_41 VGND VGND VPWR VPWR sky130_fd_sc_hd__decap_3
XFILLER_115_63 VGND VGND VPWR VPWR sky130_fd_sc_hd__decap_3
XFILLER_93_209 VGND VGND VPWR VPWR sky130_fd_sc_hd__decap_3
Xfanout274 _4197_/Y VGND VGND VPWR VPWR _4229_/B1 sky130_fd_sc_hd__clkdlybuf4s25_1
Xfanout263 _4263_/B1 VGND VGND VPWR VPWR _4253_/B1 sky130_fd_sc_hd__clkdlybuf4s25_1
XFILLER_101_561 VGND VGND VPWR VPWR sky130_fd_sc_hd__decap_3
XFILLER_115_85 VGND VGND VPWR VPWR sky130_fd_sc_hd__decap_3
XFILLER_19_306 VGND VGND VPWR VPWR sky130_fd_sc_hd__decap_3
XFILLER_47_648 VGND VGND VPWR VPWR sky130_fd_sc_hd__decap_3
XFILLER_86_261 VGND VGND VPWR VPWR sky130_fd_sc_hd__decap_3
XTAP_TAPCELL_ROW_70_1085 VGND VPWR sky130_fd_sc_hd__tapvpwrvgnd_1
XFILLER_46_125 VGND VGND VPWR VPWR sky130_fd_sc_hd__decap_3
XFILLER_46_147 VGND VGND VPWR VPWR sky130_fd_sc_hd__decap_3
XFILLER_86_294 VGND VGND VPWR VPWR sky130_fd_sc_hd__fill_2
XFILLER_42_353 VGND VGND VPWR VPWR sky130_fd_sc_hd__decap_3
XTAP_TAPCELL_ROW_25_551 VGND VPWR sky130_fd_sc_hd__tapvpwrvgnd_1
XTAP_TAPCELL_ROW_53_882 VGND VPWR sky130_fd_sc_hd__tapvpwrvgnd_1
XFILLER_30_548 VGND VGND VPWR VPWR sky130_fd_sc_hd__decap_3
Xload_slew614 _3235_/B VGND VGND VPWR VPWR _3695_/A1 sky130_fd_sc_hd__buf_2
XFILLER_111_314 VGND VGND VPWR VPWR sky130_fd_sc_hd__decap_3
XFILLER_34_6 VGND VGND VPWR VPWR sky130_fd_sc_hd__decap_3
XFILLER_69_228 VGND VGND VPWR VPWR sky130_fd_sc_hd__fill_2
XTAP_TAPCELL_ROW_88_1302 VGND VPWR sky130_fd_sc_hd__tapvpwrvgnd_1
XFILLER_1_42 VGND VGND VPWR VPWR sky130_fd_sc_hd__decap_3
XFILLER_37_147 VGND VGND VPWR VPWR sky130_fd_sc_hd__decap_3
XFILLER_38_648 VGND VGND VPWR VPWR sky130_fd_sc_hd__fill_1
XFILLER_1_75 VGND VGND VPWR VPWR sky130_fd_sc_hd__decap_3
XFILLER_92_253 VGND VGND VPWR VPWR sky130_fd_sc_hd__decap_3
X_5950_ _6046_/CLK _5950_/D VGND VGND VPWR VPWR _5950_/Q sky130_fd_sc_hd__dfxtp_2
X_4901_ _5037_/A1 _4909_/A2 _4909_/B1 _4901_/B2 VGND VGND VPWR VPWR _5933_/D sky130_fd_sc_hd__a22o_2
XFILLER_33_353 VGND VGND VPWR VPWR sky130_fd_sc_hd__decap_3
XFILLER_61_640 VGND VGND VPWR VPWR sky130_fd_sc_hd__decap_3
X_5881_ _6041_/CLK _5881_/D VGND VGND VPWR VPWR _5881_/Q sky130_fd_sc_hd__dfxtp_2
XFILLER_21_526 VGND VGND VPWR VPWR sky130_fd_sc_hd__fill_1
XFILLER_60_150 VGND VGND VPWR VPWR sky130_fd_sc_hd__fill_2
XFILLER_61_684 VGND VGND VPWR VPWR sky130_fd_sc_hd__decap_3
X_4832_ _5036_/A1 wire376/X _4843_/B1 _4832_/B2 VGND VGND VPWR VPWR _5868_/D sky130_fd_sc_hd__a22o_2
X_4763_ _4999_/A1 _4775_/A2 _4775_/B1 _4763_/B2 VGND VGND VPWR VPWR _5801_/D sky130_fd_sc_hd__a22o_2
X_4694_ _4999_/A1 _4706_/A2 _4706_/B1 _4694_/B2 VGND VGND VPWR VPWR _5737_/D sky130_fd_sc_hd__a22o_2
X_3714_ _3827_/S _3710_/X _3713_/X _3898_/A1 VGND VGND VPWR VPWR _3714_/X sky130_fd_sc_hd__o211a_2
XTAP_TAPCELL_ROW_99_1442 VGND VPWR sky130_fd_sc_hd__tapvpwrvgnd_1
X_3645_ _5418_/Q _5066_/Q _3645_/S VGND VGND VPWR VPWR _3645_/X sky130_fd_sc_hd__mux2_1
XFILLER_115_620 VGND VGND VPWR VPWR sky130_fd_sc_hd__decap_3
X_3576_ _3234_/B _3573_/X _3575_/X _3927_/B2 VGND VGND VPWR VPWR _3576_/X sky130_fd_sc_hd__a22o_2
XFILLER_114_141 VGND VGND VPWR VPWR sky130_fd_sc_hd__decap_3
XFILLER_88_504 VGND VGND VPWR VPWR sky130_fd_sc_hd__fill_1
X_5315_ _5571_/CLK _5315_/D VGND VGND VPWR VPWR _5315_/Q sky130_fd_sc_hd__dfxtp_2
X_2527_ _5369_/Q _5337_/Q _5305_/Q _5273_/Q _2529_/S _2610_/S1 VGND VGND VPWR VPWR
+ _2527_/X sky130_fd_sc_hd__mux4_2
XFILLER_102_325 VGND VGND VPWR VPWR sky130_fd_sc_hd__fill_1
X_5246_ _6050_/CLK _5246_/D VGND VGND VPWR VPWR _5246_/Q sky130_fd_sc_hd__dfxtp_2
XPHY_EDGE_ROW_89_Right_89 VGND VGND VPWR VPWR sky130_fd_sc_hd__decap_3
Xhold1901 _5490_/Q VGND VGND VPWR VPWR _4430_/B2 sky130_fd_sc_hd__dlygate4sd3_1
XFILLER_96_592 VGND VGND VPWR VPWR sky130_fd_sc_hd__decap_3
Xhold1912 _5937_/Q VGND VGND VPWR VPWR _4905_/B2 sky130_fd_sc_hd__dlygate4sd3_1
Xhold1923 _5751_/Q VGND VGND VPWR VPWR _4708_/B2 sky130_fd_sc_hd__dlygate4sd3_1
Xhold1934 _5929_/Q VGND VGND VPWR VPWR _4897_/B2 sky130_fd_sc_hd__dlygate4sd3_1
Xhold1945 _5666_/Q VGND VGND VPWR VPWR _4619_/B2 sky130_fd_sc_hd__dlygate4sd3_1
X_5177_ _6035_/CLK _5177_/D VGND VGND VPWR VPWR _5177_/Q sky130_fd_sc_hd__dfxtp_2
Xhold1956 _5935_/Q VGND VGND VPWR VPWR _4903_/B2 sky130_fd_sc_hd__dlygate4sd3_1
Xhold1967 _5658_/Q VGND VGND VPWR VPWR _4611_/B2 sky130_fd_sc_hd__dlygate4sd3_1
Xhold1978 _5057_/Q VGND VGND VPWR VPWR _3961_/B2 sky130_fd_sc_hd__dlygate4sd3_1
X_4128_ _4745_/A _4128_/B VGND VGND VPWR VPWR _4128_/Y sky130_fd_sc_hd__nor2_2
XFILLER_16_309 VGND VGND VPWR VPWR sky130_fd_sc_hd__decap_3
XFILLER_43_106 VGND VGND VPWR VPWR sky130_fd_sc_hd__decap_3
XFILLER_45_26 VGND VGND VPWR VPWR sky130_fd_sc_hd__fill_2
XFILLER_83_264 VGND VGND VPWR VPWR sky130_fd_sc_hd__fill_2
Xhold1989 _5691_/Q VGND VGND VPWR VPWR _4646_/B2 sky130_fd_sc_hd__dlygate4sd3_1
X_4059_ _4745_/A _4059_/B VGND VGND VPWR VPWR _4059_/Y sky130_fd_sc_hd__nor2_2
XFILLER_37_681 VGND VGND VPWR VPWR sky130_fd_sc_hd__decap_3
XFILLER_45_48 VGND VGND VPWR VPWR sky130_fd_sc_hd__decap_3
XFILLER_24_353 VGND VGND VPWR VPWR sky130_fd_sc_hd__decap_3
XPHY_EDGE_ROW_98_Right_98 VGND VGND VPWR VPWR sky130_fd_sc_hd__decap_3
XTAP_TAPCELL_ROW_22_510 VGND VPWR sky130_fd_sc_hd__tapvpwrvgnd_1
XTAP_TAPCELL_ROW_50_852 VGND VPWR sky130_fd_sc_hd__tapvpwrvgnd_1
XFILLER_106_675 VGND VGND VPWR VPWR sky130_fd_sc_hd__decap_3
XTAP_TAPCELL_ROW_72_1114 VGND VPWR sky130_fd_sc_hd__tapvpwrvgnd_1
XFILLER_79_526 VGND VGND VPWR VPWR sky130_fd_sc_hd__decap_3
XFILLER_79_559 VGND VGND VPWR VPWR sky130_fd_sc_hd__fill_1
XFILLER_86_55 VGND VGND VPWR VPWR sky130_fd_sc_hd__fill_1
Xfanout1025 _3742_/S1 VGND VGND VPWR VPWR _3736_/S1 sky130_fd_sc_hd__clkdlybuf4s25_1
XFILLER_59_272 VGND VGND VPWR VPWR sky130_fd_sc_hd__decap_3
XFILLER_86_88 VGND VGND VPWR VPWR sky130_fd_sc_hd__fill_2
Xfanout1069 _3339_/S VGND VGND VPWR VPWR _3743_/S sky130_fd_sc_hd__dlymetal6s2s_1
Xfanout1058 _3339_/S VGND VGND VPWR VPWR _3616_/S sky130_fd_sc_hd__clkbuf_2
XFILLER_19_136 VGND VGND VPWR VPWR sky130_fd_sc_hd__decap_3
XFILLER_86_99 VGND VGND VPWR VPWR sky130_fd_sc_hd__decap_3
XTAP_TAPCELL_ROW_58_941 VGND VPWR sky130_fd_sc_hd__tapvpwrvgnd_1
XFILLER_35_629 VGND VGND VPWR VPWR sky130_fd_sc_hd__decap_3
XFILLER_34_139 VGND VGND VPWR VPWR sky130_fd_sc_hd__fill_1
XPHY_EDGE_ROW_106_Left_222 VGND VGND VPWR VPWR sky130_fd_sc_hd__decap_3
XTAP_TAPCELL_ROW_83_1243 VGND VPWR sky130_fd_sc_hd__tapvpwrvgnd_1
XFILLER_30_312 VGND VGND VPWR VPWR sky130_fd_sc_hd__decap_3
XFILLER_43_673 VGND VGND VPWR VPWR sky130_fd_sc_hd__decap_3
XFILLER_70_470 VGND VGND VPWR VPWR sky130_fd_sc_hd__decap_3
XFILLER_30_356 VGND VGND VPWR VPWR sky130_fd_sc_hd__fill_1
XFILLER_11_581 VGND VGND VPWR VPWR sky130_fd_sc_hd__decap_3
Xmax_cap205 _4540_/Y VGND VGND VPWR VPWR fanout204/A sky130_fd_sc_hd__clkbuf_2
XPHY_EDGE_ROW_115_Left_231 VGND VGND VPWR VPWR sky130_fd_sc_hd__decap_3
X_3430_ _3261_/B _3424_/X _3429_/X _3261_/A VGND VGND VPWR VPWR _3430_/X sky130_fd_sc_hd__o211a_2
XFILLER_112_601 VGND VGND VPWR VPWR sky130_fd_sc_hd__decap_3
X_3361_ _5117_/Q _5085_/Q _6013_/Q _5981_/Q _3363_/S _3828_/S1 VGND VGND VPWR VPWR
+ _3361_/X sky130_fd_sc_hd__mux4_2
XTAP_TAPCELL_ROW_94_1383 VGND VPWR sky130_fd_sc_hd__tapvpwrvgnd_1
XTAP_TAPCELL_ROW_94_1372 VGND VPWR sky130_fd_sc_hd__tapvpwrvgnd_1
XFILLER_112_634 VGND VGND VPWR VPWR sky130_fd_sc_hd__decap_3
XFILLER_32_3 VGND VGND VPWR VPWR sky130_fd_sc_hd__decap_3
XFILLER_97_323 VGND VGND VPWR VPWR sky130_fd_sc_hd__decap_3
X_5100_ _6055_/CLK _5100_/D VGND VGND VPWR VPWR _5100_/Q sky130_fd_sc_hd__dfxtp_2
XFILLER_112_645 VGND VGND VPWR VPWR sky130_fd_sc_hd__decap_3
XFILLER_112_678 VGND VGND VPWR VPWR sky130_fd_sc_hd__decap_3
Xload_slew444 _4437_/B VGND VGND VPWR VPWR _4468_/A2 sky130_fd_sc_hd__buf_4
X_5031_ _5031_/A1 wire334/X _5047_/B1 _5031_/B2 VGND VGND VPWR VPWR _6055_/D sky130_fd_sc_hd__a22o_2
X_3292_ _3385_/A _3289_/X _3291_/X VGND VGND VPWR VPWR _3292_/X sky130_fd_sc_hd__a21o_2
XFILLER_111_177 VGND VGND VPWR VPWR sky130_fd_sc_hd__fill_1
XFILLER_38_412 VGND VGND VPWR VPWR sky130_fd_sc_hd__decap_3
XFILLER_97_378 VGND VGND VPWR VPWR sky130_fd_sc_hd__decap_3
Xhold1208 _5767_/Q VGND VGND VPWR VPWR _4727_/B2 sky130_fd_sc_hd__dlygate4sd3_1
Xhold1219 _5858_/Q VGND VGND VPWR VPWR _4822_/B2 sky130_fd_sc_hd__dlygate4sd3_1
Xload_slew477 _4295_/A2 VGND VGND VPWR VPWR _4292_/A2 sky130_fd_sc_hd__buf_2
XFILLER_78_592 VGND VGND VPWR VPWR sky130_fd_sc_hd__fill_1
XFILLER_93_551 VGND VGND VPWR VPWR sky130_fd_sc_hd__decap_3
XFILLER_25_139 VGND VGND VPWR VPWR sky130_fd_sc_hd__fill_2
XFILLER_53_437 VGND VGND VPWR VPWR sky130_fd_sc_hd__fill_1
XFILLER_80_223 VGND VGND VPWR VPWR sky130_fd_sc_hd__decap_3
XTAP_TAPCELL_ROW_0_238 VGND VPWR sky130_fd_sc_hd__tapvpwrvgnd_1
XTAP_TAPCELL_ROW_0_249 VGND VPWR sky130_fd_sc_hd__tapvpwrvgnd_1
XFILLER_15_18 VGND VGND VPWR VPWR sky130_fd_sc_hd__fill_2
XFILLER_34_640 VGND VGND VPWR VPWR sky130_fd_sc_hd__decap_3
X_5933_ _5938_/CLK _5933_/D VGND VGND VPWR VPWR _5933_/Q sky130_fd_sc_hd__dfxtp_2
XFILLER_33_161 VGND VGND VPWR VPWR sky130_fd_sc_hd__decap_3
XFILLER_34_684 VGND VGND VPWR VPWR sky130_fd_sc_hd__decap_3
XTAP_TAPCELL_ROW_36_679 VGND VPWR sky130_fd_sc_hd__tapvpwrvgnd_1
X_5864_ _6032_/CLK _5864_/D VGND VGND VPWR VPWR _5864_/Q sky130_fd_sc_hd__dfxtp_2
X_4815_ _5019_/A1 wire371/X wire153/A _4815_/B2 VGND VGND VPWR VPWR _5851_/D sky130_fd_sc_hd__a22o_2
XFILLER_21_389 VGND VGND VPWR VPWR sky130_fd_sc_hd__decap_3
XTAP_TAPCELL_ROW_103_1490 VGND VPWR sky130_fd_sc_hd__tapvpwrvgnd_1
X_5795_ _6051_/CLK _5795_/D VGND VGND VPWR VPWR _5795_/Q sky130_fd_sc_hd__dfxtp_2
X_4746_ _4880_/A1 _4745_/B _4768_/B1 _4746_/B2 VGND VGND VPWR VPWR _5784_/D sky130_fd_sc_hd__a22o_2
X_4677_ _4880_/A1 _4676_/B _4699_/B1 _4677_/B2 VGND VGND VPWR VPWR _5720_/D sky130_fd_sc_hd__a22o_2
XFILLER_103_9 VGND VGND VPWR VPWR sky130_fd_sc_hd__decap_3
X_3628_ _3837_/A _3628_/B VGND VGND VPWR VPWR _3628_/X sky130_fd_sc_hd__or2_2
XFILLER_0_205 VGND VGND VPWR VPWR sky130_fd_sc_hd__decap_3
XFILLER_102_111 VGND VGND VPWR VPWR sky130_fd_sc_hd__decap_3
XFILLER_103_623 VGND VGND VPWR VPWR sky130_fd_sc_hd__decap_3
XFILLER_88_312 VGND VGND VPWR VPWR sky130_fd_sc_hd__fill_2
X_3559_ _3713_/A1 _3557_/X _3558_/X _3713_/B2 VGND VGND VPWR VPWR _3559_/X sky130_fd_sc_hd__o22a_2
XTAP_TAPCELL_ROW_8_349 VGND VPWR sky130_fd_sc_hd__tapvpwrvgnd_1
XFILLER_103_667 VGND VGND VPWR VPWR sky130_fd_sc_hd__decap_3
XFILLER_88_356 VGND VGND VPWR VPWR sky130_fd_sc_hd__decap_3
Xhold1720 _5455_/Q VGND VGND VPWR VPWR _4392_/B2 sky130_fd_sc_hd__dlygate4sd3_1
X_5229_ _6029_/CLK _5229_/D VGND VGND VPWR VPWR _5229_/Q sky130_fd_sc_hd__dfxtp_2
XFILLER_29_434 VGND VGND VPWR VPWR sky130_fd_sc_hd__fill_2
XFILLER_29_445 VGND VGND VPWR VPWR sky130_fd_sc_hd__decap_3
Xhold1731 _5982_/Q VGND VGND VPWR VPWR _4954_/B2 sky130_fd_sc_hd__dlygate4sd3_1
Xhold1742 _5082_/Q VGND VGND VPWR VPWR _3991_/B2 sky130_fd_sc_hd__dlygate4sd3_1
Xhold1753 _5168_/Q VGND VGND VPWR VPWR _4084_/B2 sky130_fd_sc_hd__dlygate4sd3_1
XTAP_TAPCELL_ROW_55_911 VGND VPWR sky130_fd_sc_hd__tapvpwrvgnd_1
Xhold1764 _5192_/Q VGND VGND VPWR VPWR _4111_/B2 sky130_fd_sc_hd__dlygate4sd3_1
Xhold1775 _5893_/Q VGND VGND VPWR VPWR _4859_/B2 sky130_fd_sc_hd__dlygate4sd3_1
Xhold1786 _5304_/Q VGND VGND VPWR VPWR _4232_/B2 sky130_fd_sc_hd__dlygate4sd3_1
XFILLER_71_223 VGND VGND VPWR VPWR sky130_fd_sc_hd__fill_1
XFILLER_84_584 VGND VGND VPWR VPWR sky130_fd_sc_hd__decap_3
XFILLER_84_595 VGND VGND VPWR VPWR sky130_fd_sc_hd__fill_1
XTAP_TAPCELL_ROW_106_1519 VGND VPWR sky130_fd_sc_hd__tapvpwrvgnd_1
Xhold1797 _5101_/Q VGND VGND VPWR VPWR _4010_/B2 sky130_fd_sc_hd__dlygate4sd3_1
XFILLER_112_53 VGND VGND VPWR VPWR sky130_fd_sc_hd__decap_3
XFILLER_44_459 VGND VGND VPWR VPWR sky130_fd_sc_hd__fill_1
XFILLER_112_97 VGND VGND VPWR VPWR sky130_fd_sc_hd__decap_3
XFILLER_12_312 VGND VGND VPWR VPWR sky130_fd_sc_hd__decap_3
XFILLER_25_673 VGND VGND VPWR VPWR sky130_fd_sc_hd__decap_3
XFILLER_52_492 VGND VGND VPWR VPWR sky130_fd_sc_hd__fill_2
XFILLER_21_72 VGND VGND VPWR VPWR sky130_fd_sc_hd__decap_3
XFILLER_4_533 VGND VGND VPWR VPWR sky130_fd_sc_hd__decap_3
XFILLER_21_83 VGND VGND VPWR VPWR sky130_fd_sc_hd__fill_2
XFILLER_21_94 VGND VGND VPWR VPWR sky130_fd_sc_hd__decap_3
XFILLER_97_21 VGND VGND VPWR VPWR sky130_fd_sc_hd__fill_1
XFILLER_98_109 VGND VGND VPWR VPWR sky130_fd_sc_hd__decap_3
XFILLER_106_483 VGND VGND VPWR VPWR sky130_fd_sc_hd__decap_3
XFILLER_97_54 VGND VGND VPWR VPWR sky130_fd_sc_hd__fill_2
XFILLER_79_389 VGND VGND VPWR VPWR sky130_fd_sc_hd__decap_3
XFILLER_94_337 VGND VGND VPWR VPWR sky130_fd_sc_hd__decap_3
XFILLER_75_551 VGND VGND VPWR VPWR sky130_fd_sc_hd__fill_1
XFILLER_62_212 VGND VGND VPWR VPWR sky130_fd_sc_hd__fill_1
XFILLER_16_640 VGND VGND VPWR VPWR sky130_fd_sc_hd__decap_3
XFILLER_46_91 VGND VGND VPWR VPWR sky130_fd_sc_hd__decap_3
XFILLER_90_554 VGND VGND VPWR VPWR sky130_fd_sc_hd__decap_3
XFILLER_90_598 VGND VGND VPWR VPWR sky130_fd_sc_hd__decap_3
X_2930_ _5194_/Q _5162_/Q _3217_/S VGND VGND VPWR VPWR _2930_/X sky130_fd_sc_hd__mux2_1
XTAP_TAPCELL_ROW_33_649 VGND VPWR sky130_fd_sc_hd__tapvpwrvgnd_1
XFILLER_31_676 VGND VGND VPWR VPWR sky130_fd_sc_hd__fill_2
X_4600_ _4771_/A1 _4574_/B _4600_/B1 _4600_/B2 VGND VGND VPWR VPWR _5649_/D sky130_fd_sc_hd__a22o_2
X_2861_ _3215_/A _2861_/B VGND VGND VPWR VPWR _2861_/X sky130_fd_sc_hd__or2_2
XFILLER_7_30 VGND VGND VPWR VPWR sky130_fd_sc_hd__decap_3
X_5580_ _6017_/CLK _5580_/D VGND VGND VPWR VPWR _5580_/Q sky130_fd_sc_hd__dfxtp_2
X_2792_ _5700_/Q _5668_/Q _5636_/Q _5604_/Q _2794_/S _3157_/S1 VGND VGND VPWR VPWR
+ _2793_/B sky130_fd_sc_hd__mux4_2
XTAP_TAPCELL_ROW_96_1401 VGND VPWR sky130_fd_sc_hd__tapvpwrvgnd_1
XFILLER_7_63 VGND VGND VPWR VPWR sky130_fd_sc_hd__fill_1
X_4531_ _4531_/A1 _4537_/A2 _4537_/B1 _4531_/B2 VGND VGND VPWR VPWR _5585_/D sky130_fd_sc_hd__a22o_2
XFILLER_7_393 VGND VGND VPWR VPWR sky130_fd_sc_hd__decap_3
X_4462_ _4530_/A1 _4437_/B _4468_/B1 _4462_/B2 VGND VGND VPWR VPWR _5520_/D sky130_fd_sc_hd__a22o_2
X_3413_ _5407_/Q _5055_/Q _3644_/S VGND VGND VPWR VPWR _3414_/B sky130_fd_sc_hd__mux2_1
X_4393_ _5040_/A1 _4368_/B wire238/A _4393_/B2 VGND VGND VPWR VPWR _5456_/D sky130_fd_sc_hd__a22o_2
XTAP_TAPCELL_ROW_5_308 VGND VPWR sky130_fd_sc_hd__tapvpwrvgnd_1
Xfanout829 _3194_/S VGND VGND VPWR VPWR _3193_/S sky130_fd_sc_hd__clkdlybuf4s25_1
X_3344_ _3342_/X _3343_/X _3626_/A VGND VGND VPWR VPWR _3344_/X sky130_fd_sc_hd__mux2_1
XFILLER_58_518 VGND VGND VPWR VPWR sky130_fd_sc_hd__decap_3
Xload_slew252 _4318_/B1 VGND VGND VPWR VPWR _4328_/B1 sky130_fd_sc_hd__buf_4
X_6063_ _6063_/CLK _6063_/D VGND VGND VPWR VPWR _6063_/Q sky130_fd_sc_hd__dfxtp_2
X_3275_ _5113_/Q _5081_/Q _6009_/Q _5977_/Q _3277_/S _3275_/S1 VGND VGND VPWR VPWR
+ _3275_/X sky130_fd_sc_hd__mux4_2
XFILLER_100_637 VGND VGND VPWR VPWR sky130_fd_sc_hd__decap_3
XFILLER_112_497 VGND VGND VPWR VPWR sky130_fd_sc_hd__fill_1
XFILLER_85_337 VGND VGND VPWR VPWR sky130_fd_sc_hd__decap_3
Xload_slew296 _4120_/B1 VGND VGND VPWR VPWR _4123_/B1 sky130_fd_sc_hd__buf_4
Xload_slew285 _4158_/B1 VGND VGND VPWR VPWR _4146_/B1 sky130_fd_sc_hd__buf_2
X_5014_ _5014_/A _5014_/B VGND VGND VPWR VPWR _5014_/Y sky130_fd_sc_hd__nor2_2
XFILLER_38_253 VGND VGND VPWR VPWR sky130_fd_sc_hd__decap_3
XFILLER_66_595 VGND VGND VPWR VPWR sky130_fd_sc_hd__decap_3
XFILLER_81_532 VGND VGND VPWR VPWR sky130_fd_sc_hd__decap_3
XFILLER_81_587 VGND VGND VPWR VPWR sky130_fd_sc_hd__decap_3
X_5916_ _6044_/CLK _5916_/D VGND VGND VPWR VPWR _5916_/Q sky130_fd_sc_hd__dfxtp_2
XFILLER_22_621 VGND VGND VPWR VPWR sky130_fd_sc_hd__fill_1
XFILLER_22_676 VGND VGND VPWR VPWR sky130_fd_sc_hd__decap_3
XFILLER_42_49 VGND VGND VPWR VPWR sky130_fd_sc_hd__decap_3
X_5847_ _6071_/CLK _5847_/D VGND VGND VPWR VPWR _5847_/Q sky130_fd_sc_hd__dfxtp_2
XFILLER_21_164 VGND VGND VPWR VPWR sky130_fd_sc_hd__decap_3
X_5778_ _5938_/CLK _5778_/D VGND VGND VPWR VPWR _5778_/Q sky130_fd_sc_hd__dfxtp_2
X_4729_ _4999_/A1 wire386/X wire166/X _4729_/B2 VGND VGND VPWR VPWR _5769_/D sky130_fd_sc_hd__a22o_2
XFILLER_107_225 VGND VGND VPWR VPWR sky130_fd_sc_hd__decap_3
XFILLER_101_6 VGND VGND VPWR VPWR sky130_fd_sc_hd__decap_3
XFILLER_107_247 VGND VGND VPWR VPWR sky130_fd_sc_hd__decap_3
XFILLER_1_525 VGND VGND VPWR VPWR sky130_fd_sc_hd__decap_3
XFILLER_89_632 VGND VGND VPWR VPWR sky130_fd_sc_hd__decap_3
XFILLER_107_42 VGND VGND VPWR VPWR sky130_fd_sc_hd__decap_3
XFILLER_107_75 VGND VGND VPWR VPWR sky130_fd_sc_hd__decap_3
XFILLER_1_569 VGND VGND VPWR VPWR sky130_fd_sc_hd__decap_3
XFILLER_67_24 VGND VGND VPWR VPWR sky130_fd_sc_hd__decap_3
XFILLER_67_57 VGND VGND VPWR VPWR sky130_fd_sc_hd__decap_3
XTAP_TAPCELL_ROW_112_1589 VGND VPWR sky130_fd_sc_hd__tapvpwrvgnd_1
XFILLER_88_197 VGND VGND VPWR VPWR sky130_fd_sc_hd__fill_2
XFILLER_29_253 VGND VGND VPWR VPWR sky130_fd_sc_hd__decap_3
XFILLER_29_264 VGND VGND VPWR VPWR sky130_fd_sc_hd__fill_2
Xhold1550 _5795_/Q VGND VGND VPWR VPWR _4757_/B2 sky130_fd_sc_hd__dlygate4sd3_1
Xhold1561 _5496_/Q VGND VGND VPWR VPWR _4438_/B2 sky130_fd_sc_hd__dlygate4sd3_1
XFILLER_17_426 VGND VGND VPWR VPWR sky130_fd_sc_hd__decap_3
XFILLER_44_223 VGND VGND VPWR VPWR sky130_fd_sc_hd__fill_1
XFILLER_72_510 VGND VGND VPWR VPWR sky130_fd_sc_hd__fill_1
XFILLER_72_521 VGND VGND VPWR VPWR sky130_fd_sc_hd__decap_3
Xhold1572 _5443_/Q VGND VGND VPWR VPWR _4380_/B2 sky130_fd_sc_hd__dlygate4sd3_1
Xhold1583 _5124_/Q VGND VGND VPWR VPWR _4036_/B2 sky130_fd_sc_hd__dlygate4sd3_1
Xhold1594 _5243_/Q VGND VGND VPWR VPWR _4166_/B2 sky130_fd_sc_hd__dlygate4sd3_1
Xload_slew1057 _3284_/S VGND VGND VPWR VPWR _3631_/S sky130_fd_sc_hd__clkbuf_4
Xload_slew1068 _3727_/S VGND VGND VPWR VPWR _3744_/S sky130_fd_sc_hd__buf_4
XFILLER_72_543 VGND VGND VPWR VPWR sky130_fd_sc_hd__decap_3
XTAP_TAPCELL_ROW_67_1057 VGND VPWR sky130_fd_sc_hd__tapvpwrvgnd_1
Xload_slew1079 _3317_/S VGND VGND VPWR VPWR _3318_/S sky130_fd_sc_hd__buf_4
XFILLER_72_598 VGND VGND VPWR VPWR sky130_fd_sc_hd__decap_3
XTAP_TAPCELL_ROW_80_1213 VGND VPWR sky130_fd_sc_hd__tapvpwrvgnd_1
XFILLER_12_153 VGND VGND VPWR VPWR sky130_fd_sc_hd__decap_3
XFILLER_13_676 VGND VGND VPWR VPWR sky130_fd_sc_hd__decap_3
XFILLER_8_102 VGND VGND VPWR VPWR sky130_fd_sc_hd__fill_2
XTAP_TAPCELL_ROW_30_608 VGND VPWR sky130_fd_sc_hd__tapvpwrvgnd_1
XTAP_TAPCELL_ROW_10_365 VGND VPWR sky130_fd_sc_hd__tapvpwrvgnd_1
Xclkbuf_leaf_101_clk clkbuf_4_0_0_clk/X VGND VGND VPWR VPWR _6044_/CLK sky130_fd_sc_hd__clkbuf_8
XTAP_TAPCELL_ROW_78_1186 VGND VPWR sky130_fd_sc_hd__tapvpwrvgnd_1
XFILLER_106_291 VGND VGND VPWR VPWR sky130_fd_sc_hd__fill_1
XFILLER_79_131 VGND VGND VPWR VPWR sky130_fd_sc_hd__decap_3
XTAP_TAPCELL_ROW_91_1342 VGND VPWR sky130_fd_sc_hd__tapvpwrvgnd_1
XFILLER_67_337 VGND VGND VPWR VPWR sky130_fd_sc_hd__decap_3
XFILLER_95_635 VGND VGND VPWR VPWR sky130_fd_sc_hd__fill_1
X_3060_ _5808_/Q _5744_/Q _3060_/S VGND VGND VPWR VPWR _3060_/X sky130_fd_sc_hd__mux2_1
XTAP_TAPCELL_ROW_38_708 VGND VPWR sky130_fd_sc_hd__tapvpwrvgnd_1
XFILLER_48_595 VGND VGND VPWR VPWR sky130_fd_sc_hd__fill_1
XFILLER_63_521 VGND VGND VPWR VPWR sky130_fd_sc_hd__fill_1
XFILLER_35_223 VGND VGND VPWR VPWR sky130_fd_sc_hd__fill_1
XFILLER_35_278 VGND VGND VPWR VPWR sky130_fd_sc_hd__fill_2
XFILLER_50_215 VGND VGND VPWR VPWR sky130_fd_sc_hd__fill_1
XTAP_TAPCELL_ROW_18_465 VGND VPWR sky130_fd_sc_hd__tapvpwrvgnd_1
XTAP_TAPCELL_ROW_46_796 VGND VPWR sky130_fd_sc_hd__tapvpwrvgnd_1
X_5701_ _5925_/CLK _5701_/D VGND VGND VPWR VPWR _5701_/Q sky130_fd_sc_hd__dfxtp_2
X_3962_ _4653_/A1 wire546/X wire325/X _3962_/B2 VGND VGND VPWR VPWR _5058_/D sky130_fd_sc_hd__a22o_2
X_3893_ _5717_/Q _5685_/Q _5653_/Q _5621_/Q _3847_/S _3893_/S1 VGND VGND VPWR VPWR
+ _3893_/X sky130_fd_sc_hd__mux4_2
X_2913_ _6057_/Q _5961_/Q _2913_/S VGND VGND VPWR VPWR _2913_/X sky130_fd_sc_hd__mux2_1
XFILLER_31_495 VGND VGND VPWR VPWR sky130_fd_sc_hd__fill_1
X_5632_ _5934_/CLK _5632_/D VGND VGND VPWR VPWR _5632_/Q sky130_fd_sc_hd__dfxtp_2
X_2844_ _2987_/A _2844_/B VGND VGND VPWR VPWR _2844_/X sky130_fd_sc_hd__or2_2
X_5563_ _5659_/CLK _5563_/D VGND VGND VPWR VPWR _5563_/Q sky130_fd_sc_hd__dfxtp_2
XFILLER_8_680 VGND VGND VPWR VPWR sky130_fd_sc_hd__decap_3
X_4514_ _4514_/A1 _4535_/A2 _4528_/B1 _4514_/B2 VGND VGND VPWR VPWR _5568_/D sky130_fd_sc_hd__a22o_2
X_2775_ _5923_/Q _5891_/Q _5859_/Q _5763_/Q _2777_/S _3013_/S1 VGND VGND VPWR VPWR
+ _2775_/X sky130_fd_sc_hd__mux4_2
X_5494_ _5797_/CLK _5494_/D VGND VGND VPWR VPWR _5494_/Q sky130_fd_sc_hd__dfxtp_2
X_4445_ _4719_/A1 _4468_/A2 _4453_/B1 _4445_/B2 VGND VGND VPWR VPWR _5503_/D sky130_fd_sc_hd__a22o_2
Xfanout615 _3842_/A1 VGND VGND VPWR VPWR _3944_/A1 sky130_fd_sc_hd__dlymetal6s2s_1
Xfanout604 _3842_/A1 VGND VGND VPWR VPWR _3896_/B2 sky130_fd_sc_hd__buf_4
X_4376_ _4719_/A1 _4399_/A2 wire238/X _4376_/B2 VGND VGND VPWR VPWR _5439_/D sky130_fd_sc_hd__a22o_2
XFILLER_85_101 VGND VGND VPWR VPWR sky130_fd_sc_hd__decap_3
Xfanout648 fanout656/X VGND VGND VPWR VPWR _2949_/B2 sky130_fd_sc_hd__clkdlybuf4s25_1
Xfanout637 _2522_/X VGND VGND VPWR VPWR _3196_/C1 sky130_fd_sc_hd__clkdlybuf4s25_1
X_3327_ _3713_/A1 _3325_/X _3326_/X _3713_/B2 VGND VGND VPWR VPWR _3327_/X sky130_fd_sc_hd__o22a_2
X_6046_ _6046_/CLK _6046_/D VGND VGND VPWR VPWR _6046_/Q sky130_fd_sc_hd__dfxtp_2
X_3258_ _3906_/A _3258_/B VGND VGND VPWR VPWR _3258_/X sky130_fd_sc_hd__or2_2
X_3189_ _5526_/Q _5494_/Q _3204_/S VGND VGND VPWR VPWR _3189_/X sky130_fd_sc_hd__mux2_1
XFILLER_26_234 VGND VGND VPWR VPWR sky130_fd_sc_hd__fill_2
XFILLER_26_267 VGND VGND VPWR VPWR sky130_fd_sc_hd__decap_3
XFILLER_6_606 VGND VGND VPWR VPWR sky130_fd_sc_hd__decap_3
XFILLER_10_679 VGND VGND VPWR VPWR sky130_fd_sc_hd__decap_3
XFILLER_108_567 VGND VGND VPWR VPWR sky130_fd_sc_hd__decap_3
XTAP_TAPCELL_ROW_114_1618 VGND VPWR sky130_fd_sc_hd__tapvpwrvgnd_1
XFILLER_78_56 VGND VGND VPWR VPWR sky130_fd_sc_hd__fill_1
XFILLER_49_337 VGND VGND VPWR VPWR sky130_fd_sc_hd__decap_3
XFILLER_94_11 VGND VGND VPWR VPWR sky130_fd_sc_hd__decap_3
XFILLER_76_145 VGND VGND VPWR VPWR sky130_fd_sc_hd__decap_3
Xhold2070 _5377_/Q VGND VGND VPWR VPWR _4309_/B2 sky130_fd_sc_hd__dlygate4sd3_1
Xhold2081 _5320_/Q VGND VGND VPWR VPWR _4248_/B2 sky130_fd_sc_hd__dlygate4sd3_1
Xhold2092 _5818_/Q VGND VGND VPWR VPWR _4780_/B sky130_fd_sc_hd__dlygate4sd3_1
Xhold1380 _5742_/Q VGND VGND VPWR VPWR _4699_/B2 sky130_fd_sc_hd__dlygate4sd3_1
Xhold1391 _5441_/Q VGND VGND VPWR VPWR _4378_/B2 sky130_fd_sc_hd__dlygate4sd3_1
XTAP_TAPCELL_ROW_15_424 VGND VPWR sky130_fd_sc_hd__tapvpwrvgnd_1
XTAP_TAPCELL_ROW_15_435 VGND VPWR sky130_fd_sc_hd__tapvpwrvgnd_1
XTAP_TAPCELL_ROW_43_766 VGND VPWR sky130_fd_sc_hd__tapvpwrvgnd_1
XFILLER_9_444 VGND VGND VPWR VPWR sky130_fd_sc_hd__decap_3
XFILLER_64_6 VGND VGND VPWR VPWR sky130_fd_sc_hd__decap_3
XFILLER_9_488 VGND VGND VPWR VPWR sky130_fd_sc_hd__fill_2
XFILLER_5_650 VGND VGND VPWR VPWR sky130_fd_sc_hd__decap_3
X_2560_ _3183_/A1 _2556_/X _2559_/X _3184_/A1 VGND VGND VPWR VPWR _2561_/B sky130_fd_sc_hd__a22o_2
XFILLER_114_526 VGND VGND VPWR VPWR sky130_fd_sc_hd__decap_3
X_4230_ _5014_/A _4298_/B VGND VGND VPWR VPWR _4230_/Y sky130_fd_sc_hd__nor2_2
XFILLER_4_53 VGND VGND VPWR VPWR sky130_fd_sc_hd__decap_3
X_4161_ _4878_/A _4161_/B VGND VGND VPWR VPWR _4161_/Y sky130_fd_sc_hd__nor2_2
X_4092_ input1/X input2/X VGND VGND VPWR VPWR _5014_/A sky130_fd_sc_hd__nand2b_2
X_3112_ wire559/X _3108_/X _3111_/X _3106_/X VGND VGND VPWR VPWR _3112_/X sky130_fd_sc_hd__a31o_2
XFILLER_83_638 VGND VGND VPWR VPWR sky130_fd_sc_hd__decap_3
X_3043_ _5263_/Q _5231_/Q _5199_/Q _5167_/Q _3188_/S _3202_/S1 VGND VGND VPWR VPWR
+ _3044_/B sky130_fd_sc_hd__mux4_2
XFILLER_36_587 VGND VGND VPWR VPWR sky130_fd_sc_hd__fill_1
XFILLER_51_513 VGND VGND VPWR VPWR sky130_fd_sc_hd__fill_2
XFILLER_63_362 VGND VGND VPWR VPWR sky130_fd_sc_hd__fill_1
XFILLER_91_660 VGND VGND VPWR VPWR sky130_fd_sc_hd__decap_3
XFILLER_36_598 VGND VGND VPWR VPWR sky130_fd_sc_hd__decap_3
XFILLER_90_170 VGND VGND VPWR VPWR sky130_fd_sc_hd__fill_2
X_4994_ _4994_/A1 _5010_/A2 _5010_/B1 _4994_/B2 VGND VGND VPWR VPWR _6020_/D sky130_fd_sc_hd__a22o_2
XFILLER_23_18 VGND VGND VPWR VPWR sky130_fd_sc_hd__fill_1
X_3945_ _3253_/X _3941_/X _3944_/X _3928_/X _3248_/X VGND VGND VPWR VPWR _3945_/X
+ sky130_fd_sc_hd__a32o_2
XFILLER_31_281 VGND VGND VPWR VPWR sky130_fd_sc_hd__fill_1
X_5615_ _5871_/CLK _5615_/D VGND VGND VPWR VPWR _5615_/Q sky130_fd_sc_hd__dfxtp_2
X_3876_ wire630/X _3867_/X _3869_/X _3922_/B1 _3860_/X VGND VGND VPWR VPWR _3876_/X
+ sky130_fd_sc_hd__a32o_2
X_2827_ _5702_/Q _5670_/Q _5638_/Q _5606_/Q _3099_/S wire760/X VGND VGND VPWR VPWR
+ _2827_/X sky130_fd_sc_hd__mux4_2
X_5546_ _5578_/CLK _5546_/D VGND VGND VPWR VPWR _5546_/Q sky130_fd_sc_hd__dfxtp_2
X_2758_ _2751_/X _2757_/X _3119_/B1 VGND VGND VPWR VPWR _2758_/X sky130_fd_sc_hd__o21a_2
X_5477_ _5832_/CLK _5477_/D VGND VGND VPWR VPWR _5477_/Q sky130_fd_sc_hd__dfxtp_2
XFILLER_105_559 VGND VGND VPWR VPWR sky130_fd_sc_hd__fill_1
X_4428_ _4530_/A1 _4403_/B _4434_/B1 _4428_/B2 VGND VGND VPWR VPWR _5488_/D sky130_fd_sc_hd__a22o_2
X_2689_ _5120_/Q _5088_/Q _6016_/Q _5984_/Q _3021_/S _3164_/S1 VGND VGND VPWR VPWR
+ _2690_/B sky130_fd_sc_hd__mux4_2
Xfanout423 _4539_/Y VGND VGND VPWR VPWR _4557_/A2 sky130_fd_sc_hd__clkdlybuf4s25_1
Xfanout401 _4641_/Y VGND VGND VPWR VPWR _4673_/A2 sky130_fd_sc_hd__clkdlybuf4s25_1
XFILLER_113_581 VGND VGND VPWR VPWR sky130_fd_sc_hd__decap_3
XFILLER_58_112 VGND VGND VPWR VPWR sky130_fd_sc_hd__decap_3
XFILLER_86_432 VGND VGND VPWR VPWR sky130_fd_sc_hd__decap_3
XFILLER_98_270 VGND VGND VPWR VPWR sky130_fd_sc_hd__decap_3
Xfanout456 _4367_/Y VGND VGND VPWR VPWR _4368_/B sky130_fd_sc_hd__clkdlybuf4s25_1
Xfanout445 _4436_/Y VGND VGND VPWR VPWR _4469_/A2 sky130_fd_sc_hd__clkdlybuf4s25_1
X_4359_ _4771_/A1 _4365_/A2 _4365_/B1 _4359_/B2 VGND VGND VPWR VPWR _5425_/D sky130_fd_sc_hd__a22o_2
XFILLER_100_253 VGND VGND VPWR VPWR sky130_fd_sc_hd__decap_3
XFILLER_104_21 VGND VGND VPWR VPWR sky130_fd_sc_hd__decap_3
Xfanout478 _4264_/Y VGND VGND VPWR VPWR wire479/A sky130_fd_sc_hd__clkdlybuf4s25_1
Xfanout467 fanout469/A VGND VGND VPWR VPWR _4316_/A2 sky130_fd_sc_hd__clkdlybuf4s25_1
XFILLER_100_275 VGND VGND VPWR VPWR sky130_fd_sc_hd__decap_3
XFILLER_46_329 VGND VGND VPWR VPWR sky130_fd_sc_hd__fill_1
XFILLER_74_638 VGND VGND VPWR VPWR sky130_fd_sc_hd__decap_3
X_6029_ _6029_/CLK _6029_/D VGND VGND VPWR VPWR _6029_/Q sky130_fd_sc_hd__dfxtp_2
XFILLER_27_543 VGND VGND VPWR VPWR sky130_fd_sc_hd__decap_3
XFILLER_54_362 VGND VGND VPWR VPWR sky130_fd_sc_hd__fill_2
XFILLER_54_373 VGND VGND VPWR VPWR sky130_fd_sc_hd__fill_2
XFILLER_64_47 VGND VGND VPWR VPWR sky130_fd_sc_hd__decap_3
XTAP_TAPCELL_ROW_64_1016 VGND VPWR sky130_fd_sc_hd__tapvpwrvgnd_1
XFILLER_80_57 VGND VGND VPWR VPWR sky130_fd_sc_hd__decap_3
XTAP_TAPCELL_ROW_40_725 VGND VPWR sky130_fd_sc_hd__tapvpwrvgnd_1
XFILLER_10_421 VGND VGND VPWR VPWR sky130_fd_sc_hd__decap_3
XFILLER_13_51 VGND VGND VPWR VPWR sky130_fd_sc_hd__decap_3
XFILLER_80_79 VGND VGND VPWR VPWR sky130_fd_sc_hd__decap_3
XFILLER_6_403 VGND VGND VPWR VPWR sky130_fd_sc_hd__fill_1
XFILLER_108_331 VGND VGND VPWR VPWR sky130_fd_sc_hd__decap_3
XFILLER_13_95 VGND VGND VPWR VPWR sky130_fd_sc_hd__decap_3
XFILLER_6_469 VGND VGND VPWR VPWR sky130_fd_sc_hd__decap_3
XTAP_TAPCELL_ROW_20_493 VGND VPWR sky130_fd_sc_hd__tapvpwrvgnd_1
XFILLER_2_631 VGND VGND VPWR VPWR sky130_fd_sc_hd__decap_3
XTAP_TAPCELL_ROW_75_1145 VGND VPWR sky130_fd_sc_hd__tapvpwrvgnd_1
XFILLER_2_675 VGND VGND VPWR VPWR sky130_fd_sc_hd__decap_3
Xload_slew818 _2638_/S VGND VGND VPWR VPWR _2738_/S sky130_fd_sc_hd__buf_4
Xload_slew807 _2988_/S VGND VGND VPWR VPWR _3003_/S sky130_fd_sc_hd__buf_4
XFILLER_29_9 VGND VGND VPWR VPWR sky130_fd_sc_hd__fill_1
XFILLER_49_101 VGND VGND VPWR VPWR sky130_fd_sc_hd__decap_3
XFILLER_37_318 VGND VGND VPWR VPWR sky130_fd_sc_hd__fill_2
XTAP_TAPCELL_ROW_48_825 VGND VPWR sky130_fd_sc_hd__tapvpwrvgnd_1
Xfanout990 input17/X VGND VGND VPWR VPWR _4506_/A1 sky130_fd_sc_hd__clkdlybuf4s25_1
XFILLER_64_137 VGND VGND VPWR VPWR sky130_fd_sc_hd__decap_3
XFILLER_64_159 VGND VGND VPWR VPWR sky130_fd_sc_hd__decap_3
XFILLER_45_351 VGND VGND VPWR VPWR sky130_fd_sc_hd__fill_1
XFILLER_73_671 VGND VGND VPWR VPWR sky130_fd_sc_hd__fill_1
XTAP_TAPCELL_ROW_28_582 VGND VPWR sky130_fd_sc_hd__tapvpwrvgnd_1
XTAP_TAPCELL_ROW_86_1285 VGND VPWR sky130_fd_sc_hd__tapvpwrvgnd_1
XFILLER_13_270 VGND VGND VPWR VPWR sky130_fd_sc_hd__fill_2
XFILLER_20_207 VGND VGND VPWR VPWR sky130_fd_sc_hd__decap_3
X_3730_ _3738_/A _3727_/X _3729_/X _3261_/B VGND VGND VPWR VPWR _3730_/X sky130_fd_sc_hd__a211o_2
XFILLER_13_281 VGND VGND VPWR VPWR sky130_fd_sc_hd__decap_3
XFILLER_41_590 VGND VGND VPWR VPWR sky130_fd_sc_hd__decap_3
X_3661_ _3791_/A1 _3658_/X _3660_/X _3745_/B2 VGND VGND VPWR VPWR _3661_/X sky130_fd_sc_hd__a22o_2
XFILLER_62_3 VGND VGND VPWR VPWR sky130_fd_sc_hd__decap_3
Xclkload44 _5799_/CLK VGND VGND VPWR VPWR clkload44/Y sky130_fd_sc_hd__clkinv_2
Xclkload33 _6031_/CLK VGND VGND VPWR VPWR clkload33/Y sky130_fd_sc_hd__bufinv_16
Xclkload22 _6066_/CLK VGND VGND VPWR VPWR clkload22/X sky130_fd_sc_hd__clkbuf_8
Xclkload11 _5683_/CLK VGND VGND VPWR VPWR clkload11/Y sky130_fd_sc_hd__clkinv_2
X_5400_ _5400_/CLK _5400_/D VGND VGND VPWR VPWR _5400_/Q sky130_fd_sc_hd__dfxtp_2
X_3592_ _3687_/A _3588_/X _3591_/X _3832_/C1 VGND VGND VPWR VPWR _3592_/X sky130_fd_sc_hd__o211a_2
X_2612_ _3131_/A _2609_/X _2611_/X input9/X VGND VGND VPWR VPWR _2618_/A sky130_fd_sc_hd__o211a_2
X_5331_ _5500_/CLK _5331_/D VGND VGND VPWR VPWR _5331_/Q sky130_fd_sc_hd__dfxtp_2
X_2543_ _5913_/Q _5881_/Q _5849_/Q _5753_/Q _2604_/S _2911_/S1 VGND VGND VPWR VPWR
+ _2544_/B sky130_fd_sc_hd__mux4_2
XFILLER_114_345 VGND VGND VPWR VPWR sky130_fd_sc_hd__decap_3
XFILLER_102_518 VGND VGND VPWR VPWR sky130_fd_sc_hd__decap_3
X_5262_ _6030_/CLK _5262_/D VGND VGND VPWR VPWR _5262_/Q sky130_fd_sc_hd__dfxtp_2
XFILLER_68_432 VGND VGND VPWR VPWR sky130_fd_sc_hd__decap_3
X_5193_ _6012_/CLK _5193_/D VGND VGND VPWR VPWR _5193_/Q sky130_fd_sc_hd__dfxtp_2
X_4213_ _4727_/A1 _4197_/B _4216_/B1 _4213_/B2 VGND VGND VPWR VPWR _5287_/D sky130_fd_sc_hd__a22o_2
XFILLER_56_605 VGND VGND VPWR VPWR sky130_fd_sc_hd__fill_2
X_4144_ _4658_/A1 wire508/X wire290/X _4144_/B2 VGND VGND VPWR VPWR _5223_/D sky130_fd_sc_hd__a22o_2
XFILLER_18_29 VGND VGND VPWR VPWR sky130_fd_sc_hd__decap_3
XFILLER_28_307 VGND VGND VPWR VPWR sky130_fd_sc_hd__fill_1
XFILLER_83_413 VGND VGND VPWR VPWR sky130_fd_sc_hd__fill_1
XFILLER_110_595 VGND VGND VPWR VPWR sky130_fd_sc_hd__decap_3
XFILLER_95_295 VGND VGND VPWR VPWR sky130_fd_sc_hd__fill_1
X_4075_ _4658_/A1 wire524/X wire306/X _4075_/B2 VGND VGND VPWR VPWR _5159_/D sky130_fd_sc_hd__a22o_2
XFILLER_36_362 VGND VGND VPWR VPWR sky130_fd_sc_hd__fill_2
X_3026_ _5518_/Q _5486_/Q _3026_/S VGND VGND VPWR VPWR _3026_/X sky130_fd_sc_hd__mux2_1
XFILLER_34_17 VGND VGND VPWR VPWR sky130_fd_sc_hd__decap_3
XFILLER_63_181 VGND VGND VPWR VPWR sky130_fd_sc_hd__decap_3
Xclkbuf_leaf_90_clk clkbuf_4_6_0_clk/X VGND VGND VPWR VPWR _5525_/CLK sky130_fd_sc_hd__clkbuf_8
XFILLER_34_39 VGND VGND VPWR VPWR sky130_fd_sc_hd__decap_3
X_4977_ _5045_/A1 _4977_/A2 _4977_/B1 _4977_/B2 VGND VGND VPWR VPWR _6005_/D sky130_fd_sc_hd__a22o_2
Xclkload5 clkload5/A VGND VGND VPWR VPWR clkload5/X sky130_fd_sc_hd__clkbuf_8
X_3928_ _3928_/A1 _3925_/X _3927_/X VGND VGND VPWR VPWR _3928_/X sky130_fd_sc_hd__a21o_2
XFILLER_50_27 VGND VGND VPWR VPWR sky130_fd_sc_hd__fill_1
X_3859_ _3920_/A _3856_/X _3858_/X _3233_/Y VGND VGND VPWR VPWR _3859_/X sky130_fd_sc_hd__a22o_2
X_5529_ _5692_/CLK _5529_/D VGND VGND VPWR VPWR _5529_/Q sky130_fd_sc_hd__dfxtp_2
XFILLER_105_334 VGND VGND VPWR VPWR sky130_fd_sc_hd__fill_2
XFILLER_99_590 VGND VGND VPWR VPWR sky130_fd_sc_hd__fill_1
Xfanout220 fanout224/X VGND VGND VPWR VPWR _4467_/B1 sky130_fd_sc_hd__clkdlybuf4s25_1
XFILLER_115_53 VGND VGND VPWR VPWR sky130_fd_sc_hd__decap_3
XFILLER_59_443 VGND VGND VPWR VPWR sky130_fd_sc_hd__fill_1
Xfanout253 _4299_/Y VGND VGND VPWR VPWR _4331_/B1 sky130_fd_sc_hd__clkdlybuf4s25_1
XFILLER_101_573 VGND VGND VPWR VPWR sky130_fd_sc_hd__decap_3
XFILLER_115_75 VGND VGND VPWR VPWR sky130_fd_sc_hd__decap_3
XFILLER_115_97 VGND VGND VPWR VPWR sky130_fd_sc_hd__decap_3
XFILLER_75_24 VGND VGND VPWR VPWR sky130_fd_sc_hd__fill_1
XFILLER_75_46 VGND VGND VPWR VPWR sky130_fd_sc_hd__fill_2
XTAP_TAPCELL_ROW_70_1086 VGND VPWR sky130_fd_sc_hd__tapvpwrvgnd_1
Xfanout297 fanout299/X VGND VGND VPWR VPWR wire298/A sky130_fd_sc_hd__clkdlybuf4s25_1
Xfanout275 wire283/X VGND VGND VPWR VPWR _4168_/B1 sky130_fd_sc_hd__clkdlybuf4s25_1
XFILLER_46_137 VGND VGND VPWR VPWR sky130_fd_sc_hd__decap_3
XFILLER_27_351 VGND VGND VPWR VPWR sky130_fd_sc_hd__fill_1
XFILLER_70_630 VGND VGND VPWR VPWR sky130_fd_sc_hd__decap_3
XFILLER_91_12 VGND VGND VPWR VPWR sky130_fd_sc_hd__decap_3
Xclkbuf_leaf_81_clk clkbuf_4_4_0_clk/X VGND VGND VPWR VPWR _6042_/CLK sky130_fd_sc_hd__clkbuf_8
XFILLER_70_685 VGND VGND VPWR VPWR sky130_fd_sc_hd__decap_3
XTAP_TAPCELL_ROW_25_552 VGND VPWR sky130_fd_sc_hd__tapvpwrvgnd_1
XTAP_TAPCELL_ROW_53_883 VGND VPWR sky130_fd_sc_hd__tapvpwrvgnd_1
XFILLER_23_590 VGND VGND VPWR VPWR sky130_fd_sc_hd__decap_3
Xwire643 wire643/A VGND VGND VPWR VPWR wire643/X sky130_fd_sc_hd__clkbuf_4
XFILLER_109_651 VGND VGND VPWR VPWR sky130_fd_sc_hd__decap_3
Xwire676 wire676/A VGND VGND VPWR VPWR wire676/X sky130_fd_sc_hd__buf_4
XFILLER_108_150 VGND VGND VPWR VPWR sky130_fd_sc_hd__decap_3
XFILLER_109_673 VGND VGND VPWR VPWR sky130_fd_sc_hd__decap_3
XFILLER_115_109 VGND VGND VPWR VPWR sky130_fd_sc_hd__decap_3
XFILLER_40_71 VGND VGND VPWR VPWR sky130_fd_sc_hd__decap_3
XFILLER_97_505 VGND VGND VPWR VPWR sky130_fd_sc_hd__decap_3
XFILLER_111_304 VGND VGND VPWR VPWR sky130_fd_sc_hd__fill_2
XFILLER_111_337 VGND VGND VPWR VPWR sky130_fd_sc_hd__decap_3
XFILLER_27_6 VGND VGND VPWR VPWR sky130_fd_sc_hd__decap_3
XFILLER_2_494 VGND VGND VPWR VPWR sky130_fd_sc_hd__decap_3
XFILLER_1_21 VGND VGND VPWR VPWR sky130_fd_sc_hd__decap_3
XTAP_TAPCELL_ROW_88_1303 VGND VPWR sky130_fd_sc_hd__tapvpwrvgnd_1
XFILLER_1_54 VGND VGND VPWR VPWR sky130_fd_sc_hd__fill_2
XFILLER_46_682 VGND VGND VPWR VPWR sky130_fd_sc_hd__decap_3
XFILLER_65_90 VGND VGND VPWR VPWR sky130_fd_sc_hd__decap_3
XFILLER_80_427 VGND VGND VPWR VPWR sky130_fd_sc_hd__fill_1
XFILLER_92_298 VGND VGND VPWR VPWR sky130_fd_sc_hd__fill_2
X_5880_ _6064_/CLK _5880_/D VGND VGND VPWR VPWR _5880_/Q sky130_fd_sc_hd__dfxtp_2
X_4900_ _5036_/A1 wire360/X wire144/X _4900_/B2 VGND VGND VPWR VPWR _5932_/D sky130_fd_sc_hd__a22o_2
XFILLER_61_652 VGND VGND VPWR VPWR sky130_fd_sc_hd__fill_1
Xclkbuf_leaf_72_clk clkload3/A VGND VGND VPWR VPWR _6013_/CLK sky130_fd_sc_hd__clkbuf_8
X_4831_ _4899_/A1 _4811_/B wire156/X _4831_/B2 VGND VGND VPWR VPWR _5867_/D sky130_fd_sc_hd__a22o_2
X_4762_ _4762_/A1 _4762_/A2 _4762_/B1 _4762_/B2 VGND VGND VPWR VPWR _5800_/D sky130_fd_sc_hd__a22o_2
X_4693_ _4762_/A1 _4693_/A2 _4693_/B1 _4693_/B2 VGND VGND VPWR VPWR _5736_/D sky130_fd_sc_hd__a22o_2
X_3713_ _3713_/A1 _3711_/X _3712_/X _3713_/B2 VGND VGND VPWR VPWR _3713_/X sky130_fd_sc_hd__o22a_2
XTAP_TAPCELL_ROW_99_1443 VGND VPWR sky130_fd_sc_hd__tapvpwrvgnd_1
XTAP_TAPCELL_ROW_99_1432 VGND VPWR sky130_fd_sc_hd__tapvpwrvgnd_1
X_3644_ _5802_/Q _5738_/Q _3644_/S VGND VGND VPWR VPWR _3644_/X sky130_fd_sc_hd__mux2_1
XFILLER_115_610 VGND VGND VPWR VPWR sky130_fd_sc_hd__decap_3
XFILLER_115_632 VGND VGND VPWR VPWR sky130_fd_sc_hd__decap_3
X_3575_ _5511_/Q _5479_/Q _3575_/S VGND VGND VPWR VPWR _3575_/X sky130_fd_sc_hd__mux2_1
XFILLER_115_654 VGND VGND VPWR VPWR sky130_fd_sc_hd__decap_3
XFILLER_115_676 VGND VGND VPWR VPWR sky130_fd_sc_hd__decap_3
X_5314_ _5704_/CLK _5314_/D VGND VGND VPWR VPWR _5314_/Q sky130_fd_sc_hd__dfxtp_2
X_2526_ _2512_/X _2524_/X _2525_/X wire570/X VGND VGND VPWR VPWR _2526_/X sky130_fd_sc_hd__o31a_2
XFILLER_88_527 VGND VGND VPWR VPWR sky130_fd_sc_hd__decap_3
X_5245_ _5810_/CLK _5245_/D VGND VGND VPWR VPWR _5245_/Q sky130_fd_sc_hd__dfxtp_2
XFILLER_114_197 VGND VGND VPWR VPWR sky130_fd_sc_hd__decap_3
Xhold1902 _5215_/Q VGND VGND VPWR VPWR _4136_/B2 sky130_fd_sc_hd__dlygate4sd3_1
Xhold1913 _5678_/Q VGND VGND VPWR VPWR _4631_/B2 sky130_fd_sc_hd__dlygate4sd3_1
Xhold1924 _5347_/Q VGND VGND VPWR VPWR _4277_/B2 sky130_fd_sc_hd__dlygate4sd3_1
Xhold1935 _5253_/Q VGND VGND VPWR VPWR _4176_/B2 sky130_fd_sc_hd__dlygate4sd3_1
X_5176_ _6038_/CLK _5176_/D VGND VGND VPWR VPWR _5176_/Q sky130_fd_sc_hd__dfxtp_2
XFILLER_28_115 VGND VGND VPWR VPWR sky130_fd_sc_hd__fill_2
Xhold1946 _5234_/Q VGND VGND VPWR VPWR _4155_/B2 sky130_fd_sc_hd__dlygate4sd3_1
Xhold1957 _5440_/Q VGND VGND VPWR VPWR _4377_/B2 sky130_fd_sc_hd__dlygate4sd3_1
Xhold1968 _5553_/Q VGND VGND VPWR VPWR _4497_/B2 sky130_fd_sc_hd__dlygate4sd3_1
X_4127_ _4844_/A _4161_/B VGND VGND VPWR VPWR _4127_/Y sky130_fd_sc_hd__nor2_2
XTAP_TAPCELL_ROW_108_1550 VGND VPWR sky130_fd_sc_hd__tapvpwrvgnd_1
Xhold1979 _5371_/Q VGND VGND VPWR VPWR _4303_/B2 sky130_fd_sc_hd__dlygate4sd3_1
X_4058_ _4946_/B _4161_/B VGND VGND VPWR VPWR _4058_/Y sky130_fd_sc_hd__nor2_2
X_3009_ _5838_/Q _5454_/Q _3015_/S VGND VGND VPWR VPWR _3009_/X sky130_fd_sc_hd__mux2_1
XFILLER_52_630 VGND VGND VPWR VPWR sky130_fd_sc_hd__decap_3
Xclkbuf_leaf_63_clk clkbuf_4_12_0_clk/X VGND VGND VPWR VPWR _5704_/CLK sky130_fd_sc_hd__clkbuf_8
XFILLER_101_55 VGND VGND VPWR VPWR sky130_fd_sc_hd__fill_1
XFILLER_12_505 VGND VGND VPWR VPWR sky130_fd_sc_hd__decap_3
XFILLER_24_365 VGND VGND VPWR VPWR sky130_fd_sc_hd__decap_3
XTAP_TAPCELL_ROW_22_511 VGND VPWR sky130_fd_sc_hd__tapvpwrvgnd_1
XTAP_TAPCELL_ROW_50_853 VGND VPWR sky130_fd_sc_hd__tapvpwrvgnd_1
XFILLER_106_643 VGND VGND VPWR VPWR sky130_fd_sc_hd__fill_1
XFILLER_3_225 VGND VGND VPWR VPWR sky130_fd_sc_hd__decap_3
XFILLER_106_654 VGND VGND VPWR VPWR sky130_fd_sc_hd__decap_3
XTAP_TAPCELL_ROW_72_1115 VGND VPWR sky130_fd_sc_hd__tapvpwrvgnd_1
XFILLER_105_164 VGND VGND VPWR VPWR sky130_fd_sc_hd__decap_3
XFILLER_106_687 VGND VGND VPWR VPWR sky130_fd_sc_hd__fill_1
XFILLER_10_96 VGND VGND VPWR VPWR sky130_fd_sc_hd__fill_1
XFILLER_79_538 VGND VGND VPWR VPWR sky130_fd_sc_hd__decap_3
Xfanout1037 input12/X VGND VGND VPWR VPWR wire1038/A sky130_fd_sc_hd__dlymetal6s4s_1
Xfanout1015 input13/X VGND VGND VPWR VPWR _3920_/A sky130_fd_sc_hd__clkdlybuf4s25_1
XFILLER_94_519 VGND VGND VPWR VPWR sky130_fd_sc_hd__fill_2
Xfanout1048 _3940_/S1 VGND VGND VPWR VPWR _3686_/S1 sky130_fd_sc_hd__buf_4
XTAP_TAPCELL_ROW_58_942 VGND VPWR sky130_fd_sc_hd__tapvpwrvgnd_1
XFILLER_34_107 VGND VGND VPWR VPWR sky130_fd_sc_hd__decap_3
XFILLER_15_343 VGND VGND VPWR VPWR sky130_fd_sc_hd__decap_3
Xclkbuf_leaf_54_clk clkload6/A VGND VGND VPWR VPWR _6023_/CLK sky130_fd_sc_hd__clkbuf_8
XTAP_TAPCELL_ROW_83_1244 VGND VPWR sky130_fd_sc_hd__tapvpwrvgnd_1
XFILLER_35_93 VGND VGND VPWR VPWR sky130_fd_sc_hd__fill_2
XFILLER_96_9 VGND VGND VPWR VPWR sky130_fd_sc_hd__decap_3
XFILLER_30_324 VGND VGND VPWR VPWR sky130_fd_sc_hd__decap_3
XFILLER_7_553 VGND VGND VPWR VPWR sky130_fd_sc_hd__decap_3
XFILLER_7_564 VGND VGND VPWR VPWR sky130_fd_sc_hd__decap_3
Xwire462 wire462/A VGND VGND VPWR VPWR wire462/X sky130_fd_sc_hd__clkbuf_4
X_3360_ _3781_/C1 _3359_/X _3356_/X _3471_/B1 VGND VGND VPWR VPWR _3372_/B sky130_fd_sc_hd__a211o_2
XTAP_TAPCELL_ROW_94_1373 VGND VPWR sky130_fd_sc_hd__tapvpwrvgnd_1
XFILLER_112_613 VGND VGND VPWR VPWR sky130_fd_sc_hd__decap_3
XFILLER_97_313 VGND VGND VPWR VPWR sky130_fd_sc_hd__fill_1
Xload_slew412 _4608_/B VGND VGND VPWR VPWR _4634_/A2 sky130_fd_sc_hd__buf_4
XFILLER_112_657 VGND VGND VPWR VPWR sky130_fd_sc_hd__decap_3
Xload_slew434 _4494_/A2 VGND VGND VPWR VPWR _4501_/A2 sky130_fd_sc_hd__clkbuf_4
X_5030_ _5030_/A1 _5045_/A2 _5045_/B1 _5030_/B2 VGND VGND VPWR VPWR _6054_/D sky130_fd_sc_hd__a22o_2
X_3291_ _3708_/A1 _3288_/X _3290_/X _3881_/B2 VGND VGND VPWR VPWR _3291_/X sky130_fd_sc_hd__a22o_2
XFILLER_25_3 VGND VGND VPWR VPWR sky130_fd_sc_hd__decap_3
XFILLER_85_519 VGND VGND VPWR VPWR sky130_fd_sc_hd__decap_3
Xhold1209 _6049_/Q VGND VGND VPWR VPWR _5025_/B2 sky130_fd_sc_hd__dlygate4sd3_1
XFILLER_65_254 VGND VGND VPWR VPWR sky130_fd_sc_hd__fill_2
XFILLER_19_671 VGND VGND VPWR VPWR sky130_fd_sc_hd__fill_1
XFILLER_65_276 VGND VGND VPWR VPWR sky130_fd_sc_hd__decap_3
XTAP_TAPCELL_ROW_0_239 VGND VPWR sky130_fd_sc_hd__tapvpwrvgnd_1
X_5932_ _5932_/CLK _5932_/D VGND VGND VPWR VPWR _5932_/Q sky130_fd_sc_hd__dfxtp_2
Xclkbuf_leaf_45_clk clkbuf_4_14_0_clk/X VGND VGND VPWR VPWR _6065_/CLK sky130_fd_sc_hd__clkbuf_8
X_5863_ _5943_/CLK _5863_/D VGND VGND VPWR VPWR _5863_/Q sky130_fd_sc_hd__dfxtp_2
XTAP_TAPCELL_ROW_103_1480 VGND VPWR sky130_fd_sc_hd__tapvpwrvgnd_1
X_5794_ _5794_/CLK _5794_/D VGND VGND VPWR VPWR _5794_/Q sky130_fd_sc_hd__dfxtp_2
X_4814_ _5018_/A1 wire371/X wire153/A _4814_/B2 VGND VGND VPWR VPWR _5850_/D sky130_fd_sc_hd__a22o_2
XTAP_TAPCELL_ROW_103_1491 VGND VPWR sky130_fd_sc_hd__tapvpwrvgnd_1
X_4745_ _4745_/A _4745_/B VGND VGND VPWR VPWR _4745_/Y sky130_fd_sc_hd__nor2_2
X_4676_ _4745_/A _4676_/B VGND VGND VPWR VPWR _4676_/Y sky130_fd_sc_hd__nor2_2
X_3627_ _5833_/Q _5449_/Q _6057_/Q _5961_/Q _3284_/S _3627_/S1 VGND VGND VPWR VPWR
+ _3628_/B sky130_fd_sc_hd__mux4_2
X_3558_ _5798_/Q _5734_/Q _3558_/S VGND VGND VPWR VPWR _3558_/X sky130_fd_sc_hd__mux2_1
XFILLER_103_635 VGND VGND VPWR VPWR sky130_fd_sc_hd__fill_1
X_2509_ _6040_/Q _5944_/Q _2510_/S VGND VGND VPWR VPWR _2509_/X sky130_fd_sc_hd__mux2_1
XFILLER_102_123 VGND VGND VPWR VPWR sky130_fd_sc_hd__decap_3
XFILLER_88_335 VGND VGND VPWR VPWR sky130_fd_sc_hd__fill_2
X_3489_ _3745_/B2 _3486_/X _3488_/X VGND VGND VPWR VPWR _3489_/X sky130_fd_sc_hd__a21o_2
XFILLER_102_178 VGND VGND VPWR VPWR sky130_fd_sc_hd__decap_3
XFILLER_103_679 VGND VGND VPWR VPWR sky130_fd_sc_hd__decap_3
Xhold1710 _5139_/Q VGND VGND VPWR VPWR _4051_/B2 sky130_fd_sc_hd__dlygate4sd3_1
X_5228_ _6026_/CLK _5228_/D VGND VGND VPWR VPWR _5228_/Q sky130_fd_sc_hd__dfxtp_2
XFILLER_84_530 VGND VGND VPWR VPWR sky130_fd_sc_hd__fill_2
Xhold1721 _5290_/Q VGND VGND VPWR VPWR _4216_/B2 sky130_fd_sc_hd__dlygate4sd3_1
Xhold1732 _5631_/Q VGND VGND VPWR VPWR _4582_/B2 sky130_fd_sc_hd__dlygate4sd3_1
Xhold1743 _5702_/Q VGND VGND VPWR VPWR _4657_/B2 sky130_fd_sc_hd__dlygate4sd3_1
X_5159_ _5258_/CLK _5159_/D VGND VGND VPWR VPWR _5159_/Q sky130_fd_sc_hd__dfxtp_2
XFILLER_112_10 VGND VGND VPWR VPWR sky130_fd_sc_hd__decap_3
Xhold1754 _5049_/Q VGND VGND VPWR VPWR _3953_/B2 sky130_fd_sc_hd__dlygate4sd3_1
Xhold1765 _5224_/Q VGND VGND VPWR VPWR _4145_/B2 sky130_fd_sc_hd__dlygate4sd3_1
Xhold1776 _5383_/Q VGND VGND VPWR VPWR _4315_/B2 sky130_fd_sc_hd__dlygate4sd3_1
Xhold1787 _5403_/Q VGND VGND VPWR VPWR _4337_/B2 sky130_fd_sc_hd__dlygate4sd3_1
XFILLER_112_32 VGND VGND VPWR VPWR sky130_fd_sc_hd__decap_3
XTAP_TAPCELL_ROW_55_912 VGND VPWR sky130_fd_sc_hd__tapvpwrvgnd_1
Xhold1798 _5218_/Q VGND VGND VPWR VPWR _4139_/B2 sky130_fd_sc_hd__dlygate4sd3_1
XFILLER_112_65 VGND VGND VPWR VPWR sky130_fd_sc_hd__decap_3
XFILLER_72_25 VGND VGND VPWR VPWR sky130_fd_sc_hd__decap_3
Xclkbuf_leaf_36_clk clkload4/A VGND VGND VPWR VPWR _6021_/CLK sky130_fd_sc_hd__clkbuf_8
XFILLER_12_302 VGND VGND VPWR VPWR sky130_fd_sc_hd__decap_3
XFILLER_25_685 VGND VGND VPWR VPWR sky130_fd_sc_hd__decap_3
XFILLER_40_600 VGND VGND VPWR VPWR sky130_fd_sc_hd__decap_3
XFILLER_8_339 VGND VGND VPWR VPWR sky130_fd_sc_hd__fill_2
XFILLER_20_390 VGND VGND VPWR VPWR sky130_fd_sc_hd__fill_2
XFILLER_21_51 VGND VGND VPWR VPWR sky130_fd_sc_hd__decap_3
XFILLER_4_523 VGND VGND VPWR VPWR sky130_fd_sc_hd__fill_1
XFILLER_11_9 VGND VGND VPWR VPWR sky130_fd_sc_hd__decap_3
XFILLER_47_221 VGND VGND VPWR VPWR sky130_fd_sc_hd__decap_3
XFILLER_94_349 VGND VGND VPWR VPWR sky130_fd_sc_hd__decap_3
Xclkbuf_leaf_27_clk clkbuf_4_10_0_clk/X VGND VGND VPWR VPWR _5572_/CLK sky130_fd_sc_hd__clkbuf_8
XFILLER_15_162 VGND VGND VPWR VPWR sky130_fd_sc_hd__decap_3
XFILLER_43_471 VGND VGND VPWR VPWR sky130_fd_sc_hd__decap_3
XFILLER_50_419 VGND VGND VPWR VPWR sky130_fd_sc_hd__fill_1
X_2860_ _5127_/Q _5095_/Q _6023_/Q _5991_/Q _2863_/S _3214_/S1 VGND VGND VPWR VPWR
+ _2861_/B sky130_fd_sc_hd__mux4_2
XFILLER_30_187 VGND VGND VPWR VPWR sky130_fd_sc_hd__fill_1
X_2791_ _3058_/A _2787_/X _2790_/X _3179_/A1 VGND VGND VPWR VPWR _2791_/X sky130_fd_sc_hd__o211a_2
XFILLER_7_42 VGND VGND VPWR VPWR sky130_fd_sc_hd__decap_3
X_4530_ _4530_/A1 _4505_/B _4530_/B1 _4530_/B2 VGND VGND VPWR VPWR _5584_/D sky130_fd_sc_hd__a22o_2
XTAP_TAPCELL_ROW_96_1402 VGND VPWR sky130_fd_sc_hd__tapvpwrvgnd_1
Xwire281 wire281/A VGND VGND VPWR VPWR wire281/X sky130_fd_sc_hd__clkbuf_4
Xwire292 wire292/A VGND VGND VPWR VPWR wire292/X sky130_fd_sc_hd__buf_4
X_4461_ _4529_/A1 _4468_/A2 _4468_/B1 _4461_/B2 VGND VGND VPWR VPWR _5519_/D sky130_fd_sc_hd__a22o_2
X_3412_ _3454_/A _3412_/B VGND VGND VPWR VPWR _3412_/X sky130_fd_sc_hd__or2_2
XFILLER_98_633 VGND VGND VPWR VPWR sky130_fd_sc_hd__decap_3
X_4392_ _5039_/A1 _4399_/A2 wire238/X _4392_/B2 VGND VGND VPWR VPWR _5455_/D sky130_fd_sc_hd__a22o_2
XFILLER_97_121 VGND VGND VPWR VPWR sky130_fd_sc_hd__decap_3
XTAP_TAPCELL_ROW_5_309 VGND VPWR sky130_fd_sc_hd__tapvpwrvgnd_1
Xload_slew231 _4419_/B1 VGND VGND VPWR VPWR _4434_/B1 sky130_fd_sc_hd__clkbuf_4
Xfanout819 _2736_/S0 VGND VGND VPWR VPWR _3110_/S sky130_fd_sc_hd__clkbuf_4
Xfanout808 _3104_/S VGND VGND VPWR VPWR _2993_/S sky130_fd_sc_hd__dlymetal6s4s_1
X_3343_ _5820_/Q _5436_/Q _6044_/Q _5948_/Q _3616_/S _3627_/S1 VGND VGND VPWR VPWR
+ _3343_/X sky130_fd_sc_hd__mux4_2
XFILLER_97_165 VGND VGND VPWR VPWR sky130_fd_sc_hd__decap_3
Xload_slew264 _4253_/B1 VGND VGND VPWR VPWR _4261_/B1 sky130_fd_sc_hd__buf_2
X_6062_ _6062_/CLK _6062_/D VGND VGND VPWR VPWR _6062_/Q sky130_fd_sc_hd__dfxtp_2
X_3274_ _3632_/A _3272_/X _3273_/X _3347_/A VGND VGND VPWR VPWR _3274_/X sky130_fd_sc_hd__o22a_2
XFILLER_66_530 VGND VGND VPWR VPWR sky130_fd_sc_hd__fill_2
Xload_slew286 _4134_/B1 VGND VGND VPWR VPWR _4158_/B1 sky130_fd_sc_hd__buf_4
X_5013_ _5013_/A1 _5013_/A2 _5013_/B1 _5013_/B2 VGND VGND VPWR VPWR _6039_/D sky130_fd_sc_hd__a22o_2
XFILLER_66_541 VGND VGND VPWR VPWR sky130_fd_sc_hd__decap_3
XFILLER_26_29 VGND VGND VPWR VPWR sky130_fd_sc_hd__fill_1
XFILLER_66_585 VGND VGND VPWR VPWR sky130_fd_sc_hd__decap_3
XFILLER_93_360 VGND VGND VPWR VPWR sky130_fd_sc_hd__decap_3
XFILLER_93_393 VGND VGND VPWR VPWR sky130_fd_sc_hd__fill_2
XPHY_EDGE_ROW_5_Right_5 VGND VGND VPWR VPWR sky130_fd_sc_hd__decap_3
Xclkbuf_leaf_18_clk clkbuf_4_8_0_clk/X VGND VGND VPWR VPWR _5963_/CLK sky130_fd_sc_hd__clkbuf_8
X_5915_ _6042_/CLK _5915_/D VGND VGND VPWR VPWR _5915_/Q sky130_fd_sc_hd__dfxtp_2
XFILLER_22_633 VGND VGND VPWR VPWR sky130_fd_sc_hd__decap_3
X_5846_ _5925_/CLK _5846_/D VGND VGND VPWR VPWR _5846_/Q sky130_fd_sc_hd__dfxtp_2
XFILLER_21_143 VGND VGND VPWR VPWR sky130_fd_sc_hd__decap_3
XFILLER_21_187 VGND VGND VPWR VPWR sky130_fd_sc_hd__fill_1
XTAP_TAPCELL_ROW_60_970 VGND VPWR sky130_fd_sc_hd__tapvpwrvgnd_1
X_5777_ _6065_/CLK _5777_/D VGND VGND VPWR VPWR _5777_/Q sky130_fd_sc_hd__dfxtp_2
X_2989_ _5197_/Q _5165_/Q _3104_/S VGND VGND VPWR VPWR _2989_/X sky130_fd_sc_hd__mux2_1
X_4728_ _5032_/A1 _4711_/B wire171/A _4728_/B2 VGND VGND VPWR VPWR _5768_/D sky130_fd_sc_hd__a22o_2
X_4659_ _4659_/A1 _4659_/A2 _4659_/B1 _4659_/B2 VGND VGND VPWR VPWR _5704_/D sky130_fd_sc_hd__a22o_2
XFILLER_103_410 VGND VGND VPWR VPWR sky130_fd_sc_hd__decap_3
XFILLER_107_21 VGND VGND VPWR VPWR sky130_fd_sc_hd__decap_3
XFILLER_107_54 VGND VGND VPWR VPWR sky130_fd_sc_hd__fill_2
XFILLER_115_281 VGND VGND VPWR VPWR sky130_fd_sc_hd__fill_1
XFILLER_107_87 VGND VGND VPWR VPWR sky130_fd_sc_hd__decap_3
XFILLER_69_390 VGND VGND VPWR VPWR sky130_fd_sc_hd__fill_2
Xhold1540 _5050_/Q VGND VGND VPWR VPWR _3954_/B2 sky130_fd_sc_hd__dlygate4sd3_1
Xhold1551 _5560_/Q VGND VGND VPWR VPWR _4506_/B2 sky130_fd_sc_hd__dlygate4sd3_1
Xhold1562 _5686_/Q VGND VGND VPWR VPWR _4639_/B2 sky130_fd_sc_hd__dlygate4sd3_1
Xload_slew1014 _3509_/A1 VGND VGND VPWR VPWR _3791_/A1 sky130_fd_sc_hd__buf_4
XFILLER_29_287 VGND VGND VPWR VPWR sky130_fd_sc_hd__fill_2
XFILLER_57_574 VGND VGND VPWR VPWR sky130_fd_sc_hd__fill_1
Xhold1573 _5131_/Q VGND VGND VPWR VPWR _4043_/B2 sky130_fd_sc_hd__dlygate4sd3_1
Xhold1584 _6012_/Q VGND VGND VPWR VPWR _4986_/B2 sky130_fd_sc_hd__dlygate4sd3_1
Xhold1595 _5359_/Q VGND VGND VPWR VPWR _4289_/B2 sky130_fd_sc_hd__dlygate4sd3_1
Xload_slew1036 _3469_/S1 VGND VGND VPWR VPWR _3828_/S1 sky130_fd_sc_hd__clkbuf_4
Xload_slew1047 _3648_/S1 VGND VGND VPWR VPWR _3239_/B sky130_fd_sc_hd__buf_6
XFILLER_17_438 VGND VGND VPWR VPWR sky130_fd_sc_hd__fill_2
XFILLER_29_298 VGND VGND VPWR VPWR sky130_fd_sc_hd__fill_1
XFILLER_72_533 VGND VGND VPWR VPWR sky130_fd_sc_hd__fill_2
XFILLER_83_57 VGND VGND VPWR VPWR sky130_fd_sc_hd__decap_3
XTAP_TAPCELL_ROW_67_1058 VGND VPWR sky130_fd_sc_hd__tapvpwrvgnd_1
XFILLER_16_51 VGND VGND VPWR VPWR sky130_fd_sc_hd__decap_3
XFILLER_13_633 VGND VGND VPWR VPWR sky130_fd_sc_hd__decap_3
XTAP_TAPCELL_ROW_80_1214 VGND VPWR sky130_fd_sc_hd__tapvpwrvgnd_1
XFILLER_12_132 VGND VGND VPWR VPWR sky130_fd_sc_hd__decap_3
XTAP_TAPCELL_ROW_30_609 VGND VPWR sky130_fd_sc_hd__tapvpwrvgnd_1
XFILLER_32_61 VGND VGND VPWR VPWR sky130_fd_sc_hd__decap_3
XFILLER_8_147 VGND VGND VPWR VPWR sky130_fd_sc_hd__decap_3
XTAP_TAPCELL_ROW_10_366 VGND VPWR sky130_fd_sc_hd__tapvpwrvgnd_1
XTAP_TAPCELL_ROW_78_1187 VGND VPWR sky130_fd_sc_hd__tapvpwrvgnd_1
XFILLER_4_353 VGND VGND VPWR VPWR sky130_fd_sc_hd__decap_3
XFILLER_106_270 VGND VGND VPWR VPWR sky130_fd_sc_hd__fill_1
XTAP_TAPCELL_ROW_91_1343 VGND VPWR sky130_fd_sc_hd__tapvpwrvgnd_1
XFILLER_79_143 VGND VGND VPWR VPWR sky130_fd_sc_hd__decap_3
XFILLER_0_592 VGND VGND VPWR VPWR sky130_fd_sc_hd__decap_3
XFILLER_94_135 VGND VGND VPWR VPWR sky130_fd_sc_hd__decap_3
XFILLER_94_168 VGND VGND VPWR VPWR sky130_fd_sc_hd__decap_3
XTAP_TAPCELL_ROW_38_709 VGND VPWR sky130_fd_sc_hd__tapvpwrvgnd_1
XTAP_TAPCELL_ROW_18_466 VGND VPWR sky130_fd_sc_hd__tapvpwrvgnd_1
X_3961_ _5025_/A1 wire546/A wire325/A _3961_/B2 VGND VGND VPWR VPWR _5057_/D sky130_fd_sc_hd__a22o_2
XFILLER_50_227 VGND VGND VPWR VPWR sky130_fd_sc_hd__fill_1
XTAP_TAPCELL_ROW_46_797 VGND VPWR sky130_fd_sc_hd__tapvpwrvgnd_1
X_5700_ _6052_/CLK _5700_/D VGND VGND VPWR VPWR _5700_/Q sky130_fd_sc_hd__dfxtp_2
X_2912_ _5833_/Q _5449_/Q _2913_/S VGND VGND VPWR VPWR _2912_/X sky130_fd_sc_hd__mux2_1
XFILLER_31_430 VGND VGND VPWR VPWR sky130_fd_sc_hd__decap_3
XFILLER_43_290 VGND VGND VPWR VPWR sky130_fd_sc_hd__fill_2
XFILLER_92_3 VGND VGND VPWR VPWR sky130_fd_sc_hd__decap_3
X_3892_ _3896_/B2 _3890_/X _3891_/X _3896_/A1 VGND VGND VPWR VPWR _3892_/X sky130_fd_sc_hd__o22a_2
XTAP_TAPCELL_ROW_100_1450 VGND VPWR sky130_fd_sc_hd__tapvpwrvgnd_1
X_5631_ _5825_/CLK _5631_/D VGND VGND VPWR VPWR _5631_/Q sky130_fd_sc_hd__dfxtp_2
X_2843_ _5926_/Q _5894_/Q _5862_/Q _5766_/Q _2593_/S _3102_/S1 VGND VGND VPWR VPWR
+ _2844_/B sky130_fd_sc_hd__mux4_2
X_5562_ _5658_/CLK _5562_/D VGND VGND VPWR VPWR _5562_/Q sky130_fd_sc_hd__dfxtp_2
X_2774_ _3179_/A1 _2770_/X _2773_/X _2768_/X VGND VGND VPWR VPWR _2774_/X sky130_fd_sc_hd__a31o_2
X_4513_ _4719_/A1 wire431/X _4536_/B1 _4513_/B2 VGND VGND VPWR VPWR _5567_/D sky130_fd_sc_hd__a22o_2
X_5493_ _5525_/CLK _5493_/D VGND VGND VPWR VPWR _5493_/Q sky130_fd_sc_hd__dfxtp_2
Xclkbuf_leaf_7_clk clkbuf_4_2_0_clk/X VGND VGND VPWR VPWR _5838_/CLK sky130_fd_sc_hd__clkbuf_8
X_4444_ _5022_/A1 _4467_/A2 _4467_/B1 _4444_/B2 VGND VGND VPWR VPWR _5502_/D sky130_fd_sc_hd__a22o_2
XFILLER_98_441 VGND VGND VPWR VPWR sky130_fd_sc_hd__fill_2
X_4375_ _5022_/A1 _4380_/A2 _4375_/B1 _4375_/B2 VGND VGND VPWR VPWR _5438_/D sky130_fd_sc_hd__a22o_2
Xfanout638 wire647/X VGND VGND VPWR VPWR _3178_/A1 sky130_fd_sc_hd__clkbuf_2
Xfanout627 fanout632/X VGND VGND VPWR VPWR wire628/A sky130_fd_sc_hd__clkdlybuf4s25_1
X_3326_ _5179_/Q _5147_/Q _3326_/S VGND VGND VPWR VPWR _3326_/X sky130_fd_sc_hd__mux2_1
X_6045_ _6045_/CLK _6045_/D VGND VGND VPWR VPWR _6045_/Q sky130_fd_sc_hd__dfxtp_2
XFILLER_100_446 VGND VGND VPWR VPWR sky130_fd_sc_hd__fill_2
XFILLER_100_468 VGND VGND VPWR VPWR sky130_fd_sc_hd__fill_1
X_3257_ _5112_/Q _5080_/Q _6008_/Q _5976_/Q _3508_/S _3772_/S1 VGND VGND VPWR VPWR
+ _3258_/B sky130_fd_sc_hd__mux4_2
XFILLER_39_585 VGND VGND VPWR VPWR sky130_fd_sc_hd__decap_3
X_3188_ _5590_/Q _5558_/Q _3188_/S VGND VGND VPWR VPWR _3188_/X sky130_fd_sc_hd__mux2_1
XFILLER_14_419 VGND VGND VPWR VPWR sky130_fd_sc_hd__fill_1
XFILLER_53_27 VGND VGND VPWR VPWR sky130_fd_sc_hd__decap_3
XFILLER_54_566 VGND VGND VPWR VPWR sky130_fd_sc_hd__decap_3
X_5829_ _6053_/CLK _5829_/D VGND VGND VPWR VPWR _5829_/Q sky130_fd_sc_hd__dfxtp_2
XFILLER_108_502 VGND VGND VPWR VPWR sky130_fd_sc_hd__decap_3
XFILLER_6_618 VGND VGND VPWR VPWR sky130_fd_sc_hd__decap_3
XFILLER_108_513 VGND VGND VPWR VPWR sky130_fd_sc_hd__decap_3
XTAP_TAPCELL_ROW_114_1619 VGND VPWR sky130_fd_sc_hd__tapvpwrvgnd_1
XFILLER_78_35 VGND VGND VPWR VPWR sky130_fd_sc_hd__fill_1
XFILLER_1_345 VGND VGND VPWR VPWR sky130_fd_sc_hd__decap_3
XFILLER_78_79 VGND VGND VPWR VPWR sky130_fd_sc_hd__decap_3
XFILLER_76_102 VGND VGND VPWR VPWR sky130_fd_sc_hd__decap_3
XFILLER_76_124 VGND VGND VPWR VPWR sky130_fd_sc_hd__fill_1
Xhold2060 _5480_/Q VGND VGND VPWR VPWR _4420_/B2 sky130_fd_sc_hd__dlygate4sd3_1
Xhold2071 _5559_/Q VGND VGND VPWR VPWR _4503_/B2 sky130_fd_sc_hd__dlygate4sd3_1
XFILLER_57_371 VGND VGND VPWR VPWR sky130_fd_sc_hd__decap_3
Xhold1370 _5398_/Q VGND VGND VPWR VPWR _4330_/B2 sky130_fd_sc_hd__dlygate4sd3_1
Xhold2082 _5163_/Q VGND VGND VPWR VPWR _4079_/B2 sky130_fd_sc_hd__dlygate4sd3_1
Xhold2093 _5659_/Q VGND VGND VPWR VPWR _4612_/B2 sky130_fd_sc_hd__dlygate4sd3_1
XFILLER_27_72 VGND VGND VPWR VPWR sky130_fd_sc_hd__fill_2
XFILLER_45_544 VGND VGND VPWR VPWR sky130_fd_sc_hd__decap_3
Xhold1381 _5682_/Q VGND VGND VPWR VPWR _4635_/B2 sky130_fd_sc_hd__dlygate4sd3_1
Xhold1392 _5580_/Q VGND VGND VPWR VPWR _4526_/B2 sky130_fd_sc_hd__dlygate4sd3_1
XFILLER_17_268 VGND VGND VPWR VPWR sky130_fd_sc_hd__decap_3
XTAP_TAPCELL_ROW_15_425 VGND VPWR sky130_fd_sc_hd__tapvpwrvgnd_1
XTAP_TAPCELL_ROW_43_767 VGND VPWR sky130_fd_sc_hd__tapvpwrvgnd_1
XFILLER_43_60 VGND VGND VPWR VPWR sky130_fd_sc_hd__decap_3
XFILLER_9_423 VGND VGND VPWR VPWR sky130_fd_sc_hd__decap_3
XFILLER_5_662 VGND VGND VPWR VPWR sky130_fd_sc_hd__decap_3
XFILLER_5_673 VGND VGND VPWR VPWR sky130_fd_sc_hd__decap_3
XFILLER_99_205 VGND VGND VPWR VPWR sky130_fd_sc_hd__fill_2
XFILLER_4_21 VGND VGND VPWR VPWR sky130_fd_sc_hd__decap_3
XFILLER_4_32 VGND VGND VPWR VPWR sky130_fd_sc_hd__decap_3
XFILLER_4_65 VGND VGND VPWR VPWR sky130_fd_sc_hd__fill_2
X_4160_ _5013_/A1 wire508/X wire290/X _4160_/B2 VGND VGND VPWR VPWR _5239_/D sky130_fd_sc_hd__a22o_2
X_3111_ wire647/X _3109_/X _3110_/X _3111_/B2 VGND VGND VPWR VPWR _3111_/X sky130_fd_sc_hd__o22a_2
XFILLER_67_157 VGND VGND VPWR VPWR sky130_fd_sc_hd__fill_2
X_4091_ _5013_/A1 wire526/X wire306/X _4091_/B2 VGND VGND VPWR VPWR _5175_/D sky130_fd_sc_hd__a22o_2
XFILLER_83_617 VGND VGND VPWR VPWR sky130_fd_sc_hd__fill_1
X_3042_ _3042_/A _3042_/B VGND VGND VPWR VPWR _3042_/X sky130_fd_sc_hd__or2_2
XFILLER_51_503 VGND VGND VPWR VPWR sky130_fd_sc_hd__fill_1
X_4993_ _4993_/A1 _5011_/A2 _4998_/B1 _4993_/B2 VGND VGND VPWR VPWR _6019_/D sky130_fd_sc_hd__a22o_2
XFILLER_51_569 VGND VGND VPWR VPWR sky130_fd_sc_hd__decap_3
X_3944_ _3944_/A1 _3942_/X _3943_/X _3944_/B2 VGND VGND VPWR VPWR _3944_/X sky130_fd_sc_hd__o22a_2
XFILLER_31_271 VGND VGND VPWR VPWR sky130_fd_sc_hd__fill_1
X_3875_ _3867_/A _3870_/X _3872_/X _3874_/X VGND VGND VPWR VPWR _3875_/X sky130_fd_sc_hd__o211a_2
X_5614_ _5934_/CLK _5614_/D VGND VGND VPWR VPWR _5614_/Q sky130_fd_sc_hd__dfxtp_2
X_2826_ _2814_/X _2824_/X _2825_/X wire570/A VGND VGND VPWR VPWR _2826_/X sky130_fd_sc_hd__o31a_2
X_5545_ clkload8/A _5545_/D VGND VGND VPWR VPWR _5545_/Q sky130_fd_sc_hd__dfxtp_2
X_2757_ _3118_/A1 _2740_/X _2756_/X _3118_/B2 VGND VGND VPWR VPWR _2757_/X sky130_fd_sc_hd__a22o_2
X_5476_ _5572_/CLK _5476_/D VGND VGND VPWR VPWR _5476_/Q sky130_fd_sc_hd__dfxtp_2
X_2688_ _2681_/X _2687_/X wire570/A VGND VGND VPWR VPWR _2688_/X sky130_fd_sc_hd__o21a_2
X_4427_ _4529_/A1 _4434_/A2 _4434_/B1 _4427_/B2 VGND VGND VPWR VPWR _5487_/D sky130_fd_sc_hd__a22o_2
Xfanout413 _4573_/Y VGND VGND VPWR VPWR wire414/A sky130_fd_sc_hd__clkdlybuf4s25_1
Xfanout402 _4641_/Y VGND VGND VPWR VPWR _4659_/A2 sky130_fd_sc_hd__clkdlybuf4s25_1
XFILLER_113_593 VGND VGND VPWR VPWR sky130_fd_sc_hd__decap_3
XFILLER_98_282 VGND VGND VPWR VPWR sky130_fd_sc_hd__decap_3
Xfanout446 _4402_/Y VGND VGND VPWR VPWR _4431_/A2 sky130_fd_sc_hd__clkdlybuf4s25_1
Xfanout435 _4470_/Y VGND VGND VPWR VPWR _4498_/A2 sky130_fd_sc_hd__clkdlybuf4s25_1
X_4358_ _5040_/A1 _4364_/A2 _4364_/B1 _4358_/B2 VGND VGND VPWR VPWR _5424_/D sky130_fd_sc_hd__a22o_2
X_4289_ _5005_/A1 wire479/A _4294_/B1 _4289_/B2 VGND VGND VPWR VPWR _5359_/D sky130_fd_sc_hd__a22o_2
X_3309_ _3843_/C1 _3292_/X _3305_/X _3308_/X VGND VGND VPWR VPWR _3309_/X sky130_fd_sc_hd__a22o_2
XFILLER_27_500 VGND VGND VPWR VPWR sky130_fd_sc_hd__decap_3
X_6028_ _6055_/CLK _6028_/D VGND VGND VPWR VPWR _6028_/Q sky130_fd_sc_hd__dfxtp_2
XFILLER_100_287 VGND VGND VPWR VPWR sky130_fd_sc_hd__decap_3
XFILLER_104_55 VGND VGND VPWR VPWR sky130_fd_sc_hd__fill_2
XFILLER_73_138 VGND VGND VPWR VPWR sky130_fd_sc_hd__decap_3
XFILLER_64_59 VGND VGND VPWR VPWR sky130_fd_sc_hd__decap_3
XFILLER_14_238 VGND VGND VPWR VPWR sky130_fd_sc_hd__decap_3
XTAP_TAPCELL_ROW_64_1017 VGND VPWR sky130_fd_sc_hd__tapvpwrvgnd_1
XTAP_TAPCELL_ROW_40_726 VGND VPWR sky130_fd_sc_hd__tapvpwrvgnd_1
XFILLER_10_477 VGND VGND VPWR VPWR sky130_fd_sc_hd__decap_3
XFILLER_13_63 VGND VGND VPWR VPWR sky130_fd_sc_hd__decap_3
XFILLER_108_343 VGND VGND VPWR VPWR sky130_fd_sc_hd__decap_3
XFILLER_10_499 VGND VGND VPWR VPWR sky130_fd_sc_hd__decap_3
XFILLER_89_12 VGND VGND VPWR VPWR sky130_fd_sc_hd__decap_3
XTAP_TAPCELL_ROW_20_494 VGND VPWR sky130_fd_sc_hd__tapvpwrvgnd_1
XFILLER_2_610 VGND VGND VPWR VPWR sky130_fd_sc_hd__decap_3
XTAP_TAPCELL_ROW_75_1146 VGND VPWR sky130_fd_sc_hd__tapvpwrvgnd_1
XFILLER_2_643 VGND VGND VPWR VPWR sky130_fd_sc_hd__fill_1
XFILLER_2_654 VGND VGND VPWR VPWR sky130_fd_sc_hd__decap_3
XFILLER_96_219 VGND VGND VPWR VPWR sky130_fd_sc_hd__decap_3
XFILLER_2_687 VGND VGND VPWR VPWR sky130_fd_sc_hd__fill_1
XFILLER_49_113 VGND VGND VPWR VPWR sky130_fd_sc_hd__fill_2
XFILLER_18_511 VGND VGND VPWR VPWR sky130_fd_sc_hd__decap_3
XTAP_TAPCELL_ROW_48_826 VGND VPWR sky130_fd_sc_hd__tapvpwrvgnd_1
Xfanout980 input19/X VGND VGND VPWR VPWR _4891_/A1 sky130_fd_sc_hd__clkdlybuf4s25_1
Xfanout991 input16/X VGND VGND VPWR VPWR _4795_/A_N sky130_fd_sc_hd__clkdlybuf4s25_1
XFILLER_18_522 VGND VGND VPWR VPWR sky130_fd_sc_hd__fill_2
XFILLER_18_566 VGND VGND VPWR VPWR sky130_fd_sc_hd__decap_3
XTAP_TAPCELL_ROW_28_583 VGND VPWR sky130_fd_sc_hd__tapvpwrvgnd_1
XTAP_TAPCELL_ROW_86_1286 VGND VPWR sky130_fd_sc_hd__tapvpwrvgnd_1
XFILLER_33_558 VGND VGND VPWR VPWR sky130_fd_sc_hd__fill_2
XFILLER_33_569 VGND VGND VPWR VPWR sky130_fd_sc_hd__decap_3
XFILLER_13_293 VGND VGND VPWR VPWR sky130_fd_sc_hd__fill_1
XFILLER_70_80 VGND VGND VPWR VPWR sky130_fd_sc_hd__decap_3
X_3660_ _5195_/Q _5163_/Q _3665_/S VGND VGND VPWR VPWR _3660_/X sky130_fd_sc_hd__mux2_1
Xclkload34 _6000_/CLK VGND VGND VPWR VPWR clkload34/Y sky130_fd_sc_hd__clkinv_2
Xclkload23 _5800_/CLK VGND VGND VPWR VPWR clkload23/X sky130_fd_sc_hd__clkbuf_8
Xclkload12 _6069_/CLK VGND VGND VPWR VPWR clkload12/X sky130_fd_sc_hd__clkbuf_8
X_3591_ _3695_/A1 _3589_/X _3590_/X _3694_/A VGND VGND VPWR VPWR _3591_/X sky130_fd_sc_hd__o22a_2
X_2611_ _2611_/A _2611_/B VGND VGND VPWR VPWR _2611_/X sky130_fd_sc_hd__or2_2
XFILLER_55_3 VGND VGND VPWR VPWR sky130_fd_sc_hd__fill_1
Xclkload45 _5815_/CLK VGND VGND VPWR VPWR clkload45/X sky130_fd_sc_hd__clkbuf_4
X_5330_ _5502_/CLK _5330_/D VGND VGND VPWR VPWR _5330_/Q sky130_fd_sc_hd__dfxtp_2
X_2542_ _2904_/A1 _2540_/X _2541_/X _3134_/A1 VGND VGND VPWR VPWR _2542_/X sky130_fd_sc_hd__o22a_2
X_5261_ _6029_/CLK _5261_/D VGND VGND VPWR VPWR _5261_/Q sky130_fd_sc_hd__dfxtp_2
X_4212_ _4520_/A1 _4224_/A2 _4219_/B1 _4212_/B2 VGND VGND VPWR VPWR _5286_/D sky130_fd_sc_hd__a22o_2
X_5192_ _5525_/CLK _5192_/D VGND VGND VPWR VPWR _5192_/Q sky130_fd_sc_hd__dfxtp_2
X_4143_ _4894_/A1 _4155_/A2 wire292/X _4143_/B2 VGND VGND VPWR VPWR _5222_/D sky130_fd_sc_hd__a22o_2
XFILLER_110_574 VGND VGND VPWR VPWR sky130_fd_sc_hd__decap_3
X_4074_ _4894_/A1 wire526/X _4086_/B1 _4074_/B2 VGND VGND VPWR VPWR _5158_/D sky130_fd_sc_hd__a22o_2
XFILLER_83_436 VGND VGND VPWR VPWR sky130_fd_sc_hd__decap_3
X_3025_ _5582_/Q _5550_/Q _3026_/S VGND VGND VPWR VPWR _3025_/X sky130_fd_sc_hd__mux2_1
XFILLER_24_514 VGND VGND VPWR VPWR sky130_fd_sc_hd__decap_3
XFILLER_36_396 VGND VGND VPWR VPWR sky130_fd_sc_hd__decap_3
XFILLER_24_547 VGND VGND VPWR VPWR sky130_fd_sc_hd__decap_3
XFILLER_34_29 VGND VGND VPWR VPWR sky130_fd_sc_hd__fill_2
X_4976_ _5010_/A1 _4976_/A2 _4976_/B1 _4976_/B2 VGND VGND VPWR VPWR _6004_/D sky130_fd_sc_hd__a22o_2
X_3927_ _3234_/B _3924_/X _3926_/X _3927_/B2 VGND VGND VPWR VPWR _3927_/X sky130_fd_sc_hd__a22o_2
Xclkload6 clkload6/A VGND VGND VPWR VPWR clkload6/X sky130_fd_sc_hd__clkbuf_8
X_3858_ _5588_/Q _5556_/Q _3858_/S VGND VGND VPWR VPWR _3858_/X sky130_fd_sc_hd__mux2_1
X_3789_ _5424_/Q _5072_/Q _3790_/S VGND VGND VPWR VPWR _3789_/X sky130_fd_sc_hd__mux2_1
X_2809_ _3228_/B2 _2806_/X _2808_/X VGND VGND VPWR VPWR _2809_/X sky130_fd_sc_hd__a21o_2
X_5528_ _6036_/CLK _5528_/D VGND VGND VPWR VPWR _5528_/Q sky130_fd_sc_hd__dfxtp_2
XFILLER_105_313 VGND VGND VPWR VPWR sky130_fd_sc_hd__decap_3
XFILLER_105_368 VGND VGND VPWR VPWR sky130_fd_sc_hd__decap_3
X_5459_ _6067_/CLK _5459_/D VGND VGND VPWR VPWR _5459_/Q sky130_fd_sc_hd__dfxtp_2
XFILLER_115_21 VGND VGND VPWR VPWR sky130_fd_sc_hd__decap_3
Xfanout232 _4403_/Y VGND VGND VPWR VPWR fanout232/X sky130_fd_sc_hd__clkdlybuf4s25_1
XFILLER_101_530 VGND VGND VPWR VPWR sky130_fd_sc_hd__decap_3
XFILLER_113_390 VGND VGND VPWR VPWR sky130_fd_sc_hd__fill_2
XFILLER_115_32 VGND VGND VPWR VPWR sky130_fd_sc_hd__decap_3
Xfanout265 _4263_/B1 VGND VGND VPWR VPWR _4250_/B1 sky130_fd_sc_hd__clkdlybuf4s25_1
Xfanout254 _4297_/B1 VGND VGND VPWR VPWR wire255/A sky130_fd_sc_hd__clkdlybuf4s25_1
Xfanout243 _4333_/Y VGND VGND VPWR VPWR _4364_/B1 sky130_fd_sc_hd__clkdlybuf4s25_1
XFILLER_101_585 VGND VGND VPWR VPWR sky130_fd_sc_hd__decap_3
XTAP_TAPCELL_ROW_70_1087 VGND VPWR sky130_fd_sc_hd__tapvpwrvgnd_1
Xfanout287 wire290/A VGND VGND VPWR VPWR _4151_/B1 sky130_fd_sc_hd__clkdlybuf4s25_1
XFILLER_15_525 VGND VGND VPWR VPWR sky130_fd_sc_hd__decap_3
XFILLER_91_46 VGND VGND VPWR VPWR sky130_fd_sc_hd__fill_2
XFILLER_91_57 VGND VGND VPWR VPWR sky130_fd_sc_hd__fill_2
XTAP_TAPCELL_ROW_25_553 VGND VPWR sky130_fd_sc_hd__tapvpwrvgnd_1
XTAP_TAPCELL_ROW_53_884 VGND VPWR sky130_fd_sc_hd__tapvpwrvgnd_1
XFILLER_30_539 VGND VGND VPWR VPWR sky130_fd_sc_hd__decap_3
XFILLER_10_230 VGND VGND VPWR VPWR sky130_fd_sc_hd__decap_3
XFILLER_10_274 VGND VGND VPWR VPWR sky130_fd_sc_hd__fill_1
XFILLER_6_234 VGND VGND VPWR VPWR sky130_fd_sc_hd__decap_3
XFILLER_109_663 VGND VGND VPWR VPWR sky130_fd_sc_hd__decap_3
XFILLER_109_685 VGND VGND VPWR VPWR sky130_fd_sc_hd__decap_3
XFILLER_40_50 VGND VGND VPWR VPWR sky130_fd_sc_hd__decap_3
XFILLER_6_256 VGND VGND VPWR VPWR sky130_fd_sc_hd__fill_2
XFILLER_108_184 VGND VGND VPWR VPWR sky130_fd_sc_hd__decap_3
Xload_slew605 _3896_/B2 VGND VGND VPWR VPWR _3502_/A1 sky130_fd_sc_hd__buf_4
Xload_slew616 _3944_/A1 VGND VGND VPWR VPWR _3414_/A sky130_fd_sc_hd__buf_4
Xload_slew649 _2949_/B2 VGND VGND VPWR VPWR _3195_/A1 sky130_fd_sc_hd__buf_4
XFILLER_49_92 VGND VGND VPWR VPWR sky130_fd_sc_hd__decap_3
XFILLER_92_200 VGND VGND VPWR VPWR sky130_fd_sc_hd__decap_3
XTAP_TAPCELL_ROW_88_1304 VGND VPWR sky130_fd_sc_hd__tapvpwrvgnd_1
XFILLER_1_33 VGND VGND VPWR VPWR sky130_fd_sc_hd__decap_3
XFILLER_37_127 VGND VGND VPWR VPWR sky130_fd_sc_hd__decap_3
XFILLER_18_352 VGND VGND VPWR VPWR sky130_fd_sc_hd__decap_3
XFILLER_1_66 VGND VGND VPWR VPWR sky130_fd_sc_hd__decap_3
XFILLER_61_631 VGND VGND VPWR VPWR sky130_fd_sc_hd__decap_3
X_4830_ _4830_/A1 wire376/X _4843_/B1 _4830_/B2 VGND VGND VPWR VPWR _5866_/D sky130_fd_sc_hd__a22o_2
XFILLER_33_399 VGND VGND VPWR VPWR sky130_fd_sc_hd__decap_3
X_4761_ _4997_/A1 _4777_/A2 _4777_/B1 _4761_/B2 VGND VGND VPWR VPWR _5799_/D sky130_fd_sc_hd__a22o_2
X_4692_ _4997_/A1 _4708_/A2 _4708_/B1 _4692_/B2 VGND VGND VPWR VPWR _5735_/D sky130_fd_sc_hd__a22o_2
X_3712_ _5197_/Q _5165_/Q _3712_/S VGND VGND VPWR VPWR _3712_/X sky130_fd_sc_hd__mux2_1
XTAP_TAPCELL_ROW_99_1433 VGND VPWR sky130_fd_sc_hd__tapvpwrvgnd_1
X_3643_ _3941_/A _3643_/B VGND VGND VPWR VPWR _3643_/X sky130_fd_sc_hd__or2_2
X_5313_ _5578_/CLK _5313_/D VGND VGND VPWR VPWR _5313_/Q sky130_fd_sc_hd__dfxtp_2
X_3574_ _5575_/Q _5543_/Q _3575_/S VGND VGND VPWR VPWR _3574_/X sky130_fd_sc_hd__mux2_1
XFILLER_115_666 VGND VGND VPWR VPWR sky130_fd_sc_hd__decap_3
X_2525_ _2514_/X _3017_/C1 _2518_/X _2507_/X _3185_/A1 VGND VGND VPWR VPWR _2525_/X
+ sky130_fd_sc_hd__a32o_2
XFILLER_114_176 VGND VGND VPWR VPWR sky130_fd_sc_hd__decap_3
X_5244_ _6067_/CLK _5244_/D VGND VGND VPWR VPWR _5244_/Q sky130_fd_sc_hd__dfxtp_2
XFILLER_29_18 VGND VGND VPWR VPWR sky130_fd_sc_hd__decap_3
X_5175_ _5815_/CLK _5175_/D VGND VGND VPWR VPWR _5175_/Q sky130_fd_sc_hd__dfxtp_2
XFILLER_29_617 VGND VGND VPWR VPWR sky130_fd_sc_hd__decap_3
XFILLER_96_583 VGND VGND VPWR VPWR sky130_fd_sc_hd__decap_3
Xhold1903 _5856_/Q VGND VGND VPWR VPWR _4820_/B2 sky130_fd_sc_hd__dlygate4sd3_1
Xhold1914 _5459_/Q VGND VGND VPWR VPWR _4396_/B2 sky130_fd_sc_hd__dlygate4sd3_1
Xhold1925 _5343_/Q VGND VGND VPWR VPWR _4273_/B2 sky130_fd_sc_hd__dlygate4sd3_1
Xhold1936 _5906_/Q VGND VGND VPWR VPWR _4872_/B2 sky130_fd_sc_hd__dlygate4sd3_1
X_4126_ _5013_/A1 wire518/X wire298/X _4126_/B2 VGND VGND VPWR VPWR _5207_/D sky130_fd_sc_hd__a22o_2
XFILLER_110_382 VGND VGND VPWR VPWR sky130_fd_sc_hd__decap_3
XFILLER_28_138 VGND VGND VPWR VPWR sky130_fd_sc_hd__fill_2
XFILLER_83_233 VGND VGND VPWR VPWR sky130_fd_sc_hd__fill_2
Xhold1947 _5344_/Q VGND VGND VPWR VPWR _4274_/B2 sky130_fd_sc_hd__dlygate4sd3_1
Xhold1958 _5201_/Q VGND VGND VPWR VPWR _4120_/B2 sky130_fd_sc_hd__dlygate4sd3_1
Xhold1969 _5048_/Q VGND VGND VPWR VPWR _3952_/B2 sky130_fd_sc_hd__dlygate4sd3_1
XFILLER_83_255 VGND VGND VPWR VPWR sky130_fd_sc_hd__fill_1
XTAP_TAPCELL_ROW_108_1540 VGND VPWR sky130_fd_sc_hd__tapvpwrvgnd_1
X_4057_ _4401_/B _4057_/B VGND VGND VPWR VPWR _4161_/B sky130_fd_sc_hd__or2_2
XTAP_TAPCELL_ROW_108_1551 VGND VPWR sky130_fd_sc_hd__tapvpwrvgnd_1
X_3008_ _5934_/Q _5902_/Q _5870_/Q _5774_/Q _2708_/S _3013_/S1 VGND VGND VPWR VPWR
+ _3008_/X sky130_fd_sc_hd__mux4_2
XFILLER_101_12 VGND VGND VPWR VPWR sky130_fd_sc_hd__decap_3
XFILLER_36_182 VGND VGND VPWR VPWR sky130_fd_sc_hd__decap_3
XFILLER_52_664 VGND VGND VPWR VPWR sky130_fd_sc_hd__fill_2
XFILLER_52_686 VGND VGND VPWR VPWR sky130_fd_sc_hd__fill_2
XTAP_TAPCELL_ROW_22_512 VGND VPWR sky130_fd_sc_hd__tapvpwrvgnd_1
X_4959_ _4993_/A1 _4977_/A2 _4964_/B1 _4959_/B2 VGND VGND VPWR VPWR _5987_/D sky130_fd_sc_hd__a22o_2
XFILLER_20_550 VGND VGND VPWR VPWR sky130_fd_sc_hd__decap_3
XTAP_TAPCELL_ROW_50_854 VGND VPWR sky130_fd_sc_hd__tapvpwrvgnd_1
XFILLER_3_204 VGND VGND VPWR VPWR sky130_fd_sc_hd__decap_3
XFILLER_105_121 VGND VGND VPWR VPWR sky130_fd_sc_hd__fill_2
XFILLER_106_666 VGND VGND VPWR VPWR sky130_fd_sc_hd__decap_3
XFILLER_10_42 VGND VGND VPWR VPWR sky130_fd_sc_hd__fill_1
XTAP_TAPCELL_ROW_72_1116 VGND VPWR sky130_fd_sc_hd__tapvpwrvgnd_1
XFILLER_94_509 VGND VGND VPWR VPWR sky130_fd_sc_hd__fill_2
Xfanout1027 wire1038/A VGND VGND VPWR VPWR _3742_/S1 sky130_fd_sc_hd__dlymetal6s4s_1
Xfanout1016 input13/X VGND VGND VPWR VPWR _3399_/A1 sky130_fd_sc_hd__clkdlybuf4s25_1
Xfanout1005 input15/X VGND VGND VPWR VPWR _3261_/A sky130_fd_sc_hd__clkdlybuf4s25_1
XFILLER_101_360 VGND VGND VPWR VPWR sky130_fd_sc_hd__decap_3
XFILLER_59_241 VGND VGND VPWR VPWR sky130_fd_sc_hd__decap_3
XFILLER_59_252 VGND VGND VPWR VPWR sky130_fd_sc_hd__decap_3
XFILLER_87_561 VGND VGND VPWR VPWR sky130_fd_sc_hd__decap_3
XFILLER_47_447 VGND VGND VPWR VPWR sky130_fd_sc_hd__fill_1
XTAP_TAPCELL_ROW_58_943 VGND VPWR sky130_fd_sc_hd__tapvpwrvgnd_1
XFILLER_28_683 VGND VGND VPWR VPWR sky130_fd_sc_hd__decap_3
XTAP_TAPCELL_ROW_2_270 VGND VPWR sky130_fd_sc_hd__tapvpwrvgnd_1
XTAP_TAPCELL_ROW_83_1245 VGND VPWR sky130_fd_sc_hd__tapvpwrvgnd_1
XFILLER_70_461 VGND VGND VPWR VPWR sky130_fd_sc_hd__decap_3
XFILLER_70_494 VGND VGND VPWR VPWR sky130_fd_sc_hd__decap_3
XFILLER_30_347 VGND VGND VPWR VPWR sky130_fd_sc_hd__decap_3
XFILLER_89_9 VGND VGND VPWR VPWR sky130_fd_sc_hd__decap_3
XTAP_TAPCELL_ROW_94_1374 VGND VPWR sky130_fd_sc_hd__tapvpwrvgnd_1
XFILLER_111_102 VGND VGND VPWR VPWR sky130_fd_sc_hd__fill_2
XFILLER_112_625 VGND VGND VPWR VPWR sky130_fd_sc_hd__decap_3
X_3290_ _5498_/Q _5466_/Q _3822_/S VGND VGND VPWR VPWR _3290_/X sky130_fd_sc_hd__mux2_1
XFILLER_111_113 VGND VGND VPWR VPWR sky130_fd_sc_hd__decap_3
XFILLER_112_669 VGND VGND VPWR VPWR sky130_fd_sc_hd__decap_3
XPHY_EDGE_ROW_29_Left_145 VGND VGND VPWR VPWR sky130_fd_sc_hd__decap_3
Xload_slew424 _4557_/A2 VGND VGND VPWR VPWR _4572_/A2 sky130_fd_sc_hd__buf_4
XFILLER_38_403 VGND VGND VPWR VPWR sky130_fd_sc_hd__decap_3
Xload_slew468 _4316_/A2 VGND VGND VPWR VPWR _4327_/A2 sky130_fd_sc_hd__buf_4
Xload_slew457 _4368_/B VGND VGND VPWR VPWR _4399_/A2 sky130_fd_sc_hd__clkbuf_4
XFILLER_38_447 VGND VGND VPWR VPWR sky130_fd_sc_hd__decap_3
XFILLER_25_108 VGND VGND VPWR VPWR sky130_fd_sc_hd__decap_3
XFILLER_93_586 VGND VGND VPWR VPWR sky130_fd_sc_hd__decap_3
X_5931_ _5963_/CLK _5931_/D VGND VGND VPWR VPWR _5931_/Q sky130_fd_sc_hd__dfxtp_2
XFILLER_34_631 VGND VGND VPWR VPWR sky130_fd_sc_hd__decap_3
XFILLER_34_653 VGND VGND VPWR VPWR sky130_fd_sc_hd__fill_1
XFILLER_33_152 VGND VGND VPWR VPWR sky130_fd_sc_hd__decap_3
X_5862_ _6043_/CLK _5862_/D VGND VGND VPWR VPWR _5862_/Q sky130_fd_sc_hd__dfxtp_2
XPHY_EDGE_ROW_38_Left_154 VGND VGND VPWR VPWR sky130_fd_sc_hd__decap_3
X_5793_ _5825_/CLK _5793_/D VGND VGND VPWR VPWR _5793_/Q sky130_fd_sc_hd__dfxtp_2
X_4813_ _5017_/A1 wire371/A wire153/X _4813_/B2 VGND VGND VPWR VPWR _5849_/D sky130_fd_sc_hd__a22o_2
XTAP_TAPCELL_ROW_103_1481 VGND VPWR sky130_fd_sc_hd__tapvpwrvgnd_1
X_4744_ _4744_/A _5014_/A VGND VGND VPWR VPWR _4744_/Y sky130_fd_sc_hd__nor2_2
X_4675_ _4744_/A _4946_/B VGND VGND VPWR VPWR _4675_/Y sky130_fd_sc_hd__nor2_2
X_3626_ _3626_/A _3626_/B VGND VGND VPWR VPWR _3626_/X sky130_fd_sc_hd__or2_2
X_3557_ _5414_/Q _5062_/Q _3558_/S VGND VGND VPWR VPWR _3557_/X sky130_fd_sc_hd__mux2_1
XFILLER_102_102 VGND VGND VPWR VPWR sky130_fd_sc_hd__decap_3
XFILLER_103_614 VGND VGND VPWR VPWR sky130_fd_sc_hd__fill_2
XPHY_EDGE_ROW_47_Left_163 VGND VGND VPWR VPWR sky130_fd_sc_hd__decap_3
X_2508_ _5912_/Q _5880_/Q _5848_/Q _5752_/Q _2510_/S _3057_/S1 VGND VGND VPWR VPWR
+ _2508_/X sky130_fd_sc_hd__mux4_2
X_5227_ _5547_/CLK _5227_/D VGND VGND VPWR VPWR _5227_/Q sky130_fd_sc_hd__dfxtp_2
X_3488_ _3837_/A _3485_/X _3487_/X _3619_/A1 VGND VGND VPWR VPWR _3488_/X sky130_fd_sc_hd__a22o_2
XFILLER_69_561 VGND VGND VPWR VPWR sky130_fd_sc_hd__fill_2
Xhold1700 _5766_/Q VGND VGND VPWR VPWR _4726_/B2 sky130_fd_sc_hd__dlygate4sd3_1
Xhold1711 _5891_/Q VGND VGND VPWR VPWR _4857_/B2 sky130_fd_sc_hd__dlygate4sd3_1
XFILLER_56_200 VGND VGND VPWR VPWR sky130_fd_sc_hd__decap_3
Xhold1722 _5294_/Q VGND VGND VPWR VPWR _4220_/B2 sky130_fd_sc_hd__dlygate4sd3_1
Xhold1733 _5199_/Q VGND VGND VPWR VPWR _4118_/B2 sky130_fd_sc_hd__dlygate4sd3_1
Xhold1744 _5746_/Q VGND VGND VPWR VPWR _4703_/B2 sky130_fd_sc_hd__dlygate4sd3_1
X_5158_ _6029_/CLK _5158_/D VGND VGND VPWR VPWR _5158_/Q sky130_fd_sc_hd__dfxtp_2
XFILLER_17_609 VGND VGND VPWR VPWR sky130_fd_sc_hd__decap_3
Xhold1755 _5529_/Q VGND VGND VPWR VPWR _4473_/B2 sky130_fd_sc_hd__dlygate4sd3_1
Xhold1766 _5354_/Q VGND VGND VPWR VPWR _4284_/B2 sky130_fd_sc_hd__dlygate4sd3_1
Xhold1777 _5749_/Q VGND VGND VPWR VPWR _4706_/B2 sky130_fd_sc_hd__dlygate4sd3_1
X_5089_ _6026_/CLK _5089_/D VGND VGND VPWR VPWR _5089_/Q sky130_fd_sc_hd__dfxtp_2
X_4109_ _4894_/A1 wire518/X _4121_/B1 _4109_/B2 VGND VGND VPWR VPWR _5190_/D sky130_fd_sc_hd__a22o_2
XFILLER_112_22 VGND VGND VPWR VPWR sky130_fd_sc_hd__decap_3
XFILLER_44_417 VGND VGND VPWR VPWR sky130_fd_sc_hd__decap_3
XTAP_TAPCELL_ROW_55_913 VGND VPWR sky130_fd_sc_hd__tapvpwrvgnd_1
Xhold1788 _6024_/Q VGND VGND VPWR VPWR _4998_/B2 sky130_fd_sc_hd__dlygate4sd3_1
Xhold1799 _5149_/Q VGND VGND VPWR VPWR _4065_/B2 sky130_fd_sc_hd__dlygate4sd3_1
XFILLER_112_44 VGND VGND VPWR VPWR sky130_fd_sc_hd__decap_3
XFILLER_112_77 VGND VGND VPWR VPWR sky130_fd_sc_hd__decap_3
XPHY_EDGE_ROW_56_Left_172 VGND VGND VPWR VPWR sky130_fd_sc_hd__decap_3
XFILLER_112_88 VGND VGND VPWR VPWR sky130_fd_sc_hd__decap_3
XFILLER_24_174 VGND VGND VPWR VPWR sky130_fd_sc_hd__decap_3
XFILLER_52_483 VGND VGND VPWR VPWR sky130_fd_sc_hd__decap_3
XTAP_TAPCELL_ROW_35_670 VGND VPWR sky130_fd_sc_hd__tapvpwrvgnd_1
XFILLER_40_656 VGND VGND VPWR VPWR sky130_fd_sc_hd__decap_3
XFILLER_21_63 VGND VGND VPWR VPWR sky130_fd_sc_hd__decap_3
XFILLER_106_430 VGND VGND VPWR VPWR sky130_fd_sc_hd__decap_3
XFILLER_4_568 VGND VGND VPWR VPWR sky130_fd_sc_hd__decap_3
XFILLER_97_12 VGND VGND VPWR VPWR sky130_fd_sc_hd__decap_3
XPHY_EDGE_ROW_65_Left_181 VGND VGND VPWR VPWR sky130_fd_sc_hd__decap_3
XFILLER_97_89 VGND VGND VPWR VPWR sky130_fd_sc_hd__decap_3
XFILLER_102_680 VGND VGND VPWR VPWR sky130_fd_sc_hd__decap_3
XFILLER_90_501 VGND VGND VPWR VPWR sky130_fd_sc_hd__decap_3
XPHY_EDGE_ROW_74_Left_190 VGND VGND VPWR VPWR sky130_fd_sc_hd__decap_3
XFILLER_15_130 VGND VGND VPWR VPWR sky130_fd_sc_hd__decap_3
XFILLER_16_675 VGND VGND VPWR VPWR sky130_fd_sc_hd__decap_3
XFILLER_16_686 VGND VGND VPWR VPWR sky130_fd_sc_hd__fill_2
XFILLER_90_589 VGND VGND VPWR VPWR sky130_fd_sc_hd__decap_3
XFILLER_31_634 VGND VGND VPWR VPWR sky130_fd_sc_hd__fill_1
XFILLER_7_21 VGND VGND VPWR VPWR sky130_fd_sc_hd__decap_3
X_2790_ _3195_/A1 _2788_/X _2789_/X _2499_/A VGND VGND VPWR VPWR _2790_/X sky130_fd_sc_hd__o22a_2
XFILLER_7_340 VGND VGND VPWR VPWR sky130_fd_sc_hd__fill_2
XFILLER_7_54 VGND VGND VPWR VPWR sky130_fd_sc_hd__fill_2
XTAP_TAPCELL_ROW_96_1403 VGND VPWR sky130_fd_sc_hd__tapvpwrvgnd_1
XFILLER_7_362 VGND VGND VPWR VPWR sky130_fd_sc_hd__decap_3
X_4460_ _4528_/A1 _4460_/A2 _4460_/B1 _4460_/B2 VGND VGND VPWR VPWR _5518_/D sky130_fd_sc_hd__a22o_2
X_4391_ _4768_/A1 _4368_/B wire238/A _4391_/B2 VGND VGND VPWR VPWR _5454_/D sky130_fd_sc_hd__a22o_2
X_3411_ _5695_/Q _5663_/Q _5631_/Q _5599_/Q _3644_/S _3698_/S1 VGND VGND VPWR VPWR
+ _3412_/B sky130_fd_sc_hd__mux4_2
X_3342_ _5916_/Q _5884_/Q _5852_/Q _5756_/Q _3616_/S _3627_/S1 VGND VGND VPWR VPWR
+ _3342_/X sky130_fd_sc_hd__mux4_2
XFILLER_97_133 VGND VGND VPWR VPWR sky130_fd_sc_hd__decap_3
XFILLER_98_645 VGND VGND VPWR VPWR sky130_fd_sc_hd__decap_3
Xload_slew221 _4467_/B1 VGND VGND VPWR VPWR _4459_/B1 sky130_fd_sc_hd__clkbuf_2
Xload_slew210 _4530_/B1 VGND VGND VPWR VPWR _4536_/B1 sky130_fd_sc_hd__buf_4
XFILLER_85_317 VGND VGND VPWR VPWR sky130_fd_sc_hd__fill_2
X_6061_ _6061_/CLK _6061_/D VGND VGND VPWR VPWR _6061_/Q sky130_fd_sc_hd__dfxtp_2
X_3273_ _5401_/Q _5049_/Q _3631_/S VGND VGND VPWR VPWR _3273_/X sky130_fd_sc_hd__mux2_1
XFILLER_97_177 VGND VGND VPWR VPWR sky130_fd_sc_hd__decap_3
Xload_slew276 _4192_/B1 VGND VGND VPWR VPWR _4180_/B1 sky130_fd_sc_hd__buf_2
X_5012_ _5012_/A1 _5012_/A2 _5012_/B1 _5012_/B2 VGND VGND VPWR VPWR _6038_/D sky130_fd_sc_hd__a22o_2
XFILLER_66_553 VGND VGND VPWR VPWR sky130_fd_sc_hd__fill_1
XFILLER_38_277 VGND VGND VPWR VPWR sky130_fd_sc_hd__decap_3
XFILLER_81_501 VGND VGND VPWR VPWR sky130_fd_sc_hd__decap_3
XFILLER_93_383 VGND VGND VPWR VPWR sky130_fd_sc_hd__fill_1
XTAP_TAPCELL_ROW_105_1510 VGND VPWR sky130_fd_sc_hd__tapvpwrvgnd_1
X_5914_ _5914_/CLK _5914_/D VGND VGND VPWR VPWR _5914_/Q sky130_fd_sc_hd__dfxtp_2
XFILLER_21_100 VGND VGND VPWR VPWR sky130_fd_sc_hd__decap_3
X_5845_ _6069_/CLK _5845_/D VGND VGND VPWR VPWR _5845_/Q sky130_fd_sc_hd__dfxtp_2
XFILLER_22_645 VGND VGND VPWR VPWR sky130_fd_sc_hd__fill_2
XFILLER_22_667 VGND VGND VPWR VPWR sky130_fd_sc_hd__decap_3
XFILLER_21_155 VGND VGND VPWR VPWR sky130_fd_sc_hd__decap_3
XTAP_TAPCELL_ROW_60_971 VGND VPWR sky130_fd_sc_hd__tapvpwrvgnd_1
X_5776_ _6064_/CLK _5776_/D VGND VGND VPWR VPWR _5776_/Q sky130_fd_sc_hd__dfxtp_2
X_2988_ _5261_/Q _5229_/Q _2988_/S VGND VGND VPWR VPWR _2988_/X sky130_fd_sc_hd__mux2_1
XFILLER_21_199 VGND VGND VPWR VPWR sky130_fd_sc_hd__fill_2
X_4727_ _4727_/A1 wire389/X _4727_/B1 _4727_/B2 VGND VGND VPWR VPWR _5767_/D sky130_fd_sc_hd__a22o_2
X_4658_ _4658_/A1 _4642_/B _4668_/B1 _4658_/B2 VGND VGND VPWR VPWR _5703_/D sky130_fd_sc_hd__a22o_2
X_3609_ _5256_/Q _5224_/Q _3609_/S VGND VGND VPWR VPWR _3609_/X sky130_fd_sc_hd__mux2_1
XFILLER_89_623 VGND VGND VPWR VPWR sky130_fd_sc_hd__decap_3
X_4589_ _4760_/A1 _4606_/A2 _4606_/B1 _4589_/B2 VGND VGND VPWR VPWR _5638_/D sky130_fd_sc_hd__a22o_2
XFILLER_107_33 VGND VGND VPWR VPWR sky130_fd_sc_hd__decap_3
XFILLER_107_66 VGND VGND VPWR VPWR sky130_fd_sc_hd__decap_3
XFILLER_88_111 VGND VGND VPWR VPWR sky130_fd_sc_hd__fill_2
XFILLER_103_477 VGND VGND VPWR VPWR sky130_fd_sc_hd__decap_3
XFILLER_67_48 VGND VGND VPWR VPWR sky130_fd_sc_hd__decap_3
XFILLER_88_144 VGND VGND VPWR VPWR sky130_fd_sc_hd__fill_2
XFILLER_88_166 VGND VGND VPWR VPWR sky130_fd_sc_hd__decap_3
XFILLER_103_499 VGND VGND VPWR VPWR sky130_fd_sc_hd__decap_3
XFILLER_69_380 VGND VGND VPWR VPWR sky130_fd_sc_hd__fill_2
XFILLER_29_244 VGND VGND VPWR VPWR sky130_fd_sc_hd__decap_3
Xhold1530 _5238_/Q VGND VGND VPWR VPWR _4159_/B2 sky130_fd_sc_hd__dlygate4sd3_1
Xhold1541 _5947_/Q VGND VGND VPWR VPWR _4917_/B2 sky130_fd_sc_hd__dlygate4sd3_1
Xhold1552 _5085_/Q VGND VGND VPWR VPWR _3994_/B2 sky130_fd_sc_hd__dlygate4sd3_1
XFILLER_17_417 VGND VGND VPWR VPWR sky130_fd_sc_hd__decap_3
XFILLER_57_586 VGND VGND VPWR VPWR sky130_fd_sc_hd__decap_3
Xhold1563 _5934_/Q VGND VGND VPWR VPWR _4902_/B2 sky130_fd_sc_hd__dlygate4sd3_1
Xhold1574 _5952_/Q VGND VGND VPWR VPWR _4922_/B2 sky130_fd_sc_hd__dlygate4sd3_1
Xhold1585 _5620_/Q VGND VGND VPWR VPWR _4569_/B2 sky130_fd_sc_hd__dlygate4sd3_1
Xload_slew1026 _3736_/S1 VGND VGND VPWR VPWR _3615_/S1 sky130_fd_sc_hd__clkbuf_4
Xload_slew1059 _3616_/S VGND VGND VPWR VPWR _3284_/S sky130_fd_sc_hd__buf_4
XFILLER_84_394 VGND VGND VPWR VPWR sky130_fd_sc_hd__fill_1
XTAP_TAPCELL_ROW_67_1048 VGND VPWR sky130_fd_sc_hd__tapvpwrvgnd_1
Xhold1596 _5426_/Q VGND VGND VPWR VPWR _4360_/B2 sky130_fd_sc_hd__dlygate4sd3_1
XFILLER_72_567 VGND VGND VPWR VPWR sky130_fd_sc_hd__decap_3
XFILLER_72_589 VGND VGND VPWR VPWR sky130_fd_sc_hd__decap_3
XTAP_TAPCELL_ROW_67_1059 VGND VPWR sky130_fd_sc_hd__tapvpwrvgnd_1
XFILLER_16_63 VGND VGND VPWR VPWR sky130_fd_sc_hd__fill_2
XFILLER_16_85 VGND VGND VPWR VPWR sky130_fd_sc_hd__fill_1
XPHY_EDGE_ROW_11_Right_11 VGND VGND VPWR VPWR sky130_fd_sc_hd__decap_3
XTAP_TAPCELL_ROW_80_1204 VGND VPWR sky130_fd_sc_hd__tapvpwrvgnd_1
XTAP_TAPCELL_ROW_80_1215 VGND VPWR sky130_fd_sc_hd__tapvpwrvgnd_1
XFILLER_12_144 VGND VGND VPWR VPWR sky130_fd_sc_hd__decap_3
XFILLER_13_645 VGND VGND VPWR VPWR sky130_fd_sc_hd__decap_3
XFILLER_13_667 VGND VGND VPWR VPWR sky130_fd_sc_hd__decap_3
XFILLER_40_464 VGND VGND VPWR VPWR sky130_fd_sc_hd__decap_3
XFILLER_8_137 VGND VGND VPWR VPWR sky130_fd_sc_hd__decap_3
XTAP_TAPCELL_ROW_10_367 VGND VPWR sky130_fd_sc_hd__tapvpwrvgnd_1
XTAP_TAPCELL_ROW_78_1188 VGND VPWR sky130_fd_sc_hd__tapvpwrvgnd_1
XFILLER_79_122 VGND VGND VPWR VPWR sky130_fd_sc_hd__decap_3
XPHY_EDGE_ROW_20_Right_20 VGND VGND VPWR VPWR sky130_fd_sc_hd__decap_3
XTAP_TAPCELL_ROW_91_1344 VGND VPWR sky130_fd_sc_hd__tapvpwrvgnd_1
XFILLER_95_615 VGND VGND VPWR VPWR sky130_fd_sc_hd__fill_1
XFILLER_79_177 VGND VGND VPWR VPWR sky130_fd_sc_hd__fill_2
XFILLER_94_147 VGND VGND VPWR VPWR sky130_fd_sc_hd__fill_2
XFILLER_48_586 VGND VGND VPWR VPWR sky130_fd_sc_hd__fill_2
XFILLER_75_372 VGND VGND VPWR VPWR sky130_fd_sc_hd__fill_2
XFILLER_35_225 VGND VGND VPWR VPWR sky130_fd_sc_hd__decap_3
XFILLER_35_269 VGND VGND VPWR VPWR sky130_fd_sc_hd__decap_3
XTAP_TAPCELL_ROW_18_467 VGND VPWR sky130_fd_sc_hd__tapvpwrvgnd_1
X_3960_ _4754_/A1 _3981_/A2 wire322/X _3960_/B2 VGND VGND VPWR VPWR _5056_/D sky130_fd_sc_hd__a22o_2
XTAP_TAPCELL_ROW_46_798 VGND VPWR sky130_fd_sc_hd__tapvpwrvgnd_1
X_2911_ _5929_/Q _5897_/Q _5865_/Q _5769_/Q _2604_/S _2911_/S1 VGND VGND VPWR VPWR
+ _2911_/X sky130_fd_sc_hd__mux4_2
XFILLER_31_442 VGND VGND VPWR VPWR sky130_fd_sc_hd__decap_3
X_3891_ _5205_/Q _5173_/Q _3895_/S VGND VGND VPWR VPWR _3891_/X sky130_fd_sc_hd__mux2_1
XTAP_TAPCELL_ROW_100_1451 VGND VPWR sky130_fd_sc_hd__tapvpwrvgnd_1
X_5630_ _5790_/CLK _5630_/D VGND VGND VPWR VPWR _5630_/Q sky130_fd_sc_hd__dfxtp_2
X_2842_ _2987_/A _2838_/X _2841_/X _3106_/C1 VGND VGND VPWR VPWR _2842_/X sky130_fd_sc_hd__o211a_2
X_5561_ _5692_/CLK _5561_/D VGND VGND VPWR VPWR _5561_/Q sky130_fd_sc_hd__dfxtp_2
X_2773_ wire676/X _2771_/X _2772_/X wire641/X VGND VGND VPWR VPWR _2773_/X sky130_fd_sc_hd__o22a_2
XFILLER_8_671 VGND VGND VPWR VPWR sky130_fd_sc_hd__decap_3
X_5492_ _5956_/CLK _5492_/D VGND VGND VPWR VPWR _5492_/Q sky130_fd_sc_hd__dfxtp_2
X_4512_ _4886_/A1 _4532_/A2 _4532_/B1 _4512_/B2 VGND VGND VPWR VPWR _5566_/D sky130_fd_sc_hd__a22o_2
X_4443_ _4885_/A1 _4459_/A2 _4459_/B1 _4443_/B2 VGND VGND VPWR VPWR _5501_/D sky130_fd_sc_hd__a22o_2
Xfanout606 _3831_/A1 VGND VGND VPWR VPWR _3308_/B2 sky130_fd_sc_hd__dlymetal6s2s_1
X_4374_ _5021_/A1 _4380_/A2 _4375_/B1 _4374_/B2 VGND VGND VPWR VPWR _5437_/D sky130_fd_sc_hd__a22o_2
X_3325_ _5243_/Q _5211_/Q _3325_/S VGND VGND VPWR VPWR _3325_/X sky130_fd_sc_hd__mux2_1
XFILLER_58_317 VGND VGND VPWR VPWR sky130_fd_sc_hd__fill_1
XFILLER_58_328 VGND VGND VPWR VPWR sky130_fd_sc_hd__decap_3
XFILLER_98_497 VGND VGND VPWR VPWR sky130_fd_sc_hd__decap_3
XTAP_TAPCELL_ROW_111_1580 VGND VPWR sky130_fd_sc_hd__tapvpwrvgnd_1
X_6044_ _6044_/CLK _6044_/D VGND VGND VPWR VPWR _6044_/Q sky130_fd_sc_hd__dfxtp_2
X_3256_ _3244_/X _3246_/X _3249_/X _3255_/X VGND VGND VPWR VPWR _3256_/X sky130_fd_sc_hd__a31o_2
XFILLER_54_501 VGND VGND VPWR VPWR sky130_fd_sc_hd__fill_1
XFILLER_85_169 VGND VGND VPWR VPWR sky130_fd_sc_hd__decap_3
X_3187_ _5398_/Q _5366_/Q _5334_/Q _5302_/Q _3188_/S _3202_/S1 VGND VGND VPWR VPWR
+ _3187_/X sky130_fd_sc_hd__mux4_2
XFILLER_39_597 VGND VGND VPWR VPWR sky130_fd_sc_hd__fill_2
XFILLER_22_475 VGND VGND VPWR VPWR sky130_fd_sc_hd__fill_1
X_5828_ _6063_/CLK _5828_/D VGND VGND VPWR VPWR _5828_/Q sky130_fd_sc_hd__dfxtp_2
X_5759_ _6065_/CLK _5759_/D VGND VGND VPWR VPWR _5759_/Q sky130_fd_sc_hd__dfxtp_2
XFILLER_108_525 VGND VGND VPWR VPWR sky130_fd_sc_hd__decap_3
XFILLER_5_129 VGND VGND VPWR VPWR sky130_fd_sc_hd__fill_1
XFILLER_103_274 VGND VGND VPWR VPWR sky130_fd_sc_hd__fill_1
XFILLER_89_475 VGND VGND VPWR VPWR sky130_fd_sc_hd__fill_2
Xhold2050 _5144_/Q VGND VGND VPWR VPWR _4060_/B2 sky130_fd_sc_hd__dlygate4sd3_1
Xhold2061 _5509_/Q VGND VGND VPWR VPWR _4451_/B2 sky130_fd_sc_hd__dlygate4sd3_1
Xhold2072 _5532_/Q VGND VGND VPWR VPWR _4476_/B2 sky130_fd_sc_hd__dlygate4sd3_1
XFILLER_45_501 VGND VGND VPWR VPWR sky130_fd_sc_hd__decap_3
Xhold1360 _5519_/Q VGND VGND VPWR VPWR _4461_/B2 sky130_fd_sc_hd__dlygate4sd3_1
Xhold2083 _5317_/Q VGND VGND VPWR VPWR _4245_/B2 sky130_fd_sc_hd__dlygate4sd3_1
Xhold2094 _5877_/Q VGND VGND VPWR VPWR _4841_/B2 sky130_fd_sc_hd__dlygate4sd3_1
XFILLER_17_225 VGND VGND VPWR VPWR sky130_fd_sc_hd__decap_3
XFILLER_94_79 VGND VGND VPWR VPWR sky130_fd_sc_hd__decap_3
Xhold1371 _5985_/Q VGND VGND VPWR VPWR _4957_/B2 sky130_fd_sc_hd__dlygate4sd3_1
Xhold1382 _5063_/Q VGND VGND VPWR VPWR _3967_/B2 sky130_fd_sc_hd__dlygate4sd3_1
Xhold1393 _5198_/Q VGND VGND VPWR VPWR _4117_/B2 sky130_fd_sc_hd__dlygate4sd3_1
XTAP_TAPCELL_ROW_15_426 VGND VPWR sky130_fd_sc_hd__tapvpwrvgnd_1
XTAP_TAPCELL_ROW_43_768 VGND VPWR sky130_fd_sc_hd__tapvpwrvgnd_1
XFILLER_43_72 VGND VGND VPWR VPWR sky130_fd_sc_hd__decap_3
XFILLER_9_435 VGND VGND VPWR VPWR sky130_fd_sc_hd__decap_3
XFILLER_13_497 VGND VGND VPWR VPWR sky130_fd_sc_hd__decap_3
XFILLER_9_468 VGND VGND VPWR VPWR sky130_fd_sc_hd__decap_3
XFILLER_9_479 VGND VGND VPWR VPWR sky130_fd_sc_hd__decap_3
XFILLER_5_641 VGND VGND VPWR VPWR sky130_fd_sc_hd__decap_3
XFILLER_5_685 VGND VGND VPWR VPWR sky130_fd_sc_hd__decap_3
XFILLER_4_44 VGND VGND VPWR VPWR sky130_fd_sc_hd__decap_3
XFILLER_67_103 VGND VGND VPWR VPWR sky130_fd_sc_hd__decap_3
XFILLER_68_637 VGND VGND VPWR VPWR sky130_fd_sc_hd__decap_3
X_3110_ _5426_/Q _5074_/Q _3110_/S VGND VGND VPWR VPWR _3110_/X sky130_fd_sc_hd__mux2_1
X_4090_ _5012_/A1 wire524/A wire306/A _4090_/B2 VGND VGND VPWR VPWR _5174_/D sky130_fd_sc_hd__a22o_2
X_3041_ _5135_/Q _5103_/Q _6031_/Q _5999_/Q _3145_/S _3202_/S1 VGND VGND VPWR VPWR
+ _3042_/B sky130_fd_sc_hd__mux4_2
XFILLER_36_545 VGND VGND VPWR VPWR sky130_fd_sc_hd__decap_3
XFILLER_23_228 VGND VGND VPWR VPWR sky130_fd_sc_hd__fill_2
XFILLER_36_589 VGND VGND VPWR VPWR sky130_fd_sc_hd__decap_3
XFILLER_91_684 VGND VGND VPWR VPWR sky130_fd_sc_hd__decap_3
X_4992_ _4992_/A1 _5013_/A2 _5013_/B1 _4992_/B2 VGND VGND VPWR VPWR _6018_/D sky130_fd_sc_hd__a22o_2
XFILLER_51_559 VGND VGND VPWR VPWR sky130_fd_sc_hd__fill_1
X_3943_ _5815_/Q _5751_/Q _3943_/S VGND VGND VPWR VPWR _3943_/X sky130_fd_sc_hd__mux2_1
X_3874_ _3763_/A _3873_/X _3909_/B1 VGND VGND VPWR VPWR _3874_/X sky130_fd_sc_hd__o21a_2
X_5613_ _6034_/CLK _5613_/D VGND VGND VPWR VPWR _5613_/Q sky130_fd_sc_hd__dfxtp_2
X_2825_ _3179_/A1 _2816_/X _2819_/X _2809_/X _3207_/A1 VGND VGND VPWR VPWR _2825_/X
+ sky130_fd_sc_hd__a32o_2
X_5544_ _6024_/CLK _5544_/D VGND VGND VPWR VPWR _5544_/Q sky130_fd_sc_hd__dfxtp_2
X_2756_ _3184_/A1 _2753_/X _2755_/X VGND VGND VPWR VPWR _2756_/X sky130_fd_sc_hd__a21o_2
X_5475_ _5513_/CLK _5475_/D VGND VGND VPWR VPWR _5475_/Q sky130_fd_sc_hd__dfxtp_2
X_2687_ _3206_/C1 _2670_/X _2686_/X _3118_/B2 VGND VGND VPWR VPWR _2687_/X sky130_fd_sc_hd__a22o_2
X_4426_ _4528_/A1 _4426_/A2 _4426_/B1 _4426_/B2 VGND VGND VPWR VPWR _5486_/D sky130_fd_sc_hd__a22o_2
XFILLER_100_200 VGND VGND VPWR VPWR sky130_fd_sc_hd__decap_3
XFILLER_113_561 VGND VGND VPWR VPWR sky130_fd_sc_hd__decap_3
XFILLER_113_572 VGND VGND VPWR VPWR sky130_fd_sc_hd__decap_3
XFILLER_48_17 VGND VGND VPWR VPWR sky130_fd_sc_hd__decap_3
Xfanout436 _4470_/Y VGND VGND VPWR VPWR _4471_/B sky130_fd_sc_hd__clkdlybuf4s25_1
Xfanout425 _4539_/Y VGND VGND VPWR VPWR _4540_/B sky130_fd_sc_hd__clkdlybuf4s25_1
X_4357_ _4529_/A1 _4364_/A2 _4364_/B1 _4357_/B2 VGND VGND VPWR VPWR _5423_/D sky130_fd_sc_hd__a22o_2
XFILLER_100_244 VGND VGND VPWR VPWR sky130_fd_sc_hd__decap_3
Xfanout469 fanout469/A VGND VGND VPWR VPWR _4329_/A2 sky130_fd_sc_hd__clkdlybuf4s25_1
Xfanout458 fanout458/A VGND VGND VPWR VPWR wire459/A sky130_fd_sc_hd__clkdlybuf4s25_1
X_4288_ _4528_/A1 wire475/A wire255/X _4288_/B2 VGND VGND VPWR VPWR _5358_/D sky130_fd_sc_hd__a22o_2
X_3308_ _3308_/A1 _3306_/X _3307_/X _3308_/B2 _3832_/C1 VGND VGND VPWR VPWR _3308_/X
+ sky130_fd_sc_hd__o221a_2
XFILLER_100_266 VGND VGND VPWR VPWR sky130_fd_sc_hd__decap_3
XFILLER_104_12 VGND VGND VPWR VPWR sky130_fd_sc_hd__decap_3
XFILLER_46_309 VGND VGND VPWR VPWR sky130_fd_sc_hd__decap_3
XFILLER_74_629 VGND VGND VPWR VPWR sky130_fd_sc_hd__decap_3
X_6027_ _6027_/CLK _6027_/D VGND VGND VPWR VPWR _6027_/Q sky130_fd_sc_hd__dfxtp_2
X_3239_ _3234_/B _3239_/B VGND VGND VPWR VPWR _3239_/Y sky130_fd_sc_hd__nand2b_4
XFILLER_82_651 VGND VGND VPWR VPWR sky130_fd_sc_hd__fill_1
XFILLER_81_172 VGND VGND VPWR VPWR sky130_fd_sc_hd__decap_3
XTAP_TAPCELL_ROW_64_1018 VGND VPWR sky130_fd_sc_hd__tapvpwrvgnd_1
XFILLER_42_559 VGND VGND VPWR VPWR sky130_fd_sc_hd__decap_3
XTAP_TAPCELL_ROW_40_727 VGND VPWR sky130_fd_sc_hd__tapvpwrvgnd_1
XFILLER_10_445 VGND VGND VPWR VPWR sky130_fd_sc_hd__decap_3
XFILLER_6_416 VGND VGND VPWR VPWR sky130_fd_sc_hd__decap_3
XFILLER_13_86 VGND VGND VPWR VPWR sky130_fd_sc_hd__decap_3
XTAP_TAPCELL_ROW_20_484 VGND VPWR sky130_fd_sc_hd__tapvpwrvgnd_1
XFILLER_89_57 VGND VGND VPWR VPWR sky130_fd_sc_hd__decap_3
XTAP_TAPCELL_ROW_20_495 VGND VPWR sky130_fd_sc_hd__tapvpwrvgnd_1
XFILLER_2_622 VGND VGND VPWR VPWR sky130_fd_sc_hd__decap_3
XTAP_TAPCELL_ROW_75_1147 VGND VPWR sky130_fd_sc_hd__tapvpwrvgnd_1
XFILLER_1_132 VGND VGND VPWR VPWR sky130_fd_sc_hd__decap_3
XFILLER_2_666 VGND VGND VPWR VPWR sky130_fd_sc_hd__decap_3
Xload_slew809 _2993_/S VGND VGND VPWR VPWR _3099_/S sky130_fd_sc_hd__clkbuf_4
XFILLER_89_261 VGND VGND VPWR VPWR sky130_fd_sc_hd__fill_2
Xfanout970 input22/X VGND VGND VPWR VPWR _4520_/A1 sky130_fd_sc_hd__clkdlybuf4s25_1
XFILLER_49_169 VGND VGND VPWR VPWR sky130_fd_sc_hd__decap_3
XTAP_TAPCELL_ROW_48_827 VGND VPWR sky130_fd_sc_hd__tapvpwrvgnd_1
Xfanout981 input19/X VGND VGND VPWR VPWR _5027_/A1 sky130_fd_sc_hd__clkdlybuf4s25_1
XFILLER_58_681 VGND VGND VPWR VPWR sky130_fd_sc_hd__decap_3
XFILLER_64_128 VGND VGND VPWR VPWR sky130_fd_sc_hd__fill_1
Xhold1190 _5326_/Q VGND VGND VPWR VPWR _4254_/B2 sky130_fd_sc_hd__dlygate4sd3_1
XFILLER_18_589 VGND VGND VPWR VPWR sky130_fd_sc_hd__decap_3
XFILLER_72_150 VGND VGND VPWR VPWR sky130_fd_sc_hd__decap_3
XFILLER_73_684 VGND VGND VPWR VPWR sky130_fd_sc_hd__decap_3
XTAP_TAPCELL_ROW_28_584 VGND VPWR sky130_fd_sc_hd__tapvpwrvgnd_1
XTAP_TAPCELL_ROW_86_1287 VGND VPWR sky130_fd_sc_hd__tapvpwrvgnd_1
XTAP_TAPCELL_ROW_86_1276 VGND VPWR sky130_fd_sc_hd__tapvpwrvgnd_1
XFILLER_60_378 VGND VGND VPWR VPWR sky130_fd_sc_hd__fill_2
XFILLER_9_210 VGND VGND VPWR VPWR sky130_fd_sc_hd__decap_3
Xclkload35 _5871_/CLK VGND VGND VPWR VPWR clkload35/X sky130_fd_sc_hd__clkbuf_8
Xclkload24 _6024_/CLK VGND VGND VPWR VPWR clkload24/X sky130_fd_sc_hd__clkbuf_8
Xclkload13 _5824_/CLK VGND VGND VPWR VPWR clkload13/X sky130_fd_sc_hd__clkbuf_8
X_3590_ _5799_/Q _5735_/Q _3943_/S VGND VGND VPWR VPWR _3590_/X sky130_fd_sc_hd__mux2_1
X_2610_ _5244_/Q _5212_/Q _5180_/Q _5148_/Q _2897_/S _2610_/S1 VGND VGND VPWR VPWR
+ _2611_/B sky130_fd_sc_hd__mux4_2
Xclkload46 _6071_/CLK VGND VGND VPWR VPWR clkload46/Y sky130_fd_sc_hd__clkinv_2
X_2541_ _5785_/Q _5721_/Q _2908_/S VGND VGND VPWR VPWR _2541_/X sky130_fd_sc_hd__mux2_1
X_5260_ _6026_/CLK _5260_/D VGND VGND VPWR VPWR _5260_/Q sky130_fd_sc_hd__dfxtp_2
XFILLER_102_509 VGND VGND VPWR VPWR sky130_fd_sc_hd__decap_3
XFILLER_48_3 VGND VGND VPWR VPWR sky130_fd_sc_hd__decap_3
XPHY_EDGE_ROW_10_Left_126 VGND VGND VPWR VPWR sky130_fd_sc_hd__decap_3
X_4211_ _4519_/A1 _4197_/B _4226_/B1 _4211_/B2 VGND VGND VPWR VPWR _5285_/D sky130_fd_sc_hd__a22o_2
XFILLER_68_401 VGND VGND VPWR VPWR sky130_fd_sc_hd__decap_3
X_5191_ _5258_/CLK _5191_/D VGND VGND VPWR VPWR _5191_/Q sky130_fd_sc_hd__dfxtp_2
XFILLER_95_242 VGND VGND VPWR VPWR sky130_fd_sc_hd__decap_3
X_4142_ _4995_/A1 _4154_/A2 _4157_/B1 _4142_/B2 VGND VGND VPWR VPWR _5221_/D sky130_fd_sc_hd__a22o_2
XFILLER_28_309 VGND VGND VPWR VPWR sky130_fd_sc_hd__decap_3
X_4073_ _4995_/A1 _4085_/A2 _4085_/B1 _4073_/B2 VGND VGND VPWR VPWR _5157_/D sky130_fd_sc_hd__a22o_2
XFILLER_110_586 VGND VGND VPWR VPWR sky130_fd_sc_hd__fill_2
XFILLER_36_320 VGND VGND VPWR VPWR sky130_fd_sc_hd__fill_2
XFILLER_49_681 VGND VGND VPWR VPWR sky130_fd_sc_hd__decap_3
XFILLER_95_286 VGND VGND VPWR VPWR sky130_fd_sc_hd__fill_1
X_3024_ _5390_/Q _5358_/Q _5326_/Q _5294_/Q _3015_/S _3024_/S1 VGND VGND VPWR VPWR
+ _3024_/X sky130_fd_sc_hd__mux4_2
X_4975_ _5009_/A1 _4977_/A2 _4977_/B1 _4975_/B2 VGND VGND VPWR VPWR _6003_/D sky130_fd_sc_hd__a22o_2
X_3926_ _5527_/Q _5495_/Q _3926_/S VGND VGND VPWR VPWR _3926_/X sky130_fd_sc_hd__mux2_1
Xclkload7 clkload7/A VGND VGND VPWR VPWR clkload7/X sky130_fd_sc_hd__clkbuf_8
X_3857_ _5524_/Q _5492_/Q _3857_/S VGND VGND VPWR VPWR _3857_/X sky130_fd_sc_hd__mux2_1
X_3788_ _5712_/Q _5680_/Q _5648_/Q _5616_/Q _3676_/S _3788_/S1 VGND VGND VPWR VPWR
+ _3788_/X sky130_fd_sc_hd__mux4_2
X_2808_ _3228_/A1 _2805_/X _2807_/X _3071_/B2 VGND VGND VPWR VPWR _2808_/X sky130_fd_sc_hd__a22o_2
X_5527_ _5879_/CLK _5527_/D VGND VGND VPWR VPWR _5527_/Q sky130_fd_sc_hd__dfxtp_2
X_2739_ _2755_/A1 _2736_/X _2738_/X _2755_/B2 VGND VGND VPWR VPWR _2739_/X sky130_fd_sc_hd__a22o_2
XFILLER_1_9 VGND VGND VPWR VPWR sky130_fd_sc_hd__decap_3
X_5458_ _6066_/CLK _5458_/D VGND VGND VPWR VPWR _5458_/Q sky130_fd_sc_hd__dfxtp_2
XFILLER_99_581 VGND VGND VPWR VPWR sky130_fd_sc_hd__decap_3
Xfanout222 _4469_/B1 VGND VGND VPWR VPWR _4453_/B1 sky130_fd_sc_hd__clkdlybuf4s25_1
Xfanout211 _4505_/Y VGND VGND VPWR VPWR _4537_/B1 sky130_fd_sc_hd__clkdlybuf4s25_1
X_5389_ _5885_/CLK _5389_/D VGND VGND VPWR VPWR _5389_/Q sky130_fd_sc_hd__dfxtp_2
X_4409_ _4885_/A1 _4425_/A2 _4425_/B1 _4409_/B2 VGND VGND VPWR VPWR _5469_/D sky130_fd_sc_hd__a22o_2
XFILLER_115_44 VGND VGND VPWR VPWR sky130_fd_sc_hd__decap_3
Xfanout244 _4333_/Y VGND VGND VPWR VPWR _4350_/B1 sky130_fd_sc_hd__clkdlybuf4s25_1
XFILLER_101_564 VGND VGND VPWR VPWR sky130_fd_sc_hd__decap_3
XFILLER_115_66 VGND VGND VPWR VPWR sky130_fd_sc_hd__decap_3
XFILLER_115_88 VGND VGND VPWR VPWR sky130_fd_sc_hd__decap_3
XFILLER_19_309 VGND VGND VPWR VPWR sky130_fd_sc_hd__fill_2
XTAP_TAPCELL_ROW_70_1088 VGND VPWR sky130_fd_sc_hd__tapvpwrvgnd_1
Xfanout299 _4094_/Y VGND VGND VPWR VPWR fanout299/X sky130_fd_sc_hd__clkdlybuf4s25_1
XFILLER_46_128 VGND VGND VPWR VPWR sky130_fd_sc_hd__decap_3
XFILLER_55_640 VGND VGND VPWR VPWR sky130_fd_sc_hd__decap_3
XFILLER_55_673 VGND VGND VPWR VPWR sky130_fd_sc_hd__fill_1
XFILLER_54_183 VGND VGND VPWR VPWR sky130_fd_sc_hd__decap_3
XTAP_TAPCELL_ROW_25_554 VGND VPWR sky130_fd_sc_hd__tapvpwrvgnd_1
XTAP_TAPCELL_ROW_53_885 VGND VPWR sky130_fd_sc_hd__tapvpwrvgnd_1
XFILLER_109_620 VGND VGND VPWR VPWR sky130_fd_sc_hd__fill_2
XFILLER_109_642 VGND VGND VPWR VPWR sky130_fd_sc_hd__decap_3
XFILLER_108_141 VGND VGND VPWR VPWR sky130_fd_sc_hd__fill_2
XFILLER_40_40 VGND VGND VPWR VPWR sky130_fd_sc_hd__fill_2
XFILLER_111_317 VGND VGND VPWR VPWR sky130_fd_sc_hd__fill_1
XFILLER_49_60 VGND VGND VPWR VPWR sky130_fd_sc_hd__decap_3
XFILLER_77_220 VGND VGND VPWR VPWR sky130_fd_sc_hd__decap_3
Xload_slew639 _3178_/A1 VGND VGND VPWR VPWR _3134_/A1 sky130_fd_sc_hd__buf_4
XFILLER_1_12 VGND VGND VPWR VPWR sky130_fd_sc_hd__decap_3
XFILLER_38_607 VGND VGND VPWR VPWR sky130_fd_sc_hd__decap_3
XTAP_TAPCELL_ROW_88_1305 VGND VPWR sky130_fd_sc_hd__tapvpwrvgnd_1
XFILLER_1_45 VGND VGND VPWR VPWR sky130_fd_sc_hd__decap_3
XFILLER_92_212 VGND VGND VPWR VPWR sky130_fd_sc_hd__decap_3
XFILLER_1_78 VGND VGND VPWR VPWR sky130_fd_sc_hd__decap_3
XFILLER_92_256 VGND VGND VPWR VPWR sky130_fd_sc_hd__decap_3
XFILLER_45_150 VGND VGND VPWR VPWR sky130_fd_sc_hd__fill_1
XFILLER_45_172 VGND VGND VPWR VPWR sky130_fd_sc_hd__decap_3
XFILLER_61_643 VGND VGND VPWR VPWR sky130_fd_sc_hd__decap_3
XFILLER_33_356 VGND VGND VPWR VPWR sky130_fd_sc_hd__decap_3
XFILLER_61_687 VGND VGND VPWR VPWR sky130_fd_sc_hd__fill_1
XFILLER_14_592 VGND VGND VPWR VPWR sky130_fd_sc_hd__decap_3
X_4760_ _4760_/A1 _4762_/A2 _4762_/B1 _4760_/B2 VGND VGND VPWR VPWR _5798_/D sky130_fd_sc_hd__a22o_2
XPHY_EDGE_ROW_112_Right_112 VGND VGND VPWR VPWR sky130_fd_sc_hd__decap_3
X_4691_ _4760_/A1 _4693_/A2 _4693_/B1 _4691_/B2 VGND VGND VPWR VPWR _5734_/D sky130_fd_sc_hd__a22o_2
X_3711_ _5261_/Q _5229_/Q _3712_/S VGND VGND VPWR VPWR _3711_/X sky130_fd_sc_hd__mux2_1
XTAP_TAPCELL_ROW_99_1434 VGND VPWR sky130_fd_sc_hd__tapvpwrvgnd_1
X_3642_ _5706_/Q _5674_/Q _5642_/Q _5610_/Q _3645_/S _3698_/S1 VGND VGND VPWR VPWR
+ _3643_/B sky130_fd_sc_hd__mux4_2
XFILLER_115_601 VGND VGND VPWR VPWR sky130_fd_sc_hd__decap_3
XFILLER_114_100 VGND VGND VPWR VPWR sky130_fd_sc_hd__decap_3
XFILLER_115_623 VGND VGND VPWR VPWR sky130_fd_sc_hd__decap_3
XPHY_EDGE_ROW_49_Right_49 VGND VGND VPWR VPWR sky130_fd_sc_hd__decap_3
X_5312_ _6019_/CLK _5312_/D VGND VGND VPWR VPWR _5312_/Q sky130_fd_sc_hd__dfxtp_2
X_3573_ _5383_/Q _5351_/Q _5319_/Q _5287_/Q _3575_/S _3648_/S1 VGND VGND VPWR VPWR
+ _3573_/X sky130_fd_sc_hd__mux4_2
XFILLER_114_144 VGND VGND VPWR VPWR sky130_fd_sc_hd__fill_2
XFILLER_115_645 VGND VGND VPWR VPWR sky130_fd_sc_hd__decap_3
X_2524_ _3058_/A _2519_/X _3179_/A1 _2523_/X VGND VGND VPWR VPWR _2524_/X sky130_fd_sc_hd__o211a_2
X_5243_ _5938_/CLK _5243_/D VGND VGND VPWR VPWR _5243_/Q sky130_fd_sc_hd__dfxtp_2
X_5174_ _6021_/CLK _5174_/D VGND VGND VPWR VPWR _5174_/Q sky130_fd_sc_hd__dfxtp_2
Xhold1904 _5582_/Q VGND VGND VPWR VPWR _4528_/B2 sky130_fd_sc_hd__dlygate4sd3_1
Xhold1915 _5776_/Q VGND VGND VPWR VPWR _4736_/B2 sky130_fd_sc_hd__dlygate4sd3_1
Xhold1926 _5916_/Q VGND VGND VPWR VPWR _4884_/B2 sky130_fd_sc_hd__dlygate4sd3_1
X_4125_ _5012_/A1 wire516/A wire298/A _4125_/B2 VGND VGND VPWR VPWR _5206_/D sky130_fd_sc_hd__a22o_2
XFILLER_96_595 VGND VGND VPWR VPWR sky130_fd_sc_hd__decap_3
Xhold1937 _5605_/Q VGND VGND VPWR VPWR _4554_/B2 sky130_fd_sc_hd__dlygate4sd3_1
Xhold1948 _5738_/Q VGND VGND VPWR VPWR _4695_/B2 sky130_fd_sc_hd__dlygate4sd3_1
Xhold1959 _5685_/Q VGND VGND VPWR VPWR _4638_/B2 sky130_fd_sc_hd__dlygate4sd3_1
XPHY_EDGE_ROW_58_Right_58 VGND VGND VPWR VPWR sky130_fd_sc_hd__decap_3
XTAP_TAPCELL_ROW_108_1541 VGND VPWR sky130_fd_sc_hd__tapvpwrvgnd_1
X_4056_ input2/X input1/X VGND VGND VPWR VPWR _4946_/B sky130_fd_sc_hd__nand2_2
XFILLER_37_684 VGND VGND VPWR VPWR sky130_fd_sc_hd__decap_3
XFILLER_43_109 VGND VGND VPWR VPWR sky130_fd_sc_hd__decap_3
X_3007_ _3000_/X _3006_/X _3119_/B1 VGND VGND VPWR VPWR _3007_/X sky130_fd_sc_hd__o21a_2
XFILLER_24_356 VGND VGND VPWR VPWR sky130_fd_sc_hd__decap_3
XFILLER_51_164 VGND VGND VPWR VPWR sky130_fd_sc_hd__decap_3
XTAP_TAPCELL_ROW_22_513 VGND VPWR sky130_fd_sc_hd__tapvpwrvgnd_1
X_4958_ _4992_/A1 _4979_/A2 _4979_/B1 _4958_/B2 VGND VGND VPWR VPWR _5986_/D sky130_fd_sc_hd__a22o_2
XTAP_TAPCELL_ROW_50_844 VGND VPWR sky130_fd_sc_hd__tapvpwrvgnd_1
XTAP_TAPCELL_ROW_50_855 VGND VPWR sky130_fd_sc_hd__tapvpwrvgnd_1
X_4889_ _5025_/A1 wire360/X _4895_/B1 _4889_/B2 VGND VGND VPWR VPWR _5921_/D sky130_fd_sc_hd__a22o_2
X_3909_ _3914_/A _3908_/X _3909_/B1 VGND VGND VPWR VPWR _3909_/X sky130_fd_sc_hd__o21a_2
XPHY_EDGE_ROW_67_Right_67 VGND VGND VPWR VPWR sky130_fd_sc_hd__decap_3
XFILLER_106_645 VGND VGND VPWR VPWR sky130_fd_sc_hd__decap_3
XFILLER_10_32 VGND VGND VPWR VPWR sky130_fd_sc_hd__fill_2
XFILLER_106_678 VGND VGND VPWR VPWR sky130_fd_sc_hd__decap_3
XFILLER_79_529 VGND VGND VPWR VPWR sky130_fd_sc_hd__decap_3
XTAP_TAPCELL_ROW_72_1117 VGND VPWR sky130_fd_sc_hd__tapvpwrvgnd_1
XFILLER_87_540 VGND VGND VPWR VPWR sky130_fd_sc_hd__decap_3
Xfanout1006 input15/X VGND VGND VPWR VPWR _3471_/B1 sky130_fd_sc_hd__clkdlybuf4s25_1
Xwire1101 _3907_/S VGND VGND VPWR VPWR _3508_/S sky130_fd_sc_hd__clkbuf_4
Xfanout1039 _3919_/S1 VGND VGND VPWR VPWR _3788_/S1 sky130_fd_sc_hd__clkdlybuf4s25_1
XFILLER_59_275 VGND VGND VPWR VPWR sky130_fd_sc_hd__decap_3
XPHY_EDGE_ROW_76_Right_76 VGND VGND VPWR VPWR sky130_fd_sc_hd__decap_3
Xwire1134 wire1134/A VGND VGND VPWR VPWR _3683_/S sky130_fd_sc_hd__clkbuf_4
XFILLER_19_139 VGND VGND VPWR VPWR sky130_fd_sc_hd__decap_3
XTAP_TAPCELL_ROW_58_944 VGND VPWR sky130_fd_sc_hd__tapvpwrvgnd_1
XFILLER_15_301 VGND VGND VPWR VPWR sky130_fd_sc_hd__decap_3
XTAP_TAPCELL_ROW_2_271 VGND VPWR sky130_fd_sc_hd__tapvpwrvgnd_1
XFILLER_27_172 VGND VGND VPWR VPWR sky130_fd_sc_hd__fill_2
XFILLER_43_676 VGND VGND VPWR VPWR sky130_fd_sc_hd__decap_3
XFILLER_70_451 VGND VGND VPWR VPWR sky130_fd_sc_hd__fill_1
XTAP_TAPCELL_ROW_83_1246 VGND VPWR sky130_fd_sc_hd__tapvpwrvgnd_1
XFILLER_15_389 VGND VGND VPWR VPWR sky130_fd_sc_hd__decap_3
XFILLER_30_315 VGND VGND VPWR VPWR sky130_fd_sc_hd__decap_3
XFILLER_42_197 VGND VGND VPWR VPWR sky130_fd_sc_hd__decap_3
XFILLER_70_473 VGND VGND VPWR VPWR sky130_fd_sc_hd__decap_3
XFILLER_11_584 VGND VGND VPWR VPWR sky130_fd_sc_hd__fill_2
XPHY_EDGE_ROW_85_Right_85 VGND VGND VPWR VPWR sky130_fd_sc_hd__decap_3
Xwire431 _4505_/B VGND VGND VPWR VPWR wire431/X sky130_fd_sc_hd__clkbuf_4
XFILLER_51_94 VGND VGND VPWR VPWR sky130_fd_sc_hd__fill_1
Xwire475 wire475/A VGND VGND VPWR VPWR wire475/X sky130_fd_sc_hd__clkbuf_4
XFILLER_7_599 VGND VGND VPWR VPWR sky130_fd_sc_hd__decap_3
XTAP_TAPCELL_ROW_94_1375 VGND VPWR sky130_fd_sc_hd__tapvpwrvgnd_1
XFILLER_112_604 VGND VGND VPWR VPWR sky130_fd_sc_hd__decap_3
Xload_slew403 _4659_/A2 VGND VGND VPWR VPWR _4674_/A2 sky130_fd_sc_hd__buf_4
XFILLER_112_637 VGND VGND VPWR VPWR sky130_fd_sc_hd__decap_3
XFILLER_112_648 VGND VGND VPWR VPWR sky130_fd_sc_hd__decap_3
XFILLER_32_6 VGND VGND VPWR VPWR sky130_fd_sc_hd__decap_3
XFILLER_97_326 VGND VGND VPWR VPWR sky130_fd_sc_hd__fill_2
Xload_slew447 _4431_/A2 VGND VGND VPWR VPWR _4426_/A2 sky130_fd_sc_hd__buf_2
XPHY_EDGE_ROW_94_Right_94 VGND VGND VPWR VPWR sky130_fd_sc_hd__decap_3
XFILLER_38_415 VGND VGND VPWR VPWR sky130_fd_sc_hd__decap_3
XFILLER_93_543 VGND VGND VPWR VPWR sky130_fd_sc_hd__fill_1
XFILLER_93_554 VGND VGND VPWR VPWR sky130_fd_sc_hd__decap_3
XFILLER_19_673 VGND VGND VPWR VPWR sky130_fd_sc_hd__decap_3
X_5930_ _6060_/CLK _5930_/D VGND VGND VPWR VPWR _5930_/Q sky130_fd_sc_hd__dfxtp_2
XFILLER_34_643 VGND VGND VPWR VPWR sky130_fd_sc_hd__fill_1
XFILLER_34_687 VGND VGND VPWR VPWR sky130_fd_sc_hd__fill_1
X_5861_ _6070_/CLK _5861_/D VGND VGND VPWR VPWR _5861_/Q sky130_fd_sc_hd__dfxtp_2
XFILLER_21_326 VGND VGND VPWR VPWR sky130_fd_sc_hd__fill_2
XFILLER_21_337 VGND VGND VPWR VPWR sky130_fd_sc_hd__fill_1
XFILLER_33_164 VGND VGND VPWR VPWR sky130_fd_sc_hd__decap_3
X_5792_ _6062_/CLK _5792_/D VGND VGND VPWR VPWR _5792_/Q sky130_fd_sc_hd__dfxtp_2
X_4812_ _4880_/A1 _4811_/B wire156/X _4812_/B2 VGND VGND VPWR VPWR _5848_/D sky130_fd_sc_hd__a22o_2
XTAP_TAPCELL_ROW_103_1482 VGND VPWR sky130_fd_sc_hd__tapvpwrvgnd_1
X_4743_ _4843_/A1 wire389/X wire171/X _4743_/B2 VGND VGND VPWR VPWR _5783_/D sky130_fd_sc_hd__a22o_2
X_4674_ _4777_/A1 _4674_/A2 _4674_/B1 _4674_/B2 VGND VGND VPWR VPWR _5719_/D sky130_fd_sc_hd__a22o_2
X_3625_ _5929_/Q _5897_/Q _5865_/Q _5769_/Q _3284_/S _3627_/S1 VGND VGND VPWR VPWR
+ _3626_/B sky130_fd_sc_hd__mux4_2
X_3556_ _5702_/Q _5670_/Q _5638_/Q _5606_/Q _3558_/S _3826_/S1 VGND VGND VPWR VPWR
+ _3556_/X sky130_fd_sc_hd__mux4_2
XFILLER_103_626 VGND VGND VPWR VPWR sky130_fd_sc_hd__decap_3
X_2507_ _3147_/A1 _2505_/X _2506_/X VGND VGND VPWR VPWR _2507_/X sky130_fd_sc_hd__a21o_2
XFILLER_102_114 VGND VGND VPWR VPWR sky130_fd_sc_hd__decap_3
XFILLER_88_359 VGND VGND VPWR VPWR sky130_fd_sc_hd__decap_3
X_5226_ _5258_/CLK _5226_/D VGND VGND VPWR VPWR _5226_/Q sky130_fd_sc_hd__dfxtp_2
X_3487_ _5251_/Q _5219_/Q _3487_/S VGND VGND VPWR VPWR _3487_/X sky130_fd_sc_hd__mux2_1
Xhold1701 _5640_/Q VGND VGND VPWR VPWR _4591_/B2 sky130_fd_sc_hd__dlygate4sd3_1
XFILLER_96_381 VGND VGND VPWR VPWR sky130_fd_sc_hd__decap_3
Xhold1712 _5667_/Q VGND VGND VPWR VPWR _4620_/B2 sky130_fd_sc_hd__dlygate4sd3_1
Xhold1723 _5748_/Q VGND VGND VPWR VPWR _4705_/B2 sky130_fd_sc_hd__dlygate4sd3_1
Xhold1734 _5623_/Q VGND VGND VPWR VPWR _4572_/B2 sky130_fd_sc_hd__dlygate4sd3_1
Xload_slew992 _4795_/A_N VGND VGND VPWR VPWR _4805_/A_N sky130_fd_sc_hd__clkbuf_4
X_5157_ _6033_/CLK _5157_/D VGND VGND VPWR VPWR _5157_/Q sky130_fd_sc_hd__dfxtp_2
Xhold1745 _5724_/Q VGND VGND VPWR VPWR _4681_/B2 sky130_fd_sc_hd__dlygate4sd3_1
Xhold1756 _5454_/Q VGND VGND VPWR VPWR _4391_/B2 sky130_fd_sc_hd__dlygate4sd3_1
Xhold1767 _5664_/Q VGND VGND VPWR VPWR _4617_/B2 sky130_fd_sc_hd__dlygate4sd3_1
Xhold1778 _5599_/Q VGND VGND VPWR VPWR _4548_/B2 sky130_fd_sc_hd__dlygate4sd3_1
X_5088_ _6056_/CLK _5088_/D VGND VGND VPWR VPWR _5088_/Q sky130_fd_sc_hd__dfxtp_2
X_4108_ _4995_/A1 _4120_/A2 _4120_/B1 _4108_/B2 VGND VGND VPWR VPWR _5189_/D sky130_fd_sc_hd__a22o_2
XFILLER_44_429 VGND VGND VPWR VPWR sky130_fd_sc_hd__decap_3
XFILLER_84_587 VGND VGND VPWR VPWR sky130_fd_sc_hd__fill_1
XTAP_TAPCELL_ROW_55_914 VGND VPWR sky130_fd_sc_hd__tapvpwrvgnd_1
Xhold1789 _5065_/Q VGND VGND VPWR VPWR _3969_/B2 sky130_fd_sc_hd__dlygate4sd3_1
X_4039_ _4658_/A1 wire533/X _4055_/B1 _4039_/B2 VGND VGND VPWR VPWR _5127_/D sky130_fd_sc_hd__a22o_2
XFILLER_112_56 VGND VGND VPWR VPWR sky130_fd_sc_hd__decap_3
XFILLER_25_676 VGND VGND VPWR VPWR sky130_fd_sc_hd__decap_3
XFILLER_40_635 VGND VGND VPWR VPWR sky130_fd_sc_hd__decap_3
XTAP_TAPCELL_ROW_35_671 VGND VPWR sky130_fd_sc_hd__tapvpwrvgnd_1
XFILLER_21_31 VGND VGND VPWR VPWR sky130_fd_sc_hd__decap_3
XFILLER_115_3 VGND VGND VPWR VPWR sky130_fd_sc_hd__decap_3
XFILLER_106_442 VGND VGND VPWR VPWR sky130_fd_sc_hd__decap_3
XFILLER_21_75 VGND VGND VPWR VPWR sky130_fd_sc_hd__fill_2
XFILLER_21_97 VGND VGND VPWR VPWR sky130_fd_sc_hd__decap_3
XFILLER_4_536 VGND VGND VPWR VPWR sky130_fd_sc_hd__fill_2
XFILLER_97_57 VGND VGND VPWR VPWR sky130_fd_sc_hd__decap_3
XTAP_TAPCELL_ROW_7_330 VGND VPWR sky130_fd_sc_hd__tapvpwrvgnd_1
XFILLER_94_307 VGND VGND VPWR VPWR sky130_fd_sc_hd__fill_1
XFILLER_47_289 VGND VGND VPWR VPWR sky130_fd_sc_hd__fill_2
XFILLER_16_643 VGND VGND VPWR VPWR sky130_fd_sc_hd__fill_1
XFILLER_46_83 VGND VGND VPWR VPWR sky130_fd_sc_hd__fill_1
XFILLER_46_94 VGND VGND VPWR VPWR sky130_fd_sc_hd__fill_2
XFILLER_62_60 VGND VGND VPWR VPWR sky130_fd_sc_hd__decap_3
XFILLER_30_178 VGND VGND VPWR VPWR sky130_fd_sc_hd__decap_3
XFILLER_7_33 VGND VGND VPWR VPWR sky130_fd_sc_hd__decap_3
XTAP_TAPCELL_ROW_96_1404 VGND VPWR sky130_fd_sc_hd__tapvpwrvgnd_1
Xwire283 wire283/A VGND VGND VPWR VPWR wire283/X sky130_fd_sc_hd__buf_4
XFILLER_7_396 VGND VGND VPWR VPWR sky130_fd_sc_hd__decap_3
XFILLER_7_99 VGND VGND VPWR VPWR sky130_fd_sc_hd__decap_3
X_4390_ _5037_/A1 _4398_/A2 _4398_/B1 _4390_/B2 VGND VGND VPWR VPWR _5453_/D sky130_fd_sc_hd__a22o_2
X_3410_ _3806_/A _3410_/B VGND VGND VPWR VPWR _3410_/X sky130_fd_sc_hd__or2_2
XFILLER_98_624 VGND VGND VPWR VPWR sky130_fd_sc_hd__decap_3
X_3341_ _3341_/A _3341_/B _3341_/C VGND VGND VPWR VPWR _3341_/X sky130_fd_sc_hd__and3_2
Xload_slew200 _4570_/B1 VGND VGND VPWR VPWR _4563_/B1 sky130_fd_sc_hd__clkbuf_4
XFILLER_30_3 VGND VGND VPWR VPWR sky130_fd_sc_hd__decap_3
XFILLER_98_679 VGND VGND VPWR VPWR sky130_fd_sc_hd__fill_1
Xload_slew233 fanout232/X VGND VGND VPWR VPWR _4435_/B1 sky130_fd_sc_hd__buf_2
X_6060_ _6060_/CLK _6060_/D VGND VGND VPWR VPWR _6060_/Q sky130_fd_sc_hd__dfxtp_2
X_3272_ _5785_/Q _5721_/Q _3631_/S VGND VGND VPWR VPWR _3272_/X sky130_fd_sc_hd__mux2_1
XFILLER_66_510 VGND VGND VPWR VPWR sky130_fd_sc_hd__fill_2
XFILLER_87_90 VGND VGND VPWR VPWR sky130_fd_sc_hd__fill_1
Xload_slew288 _4151_/B1 VGND VGND VPWR VPWR _4157_/B1 sky130_fd_sc_hd__buf_4
Xload_slew277 _4168_/B1 VGND VGND VPWR VPWR _4192_/B1 sky130_fd_sc_hd__buf_4
Xload_slew266 _4250_/B1 VGND VGND VPWR VPWR _4260_/B1 sky130_fd_sc_hd__buf_4
X_5011_ _5045_/A1 _5011_/A2 _5011_/B1 _5011_/B2 VGND VGND VPWR VPWR _6037_/D sky130_fd_sc_hd__a22o_2
XFILLER_26_429 VGND VGND VPWR VPWR sky130_fd_sc_hd__fill_1
XFILLER_38_256 VGND VGND VPWR VPWR sky130_fd_sc_hd__fill_1
XFILLER_66_598 VGND VGND VPWR VPWR sky130_fd_sc_hd__decap_3
XFILLER_93_351 VGND VGND VPWR VPWR sky130_fd_sc_hd__decap_3
XFILLER_81_535 VGND VGND VPWR VPWR sky130_fd_sc_hd__fill_1
XTAP_TAPCELL_ROW_105_1511 VGND VPWR sky130_fd_sc_hd__tapvpwrvgnd_1
X_5913_ _6041_/CLK _5913_/D VGND VGND VPWR VPWR _5913_/Q sky130_fd_sc_hd__dfxtp_2
X_5844_ _6068_/CLK _5844_/D VGND VGND VPWR VPWR _5844_/Q sky130_fd_sc_hd__dfxtp_2
XFILLER_61_281 VGND VGND VPWR VPWR sky130_fd_sc_hd__decap_3
XTAP_TAPCELL_ROW_32_630 VGND VPWR sky130_fd_sc_hd__tapvpwrvgnd_1
XFILLER_21_167 VGND VGND VPWR VPWR sky130_fd_sc_hd__fill_1
XFILLER_21_178 VGND VGND VPWR VPWR sky130_fd_sc_hd__decap_3
XFILLER_22_679 VGND VGND VPWR VPWR sky130_fd_sc_hd__decap_3
XTAP_TAPCELL_ROW_60_972 VGND VPWR sky130_fd_sc_hd__tapvpwrvgnd_1
X_5775_ _6063_/CLK _5775_/D VGND VGND VPWR VPWR _5775_/Q sky130_fd_sc_hd__dfxtp_2
X_2987_ _2987_/A _2987_/B VGND VGND VPWR VPWR _2987_/X sky130_fd_sc_hd__or2_2
X_4726_ _4894_/A1 _4741_/A2 _4741_/B1 _4726_/B2 VGND VGND VPWR VPWR _5766_/D sky130_fd_sc_hd__a22o_2
XFILLER_107_228 VGND VGND VPWR VPWR sky130_fd_sc_hd__fill_1
XPHY_EDGE_ROW_2_Left_118 VGND VGND VPWR VPWR sky130_fd_sc_hd__decap_3
X_4657_ _4760_/A1 _4674_/A2 _4674_/B1 _4657_/B2 VGND VGND VPWR VPWR _5702_/D sky130_fd_sc_hd__a22o_2
X_3608_ _5128_/Q _5096_/Q _6024_/Q _5992_/Q _3880_/S _3839_/S1 VGND VGND VPWR VPWR
+ _3608_/X sky130_fd_sc_hd__mux4_2
XFILLER_101_9 VGND VGND VPWR VPWR sky130_fd_sc_hd__decap_3
XFILLER_107_12 VGND VGND VPWR VPWR sky130_fd_sc_hd__decap_3
Xmax_cap561 _2516_/Y VGND VGND VPWR VPWR fanout560/A sky130_fd_sc_hd__buf_4
X_4588_ _4927_/A1 _4574_/B _4600_/B1 _4588_/B2 VGND VGND VPWR VPWR _5637_/D sky130_fd_sc_hd__a22o_2
XFILLER_107_45 VGND VGND VPWR VPWR sky130_fd_sc_hd__decap_3
XFILLER_1_528 VGND VGND VPWR VPWR sky130_fd_sc_hd__decap_3
XFILLER_89_635 VGND VGND VPWR VPWR sky130_fd_sc_hd__fill_1
X_3539_ _5125_/Q _5093_/Q _6021_/Q _5989_/Q _3907_/S _3905_/S1 VGND VGND VPWR VPWR
+ _3540_/B sky130_fd_sc_hd__mux4_2
XFILLER_107_78 VGND VGND VPWR VPWR sky130_fd_sc_hd__decap_3
XFILLER_67_27 VGND VGND VPWR VPWR sky130_fd_sc_hd__decap_3
XTAP_TAPCELL_ROW_4_300 VGND VPWR sky130_fd_sc_hd__tapvpwrvgnd_1
XFILLER_76_318 VGND VGND VPWR VPWR sky130_fd_sc_hd__fill_2
X_5209_ _6035_/CLK _5209_/D VGND VGND VPWR VPWR _5209_/Q sky130_fd_sc_hd__dfxtp_2
Xhold1520 _5970_/Q VGND VGND VPWR VPWR _4940_/B2 sky130_fd_sc_hd__dlygate4sd3_1
Xhold1531 _6040_/Q VGND VGND VPWR VPWR _5016_/B2 sky130_fd_sc_hd__dlygate4sd3_1
Xhold1542 _5186_/Q VGND VGND VPWR VPWR _4105_/B2 sky130_fd_sc_hd__dlygate4sd3_1
Xhold1553 _5159_/Q VGND VGND VPWR VPWR _4075_/B2 sky130_fd_sc_hd__dlygate4sd3_1
XFILLER_29_256 VGND VGND VPWR VPWR sky130_fd_sc_hd__fill_1
XFILLER_84_351 VGND VGND VPWR VPWR sky130_fd_sc_hd__decap_3
Xhold1564 _5651_/Q VGND VGND VPWR VPWR _4602_/B2 sky130_fd_sc_hd__dlygate4sd3_1
Xhold1575 _5770_/Q VGND VGND VPWR VPWR _4730_/B2 sky130_fd_sc_hd__dlygate4sd3_1
Xhold1586 _5543_/Q VGND VGND VPWR VPWR _4487_/B2 sky130_fd_sc_hd__dlygate4sd3_1
Xload_slew1049 _3686_/S1 VGND VGND VPWR VPWR _3929_/S1 sky130_fd_sc_hd__clkbuf_4
XFILLER_17_429 VGND VGND VPWR VPWR sky130_fd_sc_hd__decap_3
XFILLER_72_546 VGND VGND VPWR VPWR sky130_fd_sc_hd__fill_2
XTAP_TAPCELL_ROW_67_1049 VGND VPWR sky130_fd_sc_hd__tapvpwrvgnd_1
Xhold1597 _5594_/Q VGND VGND VPWR VPWR _4543_/B2 sky130_fd_sc_hd__dlygate4sd3_1
XFILLER_16_42 VGND VGND VPWR VPWR sky130_fd_sc_hd__decap_3
XTAP_TAPCELL_ROW_80_1205 VGND VPWR sky130_fd_sc_hd__tapvpwrvgnd_1
XFILLER_40_421 VGND VGND VPWR VPWR sky130_fd_sc_hd__fill_1
XFILLER_9_617 VGND VGND VPWR VPWR sky130_fd_sc_hd__decap_3
XFILLER_12_156 VGND VGND VPWR VPWR sky130_fd_sc_hd__fill_2
XFILLER_13_679 VGND VGND VPWR VPWR sky130_fd_sc_hd__decap_3
XFILLER_32_74 VGND VGND VPWR VPWR sky130_fd_sc_hd__fill_2
XTAP_TAPCELL_ROW_10_368 VGND VPWR sky130_fd_sc_hd__tapvpwrvgnd_1
XFILLER_106_250 VGND VGND VPWR VPWR sky130_fd_sc_hd__fill_2
XTAP_TAPCELL_ROW_78_1189 VGND VPWR sky130_fd_sc_hd__tapvpwrvgnd_1
XTAP_TAPCELL_ROW_91_1345 VGND VPWR sky130_fd_sc_hd__tapvpwrvgnd_1
XFILLER_79_134 VGND VGND VPWR VPWR sky130_fd_sc_hd__decap_3
XFILLER_0_561 VGND VGND VPWR VPWR sky130_fd_sc_hd__decap_3
XTAP_TAPCELL_ROW_18_468 VGND VPWR sky130_fd_sc_hd__tapvpwrvgnd_1
XFILLER_43_270 VGND VGND VPWR VPWR sky130_fd_sc_hd__fill_1
XTAP_TAPCELL_ROW_46_799 VGND VPWR sky130_fd_sc_hd__tapvpwrvgnd_1
X_2910_ wire693/X _2907_/X _2909_/X VGND VGND VPWR VPWR _2910_/X sky130_fd_sc_hd__a21o_2
XFILLER_43_281 VGND VGND VPWR VPWR sky130_fd_sc_hd__fill_1
XFILLER_71_590 VGND VGND VPWR VPWR sky130_fd_sc_hd__decap_3
X_3890_ _5269_/Q _5237_/Q _3895_/S VGND VGND VPWR VPWR _3890_/X sky130_fd_sc_hd__mux2_1
XFILLER_31_465 VGND VGND VPWR VPWR sky130_fd_sc_hd__decap_3
XTAP_TAPCELL_ROW_100_1452 VGND VPWR sky130_fd_sc_hd__tapvpwrvgnd_1
X_2841_ wire643/X _2839_/X _2840_/X _2990_/A1 VGND VGND VPWR VPWR _2841_/X sky130_fd_sc_hd__o22a_2
XFILLER_78_3 VGND VGND VPWR VPWR sky130_fd_sc_hd__fill_1
X_5560_ _6036_/CLK _5560_/D VGND VGND VPWR VPWR _5560_/Q sky130_fd_sc_hd__dfxtp_2
X_2772_ _5187_/Q _5155_/Q _2772_/S VGND VGND VPWR VPWR _2772_/X sky130_fd_sc_hd__mux2_1
XFILLER_8_683 VGND VGND VPWR VPWR sky130_fd_sc_hd__decap_3
X_5491_ _5589_/CLK _5491_/D VGND VGND VPWR VPWR _5491_/Q sky130_fd_sc_hd__dfxtp_2
X_4511_ _5021_/A1 _4532_/A2 _4532_/B1 _4511_/B2 VGND VGND VPWR VPWR _5565_/D sky130_fd_sc_hd__a22o_2
X_4442_ _4510_/A1 _4460_/A2 _4460_/B1 _4442_/B2 VGND VGND VPWR VPWR _5500_/D sky130_fd_sc_hd__a22o_2
XFILLER_98_432 VGND VGND VPWR VPWR sky130_fd_sc_hd__decap_3
X_4373_ _5020_/A1 _4396_/A2 _4396_/B1 _4373_/B2 VGND VGND VPWR VPWR _5436_/D sky130_fd_sc_hd__a22o_2
Xrebuffer1137 _2712_/D VGND VGND VPWR VPWR _2894_/B1 sky130_fd_sc_hd__buf_2
Xfanout629 fanout632/X VGND VGND VPWR VPWR wire630/A sky130_fd_sc_hd__clkbuf_2
X_3324_ _5115_/Q _5083_/Q _6011_/Q _5979_/Q _3300_/S _3566_/S1 VGND VGND VPWR VPWR
+ _3324_/X sky130_fd_sc_hd__mux4_2
XFILLER_112_253 VGND VGND VPWR VPWR sky130_fd_sc_hd__decap_3
XFILLER_85_104 VGND VGND VPWR VPWR sky130_fd_sc_hd__decap_3
XTAP_TAPCELL_ROW_111_1581 VGND VPWR sky130_fd_sc_hd__tapvpwrvgnd_1
X_6043_ _6043_/CLK _6043_/D VGND VGND VPWR VPWR _6043_/Q sky130_fd_sc_hd__dfxtp_2
X_3255_ _3867_/A _3250_/X _3251_/X _3872_/A _3254_/X VGND VGND VPWR VPWR _3255_/X
+ sky130_fd_sc_hd__o221a_2
XFILLER_85_159 VGND VGND VPWR VPWR sky130_fd_sc_hd__fill_1
X_3186_ _3179_/X _3185_/X _2619_/A VGND VGND VPWR VPWR _3186_/X sky130_fd_sc_hd__o21a_2
XFILLER_93_181 VGND VGND VPWR VPWR sky130_fd_sc_hd__fill_2
X_5827_ _6051_/CLK _5827_/D VGND VGND VPWR VPWR _5827_/Q sky130_fd_sc_hd__dfxtp_2
XFILLER_6_609 VGND VGND VPWR VPWR sky130_fd_sc_hd__decap_3
X_5758_ _6046_/CLK _5758_/D VGND VGND VPWR VPWR _5758_/Q sky130_fd_sc_hd__dfxtp_2
X_4709_ input5/X input4/X _4709_/C VGND VGND VPWR VPWR _4878_/B sky130_fd_sc_hd__or3_2
X_5689_ _5785_/CLK _5689_/D VGND VGND VPWR VPWR _5689_/Q sky130_fd_sc_hd__dfxtp_2
XFILLER_103_220 VGND VGND VPWR VPWR sky130_fd_sc_hd__decap_3
XFILLER_76_148 VGND VGND VPWR VPWR sky130_fd_sc_hd__decap_3
XFILLER_94_14 VGND VGND VPWR VPWR sky130_fd_sc_hd__decap_3
Xhold2040 _5236_/Q VGND VGND VPWR VPWR _4157_/B2 sky130_fd_sc_hd__dlygate4sd3_1
Xhold2051 _5288_/Q VGND VGND VPWR VPWR _4214_/B2 sky130_fd_sc_hd__dlygate4sd3_1
Xhold2062 _5235_/Q VGND VGND VPWR VPWR _4156_/B2 sky130_fd_sc_hd__dlygate4sd3_1
Xhold1350 _5342_/Q VGND VGND VPWR VPWR _4272_/B2 sky130_fd_sc_hd__dlygate4sd3_1
Xhold1361 _5681_/Q VGND VGND VPWR VPWR _4634_/B2 sky130_fd_sc_hd__dlygate4sd3_1
Xhold2073 _5927_/Q VGND VGND VPWR VPWR _4895_/B2 sky130_fd_sc_hd__dlygate4sd3_1
Xhold2084 _5544_/Q VGND VGND VPWR VPWR _4488_/B2 sky130_fd_sc_hd__dlygate4sd3_1
Xhold2095 _5687_/Q VGND VGND VPWR VPWR _4640_/B2 sky130_fd_sc_hd__dlygate4sd3_1
XFILLER_27_63 VGND VGND VPWR VPWR sky130_fd_sc_hd__decap_3
XFILLER_45_513 VGND VGND VPWR VPWR sky130_fd_sc_hd__decap_3
Xhold1372 _6048_/Q VGND VGND VPWR VPWR _5024_/B2 sky130_fd_sc_hd__dlygate4sd3_1
Xhold1383 _5194_/Q VGND VGND VPWR VPWR _4113_/B2 sky130_fd_sc_hd__dlygate4sd3_1
Xhold1394 _5660_/Q VGND VGND VPWR VPWR _4613_/B2 sky130_fd_sc_hd__dlygate4sd3_1
XFILLER_60_516 VGND VGND VPWR VPWR sky130_fd_sc_hd__decap_3
XFILLER_25_281 VGND VGND VPWR VPWR sky130_fd_sc_hd__decap_3
XFILLER_53_590 VGND VGND VPWR VPWR sky130_fd_sc_hd__decap_3
XTAP_TAPCELL_ROW_15_427 VGND VPWR sky130_fd_sc_hd__tapvpwrvgnd_1
XTAP_TAPCELL_ROW_43_769 VGND VPWR sky130_fd_sc_hd__tapvpwrvgnd_1
XFILLER_9_414 VGND VGND VPWR VPWR sky130_fd_sc_hd__decap_3
XFILLER_9_447 VGND VGND VPWR VPWR sky130_fd_sc_hd__fill_1
XFILLER_5_620 VGND VGND VPWR VPWR sky130_fd_sc_hd__decap_3
XFILLER_64_9 VGND VGND VPWR VPWR sky130_fd_sc_hd__fill_1
XFILLER_4_141 VGND VGND VPWR VPWR sky130_fd_sc_hd__decap_3
XFILLER_5_653 VGND VGND VPWR VPWR sky130_fd_sc_hd__decap_3
XFILLER_114_529 VGND VGND VPWR VPWR sky130_fd_sc_hd__decap_3
XFILLER_4_12 VGND VGND VPWR VPWR sky130_fd_sc_hd__decap_3
XFILLER_4_56 VGND VGND VPWR VPWR sky130_fd_sc_hd__decap_3
XFILLER_68_81 VGND VGND VPWR VPWR sky130_fd_sc_hd__decap_3
XFILLER_68_92 VGND VGND VPWR VPWR sky130_fd_sc_hd__decap_3
XFILLER_48_340 VGND VGND VPWR VPWR sky130_fd_sc_hd__fill_1
X_3040_ _3198_/A _3036_/X _3039_/X _3207_/A1 VGND VGND VPWR VPWR _3040_/X sky130_fd_sc_hd__o211a_2
XFILLER_91_630 VGND VGND VPWR VPWR sky130_fd_sc_hd__decap_3
XFILLER_84_91 VGND VGND VPWR VPWR sky130_fd_sc_hd__decap_3
XFILLER_91_663 VGND VGND VPWR VPWR sky130_fd_sc_hd__fill_1
X_4991_ _4991_/A1 _5013_/A2 _5013_/B1 _4991_/B2 VGND VGND VPWR VPWR _6017_/D sky130_fd_sc_hd__a22o_2
X_3942_ _5431_/Q _5079_/Q _3943_/S VGND VGND VPWR VPWR _3942_/X sky130_fd_sc_hd__mux2_1
X_3873_ _5204_/Q _5172_/Q _3873_/S VGND VGND VPWR VPWR _3873_/X sky130_fd_sc_hd__mux2_1
X_5612_ _6049_/CLK _5612_/D VGND VGND VPWR VPWR _5612_/Q sky130_fd_sc_hd__dfxtp_2
X_2824_ _2816_/A _2820_/X _2823_/X _3185_/A1 VGND VGND VPWR VPWR _2824_/X sky130_fd_sc_hd__o211a_2
X_5543_ _5943_/CLK _5543_/D VGND VGND VPWR VPWR _5543_/Q sky130_fd_sc_hd__dfxtp_2
X_2755_ _2755_/A1 _2752_/X _2754_/X _2755_/B2 VGND VGND VPWR VPWR _2755_/X sky130_fd_sc_hd__a22o_2
X_5474_ _5879_/CLK _5474_/D VGND VGND VPWR VPWR _5474_/Q sky130_fd_sc_hd__dfxtp_2
X_2686_ _3228_/B2 _2683_/X _2685_/X VGND VGND VPWR VPWR _2686_/X sky130_fd_sc_hd__a21o_2
XTAP_TAPCELL_ROW_113_1610 VGND VPWR sky130_fd_sc_hd__tapvpwrvgnd_1
X_4425_ _4527_/A1 _4425_/A2 _4425_/B1 _4425_/B2 VGND VGND VPWR VPWR _5485_/D sky130_fd_sc_hd__a22o_2
XPHY_EDGE_ROW_92_Left_208 VGND VGND VPWR VPWR sky130_fd_sc_hd__decap_3
Xfanout404 _4641_/Y VGND VGND VPWR VPWR _4642_/B sky130_fd_sc_hd__clkdlybuf4s25_1
X_4356_ _4768_/A1 wire462/A wire242/X _4356_/B2 VGND VGND VPWR VPWR _5422_/D sky130_fd_sc_hd__a22o_2
XFILLER_113_584 VGND VGND VPWR VPWR sky130_fd_sc_hd__decap_3
XFILLER_48_29 VGND VGND VPWR VPWR sky130_fd_sc_hd__decap_3
XFILLER_98_251 VGND VGND VPWR VPWR sky130_fd_sc_hd__fill_1
XFILLER_98_273 VGND VGND VPWR VPWR sky130_fd_sc_hd__decap_3
Xfanout448 _4402_/Y VGND VGND VPWR VPWR _4433_/A2 sky130_fd_sc_hd__clkdlybuf4s25_1
Xfanout415 _4573_/Y VGND VGND VPWR VPWR _4605_/A2 sky130_fd_sc_hd__clkdlybuf4s25_1
X_3307_ _5402_/Q _5050_/Q _3318_/S VGND VGND VPWR VPWR _3307_/X sky130_fd_sc_hd__mux2_1
XFILLER_86_435 VGND VGND VPWR VPWR sky130_fd_sc_hd__fill_1
X_4287_ _4527_/A1 _4292_/A2 _4287_/B1 _4287_/B2 VGND VGND VPWR VPWR _5357_/D sky130_fd_sc_hd__a22o_2
XFILLER_100_256 VGND VGND VPWR VPWR sky130_fd_sc_hd__fill_2
XFILLER_104_24 VGND VGND VPWR VPWR sky130_fd_sc_hd__decap_3
X_6026_ _6026_/CLK _6026_/D VGND VGND VPWR VPWR _6026_/Q sky130_fd_sc_hd__dfxtp_2
X_3238_ _3234_/B _3239_/B VGND VGND VPWR VPWR _3238_/X sky130_fd_sc_hd__and2b_2
XFILLER_100_278 VGND VGND VPWR VPWR sky130_fd_sc_hd__decap_3
X_3169_ _5941_/Q _5909_/Q _5877_/Q _5781_/Q _2897_/S _3180_/S1 VGND VGND VPWR VPWR
+ _3169_/X sky130_fd_sc_hd__mux4_2
XFILLER_27_546 VGND VGND VPWR VPWR sky130_fd_sc_hd__decap_3
XFILLER_66_192 VGND VGND VPWR VPWR sky130_fd_sc_hd__decap_3
Xclkbuf_leaf_93_clk clkload0/A VGND VGND VPWR VPWR _5683_/CLK sky130_fd_sc_hd__clkbuf_8
XFILLER_54_365 VGND VGND VPWR VPWR sky130_fd_sc_hd__fill_1
XTAP_TAPCELL_ROW_64_1019 VGND VPWR sky130_fd_sc_hd__tapvpwrvgnd_1
XFILLER_10_424 VGND VGND VPWR VPWR sky130_fd_sc_hd__decap_3
XFILLER_22_262 VGND VGND VPWR VPWR sky130_fd_sc_hd__fill_2
XTAP_TAPCELL_ROW_40_728 VGND VPWR sky130_fd_sc_hd__tapvpwrvgnd_1
XFILLER_13_54 VGND VGND VPWR VPWR sky130_fd_sc_hd__fill_2
XFILLER_108_334 VGND VGND VPWR VPWR sky130_fd_sc_hd__fill_1
XFILLER_13_98 VGND VGND VPWR VPWR sky130_fd_sc_hd__decap_3
XTAP_TAPCELL_ROW_20_485 VGND VPWR sky130_fd_sc_hd__tapvpwrvgnd_1
XFILLER_2_601 VGND VGND VPWR VPWR sky130_fd_sc_hd__decap_3
XTAP_TAPCELL_ROW_75_1148 VGND VPWR sky130_fd_sc_hd__tapvpwrvgnd_1
XFILLER_2_634 VGND VGND VPWR VPWR sky130_fd_sc_hd__decap_3
XFILLER_2_645 VGND VGND VPWR VPWR sky130_fd_sc_hd__decap_3
XFILLER_8_3 VGND VGND VPWR VPWR sky130_fd_sc_hd__decap_3
XFILLER_2_678 VGND VGND VPWR VPWR sky130_fd_sc_hd__decap_3
XFILLER_49_104 VGND VGND VPWR VPWR sky130_fd_sc_hd__fill_2
XFILLER_77_402 VGND VGND VPWR VPWR sky130_fd_sc_hd__fill_1
Xfanout960 _4762_/A1 VGND VGND VPWR VPWR _4998_/A1 sky130_fd_sc_hd__clkdlybuf4s25_1
Xfanout982 input19/X VGND VGND VPWR VPWR _4517_/A1 sky130_fd_sc_hd__clkdlybuf4s25_1
Xfanout993 input16/X VGND VGND VPWR VPWR _4807_/A_N sky130_fd_sc_hd__clkdlybuf4s25_1
Xfanout971 input22/X VGND VGND VPWR VPWR _4760_/A1 sky130_fd_sc_hd__clkdlybuf4s25_1
XTAP_TAPCELL_ROW_48_828 VGND VPWR sky130_fd_sc_hd__tapvpwrvgnd_1
XFILLER_73_641 VGND VGND VPWR VPWR sky130_fd_sc_hd__decap_3
Xhold1180 _6011_/Q VGND VGND VPWR VPWR _4985_/B2 sky130_fd_sc_hd__dlygate4sd3_1
Xhold1191 _5301_/Q VGND VGND VPWR VPWR _4227_/B2 sky130_fd_sc_hd__dlygate4sd3_1
Xclkbuf_leaf_84_clk clkbuf_4_4_0_clk/X VGND VGND VPWR VPWR _5691_/CLK sky130_fd_sc_hd__clkbuf_8
XFILLER_33_505 VGND VGND VPWR VPWR sky130_fd_sc_hd__decap_3
XFILLER_72_162 VGND VGND VPWR VPWR sky130_fd_sc_hd__decap_3
XTAP_TAPCELL_ROW_86_1277 VGND VPWR sky130_fd_sc_hd__tapvpwrvgnd_1
XTAP_TAPCELL_ROW_28_585 VGND VPWR sky130_fd_sc_hd__tapvpwrvgnd_1
XFILLER_13_251 VGND VGND VPWR VPWR sky130_fd_sc_hd__decap_3
XFILLER_13_284 VGND VGND VPWR VPWR sky130_fd_sc_hd__fill_1
XFILLER_41_593 VGND VGND VPWR VPWR sky130_fd_sc_hd__decap_3
XFILLER_9_222 VGND VGND VPWR VPWR sky130_fd_sc_hd__fill_2
XFILLER_9_233 VGND VGND VPWR VPWR sky130_fd_sc_hd__decap_3
XFILLER_62_6 VGND VGND VPWR VPWR sky130_fd_sc_hd__fill_1
Xclkload25 _5525_/CLK VGND VGND VPWR VPWR clkload25/X sky130_fd_sc_hd__clkbuf_8
Xclkload14 _5838_/CLK VGND VGND VPWR VPWR clkload14/X sky130_fd_sc_hd__clkbuf_8
Xclkload47 _5578_/CLK VGND VGND VPWR VPWR clkload47/X sky130_fd_sc_hd__clkbuf_4
Xclkload36 _5797_/CLK VGND VGND VPWR VPWR clkload36/X sky130_fd_sc_hd__clkbuf_8
X_2540_ _5401_/Q _5049_/Q _2908_/S VGND VGND VPWR VPWR _2540_/X sky130_fd_sc_hd__mux2_1
X_4210_ _4312_/A1 _4226_/A2 _4226_/B1 _4210_/B2 VGND VGND VPWR VPWR _5284_/D sky130_fd_sc_hd__a22o_2
X_5190_ _6029_/CLK _5190_/D VGND VGND VPWR VPWR _5190_/Q sky130_fd_sc_hd__dfxtp_2
XFILLER_68_435 VGND VGND VPWR VPWR sky130_fd_sc_hd__decap_3
XFILLER_95_221 VGND VGND VPWR VPWR sky130_fd_sc_hd__decap_3
X_4141_ _4312_/A1 _4154_/A2 _4157_/B1 _4141_/B2 VGND VGND VPWR VPWR _5220_/D sky130_fd_sc_hd__a22o_2
X_4072_ _4312_/A1 _4085_/A2 _4088_/B1 _4072_/B2 VGND VGND VPWR VPWR _5156_/D sky130_fd_sc_hd__a22o_2
XFILLER_110_598 VGND VGND VPWR VPWR sky130_fd_sc_hd__decap_3
XFILLER_83_427 VGND VGND VPWR VPWR sky130_fd_sc_hd__decap_3
X_3023_ _3179_/A1 _3019_/X _3022_/X _3017_/X VGND VGND VPWR VPWR _3023_/X sky130_fd_sc_hd__a31o_2
Xclkbuf_leaf_75_clk clkload2/A VGND VGND VPWR VPWR _5805_/CLK sky130_fd_sc_hd__clkbuf_8
XFILLER_36_365 VGND VGND VPWR VPWR sky130_fd_sc_hd__decap_3
XFILLER_63_184 VGND VGND VPWR VPWR sky130_fd_sc_hd__fill_2
X_4974_ _5008_/A1 _4974_/A2 _4974_/B1 _4974_/B2 VGND VGND VPWR VPWR _6002_/D sky130_fd_sc_hd__a22o_2
X_3925_ _5591_/Q _5559_/Q _3926_/S VGND VGND VPWR VPWR _3925_/X sky130_fd_sc_hd__mux2_1
Xclkload8 clkload8/A VGND VGND VPWR VPWR clkload8/X sky130_fd_sc_hd__clkbuf_8
X_3856_ _5396_/Q _5364_/Q _5332_/Q _5300_/Q _3857_/S _3868_/S1 VGND VGND VPWR VPWR
+ _3856_/X sky130_fd_sc_hd__mux4_2
X_3787_ _3784_/X _3786_/X wire630/X VGND VGND VPWR VPWR _3787_/X sky130_fd_sc_hd__o21a_2
X_2807_ _5797_/Q _5733_/Q _3093_/S VGND VGND VPWR VPWR _2807_/X sky130_fd_sc_hd__mux2_1
X_5526_ _5797_/CLK _5526_/D VGND VGND VPWR VPWR _5526_/Q sky130_fd_sc_hd__dfxtp_2
X_2738_ _6050_/Q _5954_/Q _2738_/S VGND VGND VPWR VPWR _2738_/X sky130_fd_sc_hd__mux2_1
X_5457_ _6065_/CLK _5457_/D VGND VGND VPWR VPWR _5457_/Q sky130_fd_sc_hd__dfxtp_2
XFILLER_105_337 VGND VGND VPWR VPWR sky130_fd_sc_hd__fill_2
X_4408_ _4510_/A1 _4426_/A2 _4426_/B1 _4408_/B2 VGND VGND VPWR VPWR _5468_/D sky130_fd_sc_hd__a22o_2
X_2669_ _3228_/A1 _2666_/X _2668_/X _3071_/B2 VGND VGND VPWR VPWR _2669_/X sky130_fd_sc_hd__a22o_2
XFILLER_115_12 VGND VGND VPWR VPWR sky130_fd_sc_hd__decap_3
Xfanout212 _4471_/Y VGND VGND VPWR VPWR _4494_/B1 sky130_fd_sc_hd__clkdlybuf4s25_1
Xfanout201 fanout204/A VGND VGND VPWR VPWR _4571_/B1 sky130_fd_sc_hd__clkdlybuf4s25_1
X_5388_ _6017_/CLK _5388_/D VGND VGND VPWR VPWR _5388_/Q sky130_fd_sc_hd__dfxtp_2
Xfanout256 _4297_/B1 VGND VGND VPWR VPWR _4287_/B1 sky130_fd_sc_hd__clkdlybuf4s25_1
Xfanout234 _4368_/Y VGND VGND VPWR VPWR _4375_/B1 sky130_fd_sc_hd__clkdlybuf4s25_1
X_4339_ _4751_/A1 wire465/X _4360_/B1 _4339_/B2 VGND VGND VPWR VPWR _5405_/D sky130_fd_sc_hd__a22o_2
XFILLER_101_576 VGND VGND VPWR VPWR sky130_fd_sc_hd__decap_3
XFILLER_115_78 VGND VGND VPWR VPWR sky130_fd_sc_hd__decap_3
XTAP_TAPCELL_ROW_70_1089 VGND VPWR sky130_fd_sc_hd__tapvpwrvgnd_1
Xfanout289 wire292/A VGND VGND VPWR VPWR wire290/A sky130_fd_sc_hd__clkdlybuf4s25_1
Xfanout278 wire281/A VGND VGND VPWR VPWR _4185_/B1 sky130_fd_sc_hd__clkdlybuf4s25_1
Xfanout267 _4231_/Y VGND VGND VPWR VPWR _4263_/B1 sky130_fd_sc_hd__clkdlybuf4s25_1
XFILLER_74_449 VGND VGND VPWR VPWR sky130_fd_sc_hd__fill_1
X_6009_ _6035_/CLK _6009_/D VGND VGND VPWR VPWR _6009_/Q sky130_fd_sc_hd__dfxtp_2
XFILLER_55_652 VGND VGND VPWR VPWR sky130_fd_sc_hd__fill_1
Xclkbuf_leaf_66_clk clkbuf_4_6_0_clk/X VGND VGND VPWR VPWR _5885_/CLK sky130_fd_sc_hd__clkbuf_8
XFILLER_91_15 VGND VGND VPWR VPWR sky130_fd_sc_hd__decap_3
XFILLER_54_195 VGND VGND VPWR VPWR sky130_fd_sc_hd__fill_1
XFILLER_70_633 VGND VGND VPWR VPWR sky130_fd_sc_hd__decap_3
XFILLER_91_37 VGND VGND VPWR VPWR sky130_fd_sc_hd__decap_3
XTAP_TAPCELL_ROW_25_544 VGND VPWR sky130_fd_sc_hd__tapvpwrvgnd_1
XTAP_TAPCELL_ROW_25_555 VGND VPWR sky130_fd_sc_hd__tapvpwrvgnd_1
XFILLER_23_593 VGND VGND VPWR VPWR sky130_fd_sc_hd__decap_3
XFILLER_24_64 VGND VGND VPWR VPWR sky130_fd_sc_hd__fill_2
XTAP_TAPCELL_ROW_53_886 VGND VPWR sky130_fd_sc_hd__tapvpwrvgnd_1
XFILLER_109_610 VGND VGND VPWR VPWR sky130_fd_sc_hd__decap_3
XFILLER_108_131 VGND VGND VPWR VPWR sky130_fd_sc_hd__decap_3
XFILLER_109_654 VGND VGND VPWR VPWR sky130_fd_sc_hd__decap_3
XFILLER_109_676 VGND VGND VPWR VPWR sky130_fd_sc_hd__decap_3
XFILLER_108_175 VGND VGND VPWR VPWR sky130_fd_sc_hd__decap_3
XFILLER_40_74 VGND VGND VPWR VPWR sky130_fd_sc_hd__fill_2
XFILLER_40_85 VGND VGND VPWR VPWR sky130_fd_sc_hd__decap_3
XFILLER_97_508 VGND VGND VPWR VPWR sky130_fd_sc_hd__fill_2
XFILLER_2_475 VGND VGND VPWR VPWR sky130_fd_sc_hd__fill_1
Xload_slew618 _3234_/X VGND VGND VPWR VPWR _3842_/A1 sky130_fd_sc_hd__buf_6
Xload_slew607 _3308_/B2 VGND VGND VPWR VPWR _3713_/A1 sky130_fd_sc_hd__buf_4
XFILLER_27_9 VGND VGND VPWR VPWR sky130_fd_sc_hd__decap_3
XFILLER_77_243 VGND VGND VPWR VPWR sky130_fd_sc_hd__decap_3
XTAP_TAPCELL_ROW_88_1306 VGND VPWR sky130_fd_sc_hd__tapvpwrvgnd_1
XFILLER_1_24 VGND VGND VPWR VPWR sky130_fd_sc_hd__decap_3
Xfanout790 fanout822/X VGND VGND VPWR VPWR _3182_/S sky130_fd_sc_hd__clkbuf_2
XFILLER_1_57 VGND VGND VPWR VPWR sky130_fd_sc_hd__decap_3
XFILLER_65_60 VGND VGND VPWR VPWR sky130_fd_sc_hd__fill_1
Xclkbuf_leaf_57_clk clkload6/A VGND VGND VPWR VPWR _5815_/CLK sky130_fd_sc_hd__clkbuf_8
XFILLER_46_685 VGND VGND VPWR VPWR sky130_fd_sc_hd__decap_3
XFILLER_65_93 VGND VGND VPWR VPWR sky130_fd_sc_hd__fill_1
XFILLER_73_482 VGND VGND VPWR VPWR sky130_fd_sc_hd__fill_2
XFILLER_60_187 VGND VGND VPWR VPWR sky130_fd_sc_hd__fill_1
X_3710_ _5133_/Q _5101_/Q _6029_/Q _5997_/Q _3712_/S _3717_/S1 VGND VGND VPWR VPWR
+ _3710_/X sky130_fd_sc_hd__mux4_2
X_4690_ _5029_/A1 _4707_/A2 _4707_/B1 _4690_/B2 VGND VGND VPWR VPWR _5733_/D sky130_fd_sc_hd__a22o_2
XTAP_TAPCELL_ROW_99_1435 VGND VPWR sky130_fd_sc_hd__tapvpwrvgnd_1
X_3641_ _3687_/A _3637_/X _3640_/X _3909_/B1 VGND VGND VPWR VPWR _3641_/X sky130_fd_sc_hd__o211a_2
XFILLER_60_3 VGND VGND VPWR VPWR sky130_fd_sc_hd__decap_3
X_3572_ _3560_/X _3570_/X _3571_/X _3614_/A VGND VGND VPWR VPWR _3572_/X sky130_fd_sc_hd__o31a_2
XFILLER_115_613 VGND VGND VPWR VPWR sky130_fd_sc_hd__decap_3
XFILLER_115_635 VGND VGND VPWR VPWR sky130_fd_sc_hd__decap_3
X_5311_ _5578_/CLK _5311_/D VGND VGND VPWR VPWR _5311_/Q sky130_fd_sc_hd__dfxtp_2
X_2523_ _2499_/A _2520_/X _2521_/X _3195_/A1 VGND VGND VPWR VPWR _2523_/X sky130_fd_sc_hd__o22a_2
XFILLER_115_657 VGND VGND VPWR VPWR sky130_fd_sc_hd__decap_3
XFILLER_115_679 VGND VGND VPWR VPWR sky130_fd_sc_hd__decap_3
X_5242_ _5914_/CLK _5242_/D VGND VGND VPWR VPWR _5242_/Q sky130_fd_sc_hd__dfxtp_2
XFILLER_96_530 VGND VGND VPWR VPWR sky130_fd_sc_hd__fill_2
X_5173_ _6037_/CLK _5173_/D VGND VGND VPWR VPWR _5173_/Q sky130_fd_sc_hd__dfxtp_2
XFILLER_96_541 VGND VGND VPWR VPWR sky130_fd_sc_hd__decap_3
Xhold1905 _5884_/Q VGND VGND VPWR VPWR _4850_/B2 sky130_fd_sc_hd__dlygate4sd3_1
Xhold1916 _5487_/Q VGND VGND VPWR VPWR _4427_/B2 sky130_fd_sc_hd__dlygate4sd3_1
Xhold1927 _5539_/Q VGND VGND VPWR VPWR _4483_/B2 sky130_fd_sc_hd__dlygate4sd3_1
X_4124_ _4943_/A1 _4124_/A2 _4124_/B1 _4124_/B2 VGND VGND VPWR VPWR _5205_/D sky130_fd_sc_hd__a22o_2
Xhold1938 _5150_/Q VGND VGND VPWR VPWR _4066_/B2 sky130_fd_sc_hd__dlygate4sd3_1
Xhold1949 _5466_/Q VGND VGND VPWR VPWR _4406_/B2 sky130_fd_sc_hd__dlygate4sd3_1
Xinput1 rd[0] VGND VGND VPWR VPWR input1/X sky130_fd_sc_hd__clkdlybuf4s25_1
Xclkbuf_leaf_48_clk clkload7/A VGND VGND VPWR VPWR _6058_/CLK sky130_fd_sc_hd__clkbuf_8
X_4055_ _5013_/A1 wire533/X _4055_/B1 _4055_/B2 VGND VGND VPWR VPWR _5143_/D sky130_fd_sc_hd__a22o_2
XFILLER_52_600 VGND VGND VPWR VPWR sky130_fd_sc_hd__decap_3
XTAP_TAPCELL_ROW_108_1542 VGND VPWR sky130_fd_sc_hd__tapvpwrvgnd_1
X_3006_ _3106_/C1 _2987_/X _2990_/X _2995_/X _3005_/X VGND VGND VPWR VPWR _3006_/X
+ sky130_fd_sc_hd__a311o_2
XFILLER_52_633 VGND VGND VPWR VPWR sky130_fd_sc_hd__decap_3
XFILLER_91_290 VGND VGND VPWR VPWR sky130_fd_sc_hd__decap_3
XFILLER_24_368 VGND VGND VPWR VPWR sky130_fd_sc_hd__decap_3
XFILLER_24_379 VGND VGND VPWR VPWR sky130_fd_sc_hd__fill_1
XTAP_TAPCELL_ROW_22_514 VGND VPWR sky130_fd_sc_hd__tapvpwrvgnd_1
X_4957_ _4991_/A1 _4979_/A2 _4979_/B1 _4957_/B2 VGND VGND VPWR VPWR _5985_/D sky130_fd_sc_hd__a22o_2
XTAP_TAPCELL_ROW_50_845 VGND VPWR sky130_fd_sc_hd__tapvpwrvgnd_1
X_4888_ _5024_/A1 _4902_/A2 wire139/X _4888_/B2 VGND VGND VPWR VPWR _5920_/D sky130_fd_sc_hd__a22o_2
X_3908_ _5270_/Q _5238_/Q _3908_/S VGND VGND VPWR VPWR _3908_/X sky130_fd_sc_hd__mux2_1
X_3839_ _5395_/Q _5363_/Q _5331_/Q _5299_/Q _3487_/S _3839_/S1 VGND VGND VPWR VPWR
+ _3839_/X sky130_fd_sc_hd__mux4_2
XFILLER_106_657 VGND VGND VPWR VPWR sky130_fd_sc_hd__decap_3
XFILLER_3_228 VGND VGND VPWR VPWR sky130_fd_sc_hd__fill_2
X_5509_ _5832_/CLK _5509_/D VGND VGND VPWR VPWR _5509_/Q sky130_fd_sc_hd__dfxtp_2
XFILLER_105_167 VGND VGND VPWR VPWR sky130_fd_sc_hd__fill_1
XTAP_TAPCELL_ROW_72_1118 VGND VPWR sky130_fd_sc_hd__tapvpwrvgnd_1
Xfanout1029 _3878_/S1 VGND VGND VPWR VPWR _3304_/S1 sky130_fd_sc_hd__clkdlybuf4s25_1
Xfanout1018 _3718_/A VGND VGND VPWR VPWR _3806_/A sky130_fd_sc_hd__clkdlybuf4s25_1
Xfanout1007 _3612_/C1 VGND VGND VPWR VPWR _3261_/B sky130_fd_sc_hd__clkbuf_4
XFILLER_101_340 VGND VGND VPWR VPWR sky130_fd_sc_hd__decap_3
XFILLER_87_552 VGND VGND VPWR VPWR sky130_fd_sc_hd__decap_3
XFILLER_28_630 VGND VGND VPWR VPWR sky130_fd_sc_hd__decap_3
XFILLER_47_449 VGND VGND VPWR VPWR sky130_fd_sc_hd__decap_3
XTAP_TAPCELL_ROW_58_945 VGND VPWR sky130_fd_sc_hd__tapvpwrvgnd_1
Xclkbuf_leaf_39_clk clkbuf_4_12_0_clk/X VGND VGND VPWR VPWR _6033_/CLK sky130_fd_sc_hd__clkbuf_8
XFILLER_62_419 VGND VGND VPWR VPWR sky130_fd_sc_hd__fill_1
XTAP_TAPCELL_ROW_2_272 VGND VPWR sky130_fd_sc_hd__tapvpwrvgnd_1
XFILLER_35_41 VGND VGND VPWR VPWR sky130_fd_sc_hd__decap_3
XFILLER_15_346 VGND VGND VPWR VPWR sky130_fd_sc_hd__decap_3
XFILLER_35_74 VGND VGND VPWR VPWR sky130_fd_sc_hd__decap_3
XFILLER_43_666 VGND VGND VPWR VPWR sky130_fd_sc_hd__decap_3
XTAP_TAPCELL_ROW_83_1247 VGND VPWR sky130_fd_sc_hd__tapvpwrvgnd_1
XFILLER_30_305 VGND VGND VPWR VPWR sky130_fd_sc_hd__decap_3
Xwire421 wire421/A VGND VGND VPWR VPWR wire421/X sky130_fd_sc_hd__buf_4
XFILLER_7_556 VGND VGND VPWR VPWR sky130_fd_sc_hd__decap_3
XFILLER_7_567 VGND VGND VPWR VPWR sky130_fd_sc_hd__decap_3
Xwire465 _4333_/B VGND VGND VPWR VPWR wire465/X sky130_fd_sc_hd__buf_4
XFILLER_112_616 VGND VGND VPWR VPWR sky130_fd_sc_hd__decap_3
XTAP_TAPCELL_ROW_94_1376 VGND VPWR sky130_fd_sc_hd__tapvpwrvgnd_1
Xload_slew426 _4540_/B VGND VGND VPWR VPWR _4566_/A2 sky130_fd_sc_hd__clkbuf_4
XFILLER_25_6 VGND VGND VPWR VPWR sky130_fd_sc_hd__fill_1
XFILLER_76_81 VGND VGND VPWR VPWR sky130_fd_sc_hd__decap_3
XFILLER_65_279 VGND VGND VPWR VPWR sky130_fd_sc_hd__fill_1
XFILLER_93_577 VGND VGND VPWR VPWR sky130_fd_sc_hd__decap_3
X_5860_ _6052_/CLK _5860_/D VGND VGND VPWR VPWR _5860_/Q sky130_fd_sc_hd__dfxtp_2
XFILLER_33_121 VGND VGND VPWR VPWR sky130_fd_sc_hd__decap_3
X_4811_ _4811_/A _4811_/B VGND VGND VPWR VPWR _4811_/Y sky130_fd_sc_hd__nor2_1
X_5791_ _5825_/CLK _5791_/D VGND VGND VPWR VPWR _5791_/Q sky130_fd_sc_hd__dfxtp_2
XTAP_TAPCELL_ROW_103_1483 VGND VPWR sky130_fd_sc_hd__tapvpwrvgnd_1
X_4742_ _5046_/A1 _4742_/A2 wire171/X _4742_/B2 VGND VGND VPWR VPWR _5782_/D sky130_fd_sc_hd__a22o_2
X_4673_ _5046_/A1 _4673_/A2 _4673_/B1 _4673_/B2 VGND VGND VPWR VPWR _5718_/D sky130_fd_sc_hd__a22o_2
X_3624_ _3626_/A _3620_/X _3623_/X _3898_/A1 VGND VGND VPWR VPWR _3624_/X sky130_fd_sc_hd__o211a_2
X_3555_ _3881_/B2 _3552_/X _3554_/X VGND VGND VPWR VPWR _3555_/X sky130_fd_sc_hd__a21o_2
XFILLER_115_465 VGND VGND VPWR VPWR sky130_fd_sc_hd__decap_3
X_3486_ _5187_/Q _5155_/Q _3487_/S VGND VGND VPWR VPWR _3486_/X sky130_fd_sc_hd__mux2_1
X_2506_ _3055_/A1 _2501_/X _3146_/B2 _2504_/X VGND VGND VPWR VPWR _2506_/X sky130_fd_sc_hd__a22o_2
XFILLER_102_126 VGND VGND VPWR VPWR sky130_fd_sc_hd__decap_3
X_5225_ _6012_/CLK _5225_/D VGND VGND VPWR VPWR _5225_/Q sky130_fd_sc_hd__dfxtp_2
Xhold1702 _5768_/Q VGND VGND VPWR VPWR _4728_/B2 sky130_fd_sc_hd__dlygate4sd3_1
XFILLER_111_671 VGND VGND VPWR VPWR sky130_fd_sc_hd__fill_1
XFILLER_111_682 VGND VGND VPWR VPWR sky130_fd_sc_hd__decap_3
XFILLER_96_360 VGND VGND VPWR VPWR sky130_fd_sc_hd__decap_3
Xhold1713 _5888_/Q VGND VGND VPWR VPWR _4854_/B2 sky130_fd_sc_hd__dlygate4sd3_1
Xhold1724 _5281_/Q VGND VGND VPWR VPWR _4207_/B2 sky130_fd_sc_hd__dlygate4sd3_1
Xhold1735 _5848_/Q VGND VGND VPWR VPWR _4812_/B2 sky130_fd_sc_hd__dlygate4sd3_1
X_5156_ _6038_/CLK _5156_/D VGND VGND VPWR VPWR _5156_/Q sky130_fd_sc_hd__dfxtp_2
XFILLER_84_533 VGND VGND VPWR VPWR sky130_fd_sc_hd__decap_3
Xhold1746 _5390_/Q VGND VGND VPWR VPWR _4322_/B2 sky130_fd_sc_hd__dlygate4sd3_1
Xhold1757 _5174_/Q VGND VGND VPWR VPWR _4090_/B2 sky130_fd_sc_hd__dlygate4sd3_1
Xhold1768 _5286_/Q VGND VGND VPWR VPWR _4212_/B2 sky130_fd_sc_hd__dlygate4sd3_1
X_5087_ _5804_/CLK _5087_/D VGND VGND VPWR VPWR _5087_/Q sky130_fd_sc_hd__dfxtp_2
X_4107_ _4312_/A1 _4120_/A2 _4123_/B1 _4107_/B2 VGND VGND VPWR VPWR _5188_/D sky130_fd_sc_hd__a22o_2
XFILLER_112_13 VGND VGND VPWR VPWR sky130_fd_sc_hd__decap_3
XTAP_TAPCELL_ROW_55_904 VGND VPWR sky130_fd_sc_hd__tapvpwrvgnd_1
XTAP_TAPCELL_ROW_55_915 VGND VPWR sky130_fd_sc_hd__tapvpwrvgnd_1
Xhold1779 _5299_/Q VGND VGND VPWR VPWR _4225_/B2 sky130_fd_sc_hd__dlygate4sd3_1
X_4038_ _4894_/A1 _4050_/A2 _4050_/B1 _4038_/B2 VGND VGND VPWR VPWR _5126_/D sky130_fd_sc_hd__a22o_2
XFILLER_112_35 VGND VGND VPWR VPWR sky130_fd_sc_hd__decap_3
XFILLER_112_68 VGND VGND VPWR VPWR sky130_fd_sc_hd__decap_3
XTAP_TAPCELL_ROW_69_1080 VGND VPWR sky130_fd_sc_hd__tapvpwrvgnd_1
XFILLER_12_305 VGND VGND VPWR VPWR sky130_fd_sc_hd__decap_3
XTAP_TAPCELL_ROW_35_672 VGND VPWR sky130_fd_sc_hd__tapvpwrvgnd_1
X_5989_ _6021_/CLK _5989_/D VGND VGND VPWR VPWR _5989_/Q sky130_fd_sc_hd__dfxtp_2
XFILLER_21_54 VGND VGND VPWR VPWR sky130_fd_sc_hd__fill_2
XFILLER_106_421 VGND VGND VPWR VPWR sky130_fd_sc_hd__decap_3
XFILLER_108_3 VGND VGND VPWR VPWR sky130_fd_sc_hd__decap_3
XTAP_TAPCELL_ROW_7_331 VGND VPWR sky130_fd_sc_hd__tapvpwrvgnd_1
XFILLER_87_393 VGND VGND VPWR VPWR sky130_fd_sc_hd__fill_1
XFILLER_15_121 VGND VGND VPWR VPWR sky130_fd_sc_hd__decap_3
XFILLER_15_165 VGND VGND VPWR VPWR sky130_fd_sc_hd__decap_3
XFILLER_15_187 VGND VGND VPWR VPWR sky130_fd_sc_hd__decap_3
XFILLER_30_102 VGND VGND VPWR VPWR sky130_fd_sc_hd__fill_2
XFILLER_43_474 VGND VGND VPWR VPWR sky130_fd_sc_hd__fill_1
XFILLER_31_669 VGND VGND VPWR VPWR sky130_fd_sc_hd__decap_3
XFILLER_62_83 VGND VGND VPWR VPWR sky130_fd_sc_hd__fill_1
XFILLER_7_12 VGND VGND VPWR VPWR sky130_fd_sc_hd__decap_3
XFILLER_7_45 VGND VGND VPWR VPWR sky130_fd_sc_hd__decap_3
XTAP_TAPCELL_ROW_96_1405 VGND VPWR sky130_fd_sc_hd__tapvpwrvgnd_1
Xwire262 wire262/A VGND VGND VPWR VPWR wire262/X sky130_fd_sc_hd__clkbuf_4
XFILLER_109_281 VGND VGND VPWR VPWR sky130_fd_sc_hd__fill_1
X_3340_ _3347_/A _3338_/X _3339_/X _3632_/A VGND VGND VPWR VPWR _3341_/C sky130_fd_sc_hd__o22a_2
XFILLER_97_124 VGND VGND VPWR VPWR sky130_fd_sc_hd__decap_3
XFILLER_98_636 VGND VGND VPWR VPWR sky130_fd_sc_hd__decap_3
XFILLER_85_308 VGND VGND VPWR VPWR sky130_fd_sc_hd__fill_1
Xload_slew245 _4350_/B1 VGND VGND VPWR VPWR _4360_/B1 sky130_fd_sc_hd__buf_4
Xload_slew223 _4453_/B1 VGND VGND VPWR VPWR _4468_/B1 sky130_fd_sc_hd__clkbuf_4
X_5010_ _5010_/A1 _5010_/A2 _5010_/B1 _5010_/B2 VGND VGND VPWR VPWR _6036_/D sky130_fd_sc_hd__a22o_2
X_3271_ _3626_/A _3271_/B VGND VGND VPWR VPWR _3271_/X sky130_fd_sc_hd__or2_2
XFILLER_23_3 VGND VGND VPWR VPWR sky130_fd_sc_hd__fill_1
XFILLER_66_544 VGND VGND VPWR VPWR sky130_fd_sc_hd__decap_3
XTAP_TAPCELL_ROW_105_1512 VGND VPWR sky130_fd_sc_hd__tapvpwrvgnd_1
XFILLER_81_569 VGND VGND VPWR VPWR sky130_fd_sc_hd__fill_1
X_5912_ _6040_/CLK _5912_/D VGND VGND VPWR VPWR _5912_/Q sky130_fd_sc_hd__dfxtp_2
XFILLER_34_485 VGND VGND VPWR VPWR sky130_fd_sc_hd__decap_3
X_5843_ _6067_/CLK _5843_/D VGND VGND VPWR VPWR _5843_/Q sky130_fd_sc_hd__dfxtp_2
XFILLER_21_113 VGND VGND VPWR VPWR sky130_fd_sc_hd__fill_1
XFILLER_22_636 VGND VGND VPWR VPWR sky130_fd_sc_hd__decap_3
XTAP_TAPCELL_ROW_32_631 VGND VPWR sky130_fd_sc_hd__tapvpwrvgnd_1
XFILLER_21_146 VGND VGND VPWR VPWR sky130_fd_sc_hd__decap_3
XTAP_TAPCELL_ROW_60_973 VGND VPWR sky130_fd_sc_hd__tapvpwrvgnd_1
X_5774_ _5934_/CLK _5774_/D VGND VGND VPWR VPWR _5774_/Q sky130_fd_sc_hd__dfxtp_2
X_2986_ _5133_/Q _5101_/Q _6029_/Q _5997_/Q _2988_/S _3102_/S1 VGND VGND VPWR VPWR
+ _2987_/B sky130_fd_sc_hd__mux4_2
X_4725_ _4927_/A1 wire389/X _4727_/B1 _4725_/B2 VGND VGND VPWR VPWR _5765_/D sky130_fd_sc_hd__a22o_2
X_4656_ _4927_/A1 _4668_/A2 _4668_/B1 _4656_/B2 VGND VGND VPWR VPWR _5701_/D sky130_fd_sc_hd__a22o_2
X_4587_ _4926_/A1 wire414/A wire193/X _4587_/B2 VGND VGND VPWR VPWR _5636_/D sky130_fd_sc_hd__a22o_2
X_3607_ _3896_/B2 _3604_/X _3606_/X _3781_/C1 VGND VGND VPWR VPWR _3613_/A sky130_fd_sc_hd__o211a_2
X_3538_ _3548_/A1 _3534_/X _3537_/X _3916_/B1 VGND VGND VPWR VPWR _3538_/X sky130_fd_sc_hd__o211a_2
XFILLER_107_24 VGND VGND VPWR VPWR sky130_fd_sc_hd__decap_3
XFILLER_107_57 VGND VGND VPWR VPWR sky130_fd_sc_hd__decap_3
XFILLER_103_446 VGND VGND VPWR VPWR sky130_fd_sc_hd__fill_2
XFILLER_103_468 VGND VGND VPWR VPWR sky130_fd_sc_hd__decap_3
X_3469_ _5826_/Q _5442_/Q _6050_/Q _5954_/Q _3469_/S0 _3469_/S1 VGND VGND VPWR VPWR
+ _3469_/X sky130_fd_sc_hd__mux4_2
XTAP_TAPCELL_ROW_4_301 VGND VPWR sky130_fd_sc_hd__tapvpwrvgnd_1
Xhold1510 _5811_/Q VGND VGND VPWR VPWR _4773_/B2 sky130_fd_sc_hd__dlygate4sd3_1
X_5208_ _6038_/CLK _5208_/D VGND VGND VPWR VPWR _5208_/Q sky130_fd_sc_hd__dfxtp_2
XFILLER_57_522 VGND VGND VPWR VPWR sky130_fd_sc_hd__decap_3
Xhold1521 _5696_/Q VGND VGND VPWR VPWR _4651_/B2 sky130_fd_sc_hd__dlygate4sd3_1
Xhold1532 _6004_/Q VGND VGND VPWR VPWR _4976_/B2 sky130_fd_sc_hd__dlygate4sd3_1
Xhold1543 _5679_/Q VGND VGND VPWR VPWR _4632_/B2 sky130_fd_sc_hd__dlygate4sd3_1
X_5139_ _5683_/CLK _5139_/D VGND VGND VPWR VPWR _5139_/Q sky130_fd_sc_hd__dfxtp_2
XFILLER_29_279 VGND VGND VPWR VPWR sky130_fd_sc_hd__fill_1
Xhold1554 _5925_/Q VGND VGND VPWR VPWR _4893_/B2 sky130_fd_sc_hd__dlygate4sd3_1
Xhold1565 _5626_/Q VGND VGND VPWR VPWR _4577_/B2 sky130_fd_sc_hd__dlygate4sd3_1
Xhold1576 _5328_/Q VGND VGND VPWR VPWR _4256_/B2 sky130_fd_sc_hd__dlygate4sd3_1
Xload_slew1017 _3399_/A1 VGND VGND VPWR VPWR _3234_/B sky130_fd_sc_hd__clkbuf_4
Xload_slew1028 _3742_/S1 VGND VGND VPWR VPWR _3839_/S1 sky130_fd_sc_hd__clkbuf_4
XPHY_EDGE_ROW_103_Left_219 VGND VGND VPWR VPWR sky130_fd_sc_hd__decap_3
Xhold1587 _5595_/Q VGND VGND VPWR VPWR _4544_/B2 sky130_fd_sc_hd__dlygate4sd3_1
Xhold1598 _5871_/Q VGND VGND VPWR VPWR _4835_/B2 sky130_fd_sc_hd__dlygate4sd3_1
XFILLER_16_21 VGND VGND VPWR VPWR sky130_fd_sc_hd__decap_3
XFILLER_25_430 VGND VGND VPWR VPWR sky130_fd_sc_hd__decap_3
XFILLER_44_249 VGND VGND VPWR VPWR sky130_fd_sc_hd__decap_3
XFILLER_16_54 VGND VGND VPWR VPWR sky130_fd_sc_hd__decap_3
XFILLER_25_474 VGND VGND VPWR VPWR sky130_fd_sc_hd__decap_3
XFILLER_25_485 VGND VGND VPWR VPWR sky130_fd_sc_hd__decap_3
XFILLER_40_411 VGND VGND VPWR VPWR sky130_fd_sc_hd__fill_1
XTAP_TAPCELL_ROW_80_1206 VGND VPWR sky130_fd_sc_hd__tapvpwrvgnd_1
XFILLER_12_135 VGND VGND VPWR VPWR sky130_fd_sc_hd__decap_3
XFILLER_13_636 VGND VGND VPWR VPWR sky130_fd_sc_hd__decap_3
XFILLER_52_282 VGND VGND VPWR VPWR sky130_fd_sc_hd__fill_1
XFILLER_40_477 VGND VGND VPWR VPWR sky130_fd_sc_hd__fill_1
XFILLER_32_64 VGND VGND VPWR VPWR sky130_fd_sc_hd__fill_2
XPHY_EDGE_ROW_112_Left_228 VGND VGND VPWR VPWR sky130_fd_sc_hd__decap_3
XTAP_TAPCELL_ROW_10_369 VGND VPWR sky130_fd_sc_hd__tapvpwrvgnd_1
XFILLER_79_113 VGND VGND VPWR VPWR sky130_fd_sc_hd__decap_3
XTAP_TAPCELL_ROW_91_1346 VGND VPWR sky130_fd_sc_hd__tapvpwrvgnd_1
XFILLER_79_146 VGND VGND VPWR VPWR sky130_fd_sc_hd__decap_3
XFILLER_0_573 VGND VGND VPWR VPWR sky130_fd_sc_hd__decap_3
XFILLER_0_584 VGND VGND VPWR VPWR sky130_fd_sc_hd__decap_3
XFILLER_0_595 VGND VGND VPWR VPWR sky130_fd_sc_hd__decap_3
XFILLER_48_533 VGND VGND VPWR VPWR sky130_fd_sc_hd__fill_1
XFILLER_94_138 VGND VGND VPWR VPWR sky130_fd_sc_hd__fill_2
XFILLER_57_83 VGND VGND VPWR VPWR sky130_fd_sc_hd__decap_3
XFILLER_75_352 VGND VGND VPWR VPWR sky130_fd_sc_hd__decap_3
XFILLER_16_474 VGND VGND VPWR VPWR sky130_fd_sc_hd__fill_2
XFILLER_16_485 VGND VGND VPWR VPWR sky130_fd_sc_hd__decap_3
XFILLER_43_260 VGND VGND VPWR VPWR sky130_fd_sc_hd__fill_2
XTAP_TAPCELL_ROW_18_469 VGND VPWR sky130_fd_sc_hd__tapvpwrvgnd_1
XFILLER_31_433 VGND VGND VPWR VPWR sky130_fd_sc_hd__decap_3
XFILLER_92_6 VGND VGND VPWR VPWR sky130_fd_sc_hd__decap_3
X_2840_ _5254_/Q _5222_/Q _3003_/S VGND VGND VPWR VPWR _2840_/X sky130_fd_sc_hd__mux2_1
XTAP_TAPCELL_ROW_100_1453 VGND VPWR sky130_fd_sc_hd__tapvpwrvgnd_1
X_2771_ _5251_/Q _5219_/Q _2772_/S VGND VGND VPWR VPWR _2771_/X sky130_fd_sc_hd__mux2_1
XFILLER_8_662 VGND VGND VPWR VPWR sky130_fd_sc_hd__fill_1
X_5490_ _5502_/CLK _5490_/D VGND VGND VPWR VPWR _5490_/Q sky130_fd_sc_hd__dfxtp_2
X_4510_ _4510_/A1 _4535_/A2 _4535_/B1 _4510_/B2 VGND VGND VPWR VPWR _5564_/D sky130_fd_sc_hd__a22o_2
XFILLER_7_172 VGND VGND VPWR VPWR sky130_fd_sc_hd__decap_3
X_4441_ _4509_/A1 _4465_/A2 _4465_/B1 _4441_/B2 VGND VGND VPWR VPWR _5499_/D sky130_fd_sc_hd__a22o_2
XPHY_EDGE_ROW_9_Right_9 VGND VGND VPWR VPWR sky130_fd_sc_hd__decap_3
X_4372_ _5019_/A1 _4396_/A2 _4375_/B1 _4372_/B2 VGND VGND VPWR VPWR _5435_/D sky130_fd_sc_hd__a22o_2
XFILLER_112_243 VGND VGND VPWR VPWR sky130_fd_sc_hd__fill_1
Xfanout619 _3784_/A VGND VGND VPWR VPWR _3619_/A1 sky130_fd_sc_hd__clkdlybuf4s25_1
Xfanout608 _3234_/X VGND VGND VPWR VPWR _3370_/A1 sky130_fd_sc_hd__clkdlybuf4s25_1
X_3323_ _3321_/X _3322_/X _3562_/A VGND VGND VPWR VPWR _3323_/X sky130_fd_sc_hd__mux2_1
XFILLER_39_511 VGND VGND VPWR VPWR sky130_fd_sc_hd__decap_3
XFILLER_98_477 VGND VGND VPWR VPWR sky130_fd_sc_hd__decap_3
XFILLER_98_488 VGND VGND VPWR VPWR sky130_fd_sc_hd__decap_3
XPHY_EDGE_ROW_107_Right_107 VGND VGND VPWR VPWR sky130_fd_sc_hd__decap_3
XTAP_TAPCELL_ROW_111_1582 VGND VPWR sky130_fd_sc_hd__tapvpwrvgnd_1
X_6042_ _6042_/CLK _6042_/D VGND VGND VPWR VPWR _6042_/Q sky130_fd_sc_hd__dfxtp_2
X_3254_ _3763_/A _3252_/X _3341_/A VGND VGND VPWR VPWR _3254_/X sky130_fd_sc_hd__o21a_2
X_3185_ _3185_/A1 _3168_/X _3184_/X _3185_/B2 VGND VGND VPWR VPWR _3185_/X sky130_fd_sc_hd__a22o_2
XFILLER_26_216 VGND VGND VPWR VPWR sky130_fd_sc_hd__decap_3
XFILLER_39_588 VGND VGND VPWR VPWR sky130_fd_sc_hd__decap_3
XFILLER_54_569 VGND VGND VPWR VPWR sky130_fd_sc_hd__decap_3
X_5826_ _6071_/CLK _5826_/D VGND VGND VPWR VPWR _5826_/Q sky130_fd_sc_hd__dfxtp_2
X_5757_ _5885_/CLK _5757_/D VGND VGND VPWR VPWR _5757_/Q sky130_fd_sc_hd__dfxtp_2
X_2969_ _3081_/A _2969_/B VGND VGND VPWR VPWR _2969_/X sky130_fd_sc_hd__or2_2
XFILLER_108_516 VGND VGND VPWR VPWR sky130_fd_sc_hd__decap_3
X_4708_ _4777_/A1 _4708_/A2 _4708_/B1 _4708_/B2 VGND VGND VPWR VPWR _5751_/D sky130_fd_sc_hd__a22o_2
X_5688_ _5812_/CLK _5688_/D VGND VGND VPWR VPWR _5688_/Q sky130_fd_sc_hd__dfxtp_2
X_4639_ _4776_/A1 _4639_/A2 _4639_/B1 _4639_/B2 VGND VGND VPWR VPWR _5686_/D sky130_fd_sc_hd__a22o_2
XFILLER_1_348 VGND VGND VPWR VPWR sky130_fd_sc_hd__decap_3
XFILLER_76_105 VGND VGND VPWR VPWR sky130_fd_sc_hd__fill_2
Xhold2030 _5350_/Q VGND VGND VPWR VPWR _4280_/B2 sky130_fd_sc_hd__dlygate4sd3_1
Xhold2041 _5545_/Q VGND VGND VPWR VPWR _4489_/B2 sky130_fd_sc_hd__dlygate4sd3_1
Xhold2052 _5122_/Q VGND VGND VPWR VPWR _4034_/B2 sky130_fd_sc_hd__dlygate4sd3_1
Xhold2063 _5969_/Q VGND VGND VPWR VPWR _4939_/B2 sky130_fd_sc_hd__dlygate4sd3_1
XFILLER_85_650 VGND VGND VPWR VPWR sky130_fd_sc_hd__decap_3
XFILLER_85_661 VGND VGND VPWR VPWR sky130_fd_sc_hd__decap_3
Xhold1340 _5411_/Q VGND VGND VPWR VPWR _4345_/B2 sky130_fd_sc_hd__dlygate4sd3_1
Xhold1351 _5900_/Q VGND VGND VPWR VPWR _4866_/B2 sky130_fd_sc_hd__dlygate4sd3_1
Xhold2074 _5108_/Q VGND VGND VPWR VPWR _4017_/B2 sky130_fd_sc_hd__dlygate4sd3_1
Xhold2085 _5464_/Q VGND VGND VPWR VPWR _4404_/B2 sky130_fd_sc_hd__dlygate4sd3_1
Xhold2096 _5397_/Q VGND VGND VPWR VPWR _4329_/B2 sky130_fd_sc_hd__dlygate4sd3_1
XFILLER_45_525 VGND VGND VPWR VPWR sky130_fd_sc_hd__decap_3
Xhold1362 _5271_/Q VGND VGND VPWR VPWR _4194_/B2 sky130_fd_sc_hd__dlygate4sd3_1
Xhold1373 _5197_/Q VGND VGND VPWR VPWR _4116_/B2 sky130_fd_sc_hd__dlygate4sd3_1
Xhold1384 _5506_/Q VGND VGND VPWR VPWR _4448_/B2 sky130_fd_sc_hd__dlygate4sd3_1
Xhold1395 _6039_/Q VGND VGND VPWR VPWR _5013_/B2 sky130_fd_sc_hd__dlygate4sd3_1
XFILLER_45_547 VGND VGND VPWR VPWR sky130_fd_sc_hd__decap_3
XFILLER_45_558 VGND VGND VPWR VPWR sky130_fd_sc_hd__fill_2
XTAP_TAPCELL_ROW_15_428 VGND VPWR sky130_fd_sc_hd__tapvpwrvgnd_1
XFILLER_40_230 VGND VGND VPWR VPWR sky130_fd_sc_hd__decap_3
XFILLER_43_52 VGND VGND VPWR VPWR sky130_fd_sc_hd__decap_3
XFILLER_9_426 VGND VGND VPWR VPWR sky130_fd_sc_hd__decap_3
XFILLER_5_610 VGND VGND VPWR VPWR sky130_fd_sc_hd__decap_3
XFILLER_5_632 VGND VGND VPWR VPWR sky130_fd_sc_hd__decap_3
XFILLER_114_508 VGND VGND VPWR VPWR sky130_fd_sc_hd__fill_1
XFILLER_5_665 VGND VGND VPWR VPWR sky130_fd_sc_hd__decap_3
XFILLER_4_24 VGND VGND VPWR VPWR sky130_fd_sc_hd__decap_3
XFILLER_5_676 VGND VGND VPWR VPWR sky130_fd_sc_hd__decap_3
XFILLER_4_35 VGND VGND VPWR VPWR sky130_fd_sc_hd__decap_3
XFILLER_63_322 VGND VGND VPWR VPWR sky130_fd_sc_hd__fill_1
XFILLER_84_81 VGND VGND VPWR VPWR sky130_fd_sc_hd__decap_3
XFILLER_90_141 VGND VGND VPWR VPWR sky130_fd_sc_hd__decap_3
X_4990_ _4990_/A1 _4998_/A2 _4998_/B1 _4990_/B2 VGND VGND VPWR VPWR _6016_/D sky130_fd_sc_hd__a22o_2
XFILLER_16_271 VGND VGND VPWR VPWR sky130_fd_sc_hd__decap_3
X_3941_ _3941_/A _3941_/B VGND VGND VPWR VPWR _3941_/X sky130_fd_sc_hd__or2_2
XFILLER_31_252 VGND VGND VPWR VPWR sky130_fd_sc_hd__decap_3
XFILLER_90_3 VGND VGND VPWR VPWR sky130_fd_sc_hd__decap_3
X_3872_ _3872_/A _3872_/B VGND VGND VPWR VPWR _3872_/X sky130_fd_sc_hd__or2_2
X_5611_ _5867_/CLK _5611_/D VGND VGND VPWR VPWR _5611_/Q sky130_fd_sc_hd__dfxtp_2
X_2823_ _2886_/A1 _2821_/X _2822_/X _2949_/B2 VGND VGND VPWR VPWR _2823_/X sky130_fd_sc_hd__o22a_2
X_5542_ _5790_/CLK _5542_/D VGND VGND VPWR VPWR _5542_/Q sky130_fd_sc_hd__dfxtp_2
X_2754_ _5506_/Q _5474_/Q _3221_/S VGND VGND VPWR VPWR _2754_/X sky130_fd_sc_hd__mux2_1
X_5473_ _6058_/CLK _5473_/D VGND VGND VPWR VPWR _5473_/Q sky130_fd_sc_hd__dfxtp_2
X_2685_ _3228_/A1 _2682_/X _2684_/X _3071_/B2 VGND VGND VPWR VPWR _2685_/X sky130_fd_sc_hd__a22o_2
XTAP_TAPCELL_ROW_113_1600 VGND VPWR sky130_fd_sc_hd__tapvpwrvgnd_1
XTAP_TAPCELL_ROW_113_1611 VGND VPWR sky130_fd_sc_hd__tapvpwrvgnd_1
X_4424_ _4526_/A1 _4435_/A2 _4435_/B1 _4424_/B2 VGND VGND VPWR VPWR _5484_/D sky130_fd_sc_hd__a22o_2
XFILLER_113_530 VGND VGND VPWR VPWR sky130_fd_sc_hd__decap_3
X_4355_ _4527_/A1 wire465/X _4360_/B1 _4355_/B2 VGND VGND VPWR VPWR _5421_/D sky130_fd_sc_hd__a22o_2
Xfanout438 _4470_/Y VGND VGND VPWR VPWR _4503_/A2 sky130_fd_sc_hd__clkdlybuf4s25_1
Xfanout427 _4504_/Y VGND VGND VPWR VPWR _4528_/A2 sky130_fd_sc_hd__clkdlybuf4s25_1
Xfanout416 _4573_/Y VGND VGND VPWR VPWR _4591_/A2 sky130_fd_sc_hd__clkdlybuf4s25_1
X_3306_ _5786_/Q _5722_/Q _3318_/S VGND VGND VPWR VPWR _3306_/X sky130_fd_sc_hd__mux2_1
XFILLER_100_235 VGND VGND VPWR VPWR sky130_fd_sc_hd__decap_3
XFILLER_113_596 VGND VGND VPWR VPWR sky130_fd_sc_hd__decap_3
XFILLER_98_285 VGND VGND VPWR VPWR sky130_fd_sc_hd__decap_3
X_4286_ _4526_/A1 _4297_/A2 _4297_/B1 _4286_/B2 VGND VGND VPWR VPWR _5356_/D sky130_fd_sc_hd__a22o_2
X_6025_ _6044_/CLK _6025_/D VGND VGND VPWR VPWR _6025_/Q sky130_fd_sc_hd__dfxtp_2
X_3237_ _5816_/Q _5432_/Q _3774_/S VGND VGND VPWR VPWR _3237_/X sky130_fd_sc_hd__mux2_1
XFILLER_27_503 VGND VGND VPWR VPWR sky130_fd_sc_hd__fill_1
XFILLER_64_18 VGND VGND VPWR VPWR sky130_fd_sc_hd__fill_2
X_3168_ _2558_/A _3165_/X _3167_/X VGND VGND VPWR VPWR _3168_/X sky130_fd_sc_hd__a21o_2
XFILLER_82_686 VGND VGND VPWR VPWR sky130_fd_sc_hd__fill_2
X_3099_ _6066_/Q _5970_/Q _3099_/S VGND VGND VPWR VPWR _3099_/X sky130_fd_sc_hd__mux2_1
XTAP_TAPCELL_ROW_40_729 VGND VPWR sky130_fd_sc_hd__tapvpwrvgnd_1
X_5809_ _6060_/CLK _5809_/D VGND VGND VPWR VPWR _5809_/Q sky130_fd_sc_hd__dfxtp_2
XFILLER_13_66 VGND VGND VPWR VPWR sky130_fd_sc_hd__decap_3
XFILLER_108_324 VGND VGND VPWR VPWR sky130_fd_sc_hd__fill_1
XFILLER_89_15 VGND VGND VPWR VPWR sky130_fd_sc_hd__decap_3
XFILLER_108_346 VGND VGND VPWR VPWR sky130_fd_sc_hd__fill_1
XTAP_TAPCELL_ROW_20_486 VGND VPWR sky130_fd_sc_hd__tapvpwrvgnd_1
XFILLER_2_613 VGND VGND VPWR VPWR sky130_fd_sc_hd__decap_3
XTAP_TAPCELL_ROW_75_1149 VGND VPWR sky130_fd_sc_hd__tapvpwrvgnd_1
XFILLER_2_657 VGND VGND VPWR VPWR sky130_fd_sc_hd__decap_3
XFILLER_77_447 VGND VGND VPWR VPWR sky130_fd_sc_hd__fill_1
Xfanout961 _4762_/A1 VGND VGND VPWR VPWR _5032_/A1 sky130_fd_sc_hd__clkdlybuf4s25_1
Xfanout950 input27/X VGND VGND VPWR VPWR _5035_/A1 sky130_fd_sc_hd__clkdlybuf4s25_1
Xfanout983 input19/X VGND VGND VPWR VPWR _4993_/A1 sky130_fd_sc_hd__clkdlybuf4s25_1
Xfanout994 input16/X VGND VGND VPWR VPWR _3948_/B sky130_fd_sc_hd__clkbuf_2
Xfanout972 input21/X VGND VGND VPWR VPWR _4519_/A1 sky130_fd_sc_hd__clkdlybuf4s25_1
XFILLER_73_620 VGND VGND VPWR VPWR sky130_fd_sc_hd__decap_3
XTAP_TAPCELL_ROW_48_829 VGND VPWR sky130_fd_sc_hd__tapvpwrvgnd_1
Xhold1170 _5629_/Q VGND VGND VPWR VPWR _4580_/B2 sky130_fd_sc_hd__dlygate4sd3_1
XFILLER_18_569 VGND VGND VPWR VPWR sky130_fd_sc_hd__fill_2
XFILLER_85_491 VGND VGND VPWR VPWR sky130_fd_sc_hd__decap_3
Xhold1181 _5797_/Q VGND VGND VPWR VPWR _4759_/B2 sky130_fd_sc_hd__dlygate4sd3_1
Xhold1192 _5257_/Q VGND VGND VPWR VPWR _4180_/B2 sky130_fd_sc_hd__dlygate4sd3_1
XFILLER_72_141 VGND VGND VPWR VPWR sky130_fd_sc_hd__decap_3
XTAP_TAPCELL_ROW_86_1278 VGND VPWR sky130_fd_sc_hd__tapvpwrvgnd_1
XTAP_TAPCELL_ROW_28_586 VGND VPWR sky130_fd_sc_hd__tapvpwrvgnd_1
XFILLER_41_561 VGND VGND VPWR VPWR sky130_fd_sc_hd__decap_3
XFILLER_54_95 VGND VGND VPWR VPWR sky130_fd_sc_hd__decap_3
XFILLER_9_201 VGND VGND VPWR VPWR sky130_fd_sc_hd__decap_3
XFILLER_70_50 VGND VGND VPWR VPWR sky130_fd_sc_hd__decap_3
XFILLER_70_83 VGND VGND VPWR VPWR sky130_fd_sc_hd__fill_1
Xclkload26 _6045_/CLK VGND VGND VPWR VPWR clkload26/X sky130_fd_sc_hd__clkbuf_8
Xclkload15 _5571_/CLK VGND VGND VPWR VPWR clkload15/X sky130_fd_sc_hd__clkbuf_8
Xclkload48 _5866_/CLK VGND VGND VPWR VPWR clkload48/Y sky130_fd_sc_hd__bufinv_16
Xclkload37 _5713_/CLK VGND VGND VPWR VPWR clkload37/X sky130_fd_sc_hd__clkbuf_8
X_4140_ _4993_/A1 _4145_/A2 _4146_/B1 _4140_/B2 VGND VGND VPWR VPWR _5219_/D sky130_fd_sc_hd__a22o_2
XFILLER_68_458 VGND VGND VPWR VPWR sky130_fd_sc_hd__decap_3
XFILLER_68_469 VGND VGND VPWR VPWR sky130_fd_sc_hd__fill_1
X_4071_ _4517_/A1 _4076_/A2 _4077_/B1 _4071_/B2 VGND VGND VPWR VPWR _5155_/D sky130_fd_sc_hd__a22o_2
XFILLER_110_577 VGND VGND VPWR VPWR sky130_fd_sc_hd__decap_3
XFILLER_83_439 VGND VGND VPWR VPWR sky130_fd_sc_hd__decap_3
XFILLER_95_91 VGND VGND VPWR VPWR sky130_fd_sc_hd__decap_3
X_3022_ wire676/X _3020_/X _3021_/X wire641/X VGND VGND VPWR VPWR _3022_/X sky130_fd_sc_hd__o22a_2
XFILLER_48_182 VGND VGND VPWR VPWR sky130_fd_sc_hd__decap_3
XFILLER_63_130 VGND VGND VPWR VPWR sky130_fd_sc_hd__decap_3
XFILLER_64_642 VGND VGND VPWR VPWR sky130_fd_sc_hd__fill_2
XFILLER_24_517 VGND VGND VPWR VPWR sky130_fd_sc_hd__decap_3
XFILLER_36_399 VGND VGND VPWR VPWR sky130_fd_sc_hd__decap_3
X_4973_ _5007_/A1 _4947_/B _4978_/B1 _4973_/B2 VGND VGND VPWR VPWR _6001_/D sky130_fd_sc_hd__a22o_2
XFILLER_32_550 VGND VGND VPWR VPWR sky130_fd_sc_hd__decap_3
X_3924_ _5399_/Q _5367_/Q _5335_/Q _5303_/Q _3926_/S _3239_/B VGND VGND VPWR VPWR
+ _3924_/X sky130_fd_sc_hd__mux4_2
XFILLER_32_583 VGND VGND VPWR VPWR sky130_fd_sc_hd__decap_3
Xclkload9 clkload9/A VGND VGND VPWR VPWR clkload9/Y sky130_fd_sc_hd__clkinv_2
X_3855_ _3838_/X _3843_/X _3854_/X _3855_/B1 VGND VGND VPWR VPWR _3855_/X sky130_fd_sc_hd__o31a_2
X_3786_ _3791_/A1 _3782_/X _3785_/X _3791_/B2 VGND VGND VPWR VPWR _3786_/X sky130_fd_sc_hd__a22o_2
X_2806_ _5413_/Q _5061_/Q _3093_/S VGND VGND VPWR VPWR _2806_/X sky130_fd_sc_hd__mux2_1
X_5525_ _5525_/CLK _5525_/D VGND VGND VPWR VPWR _5525_/Q sky130_fd_sc_hd__dfxtp_2
X_2737_ _5826_/Q _5442_/Q _2738_/S VGND VGND VPWR VPWR _2737_/X sky130_fd_sc_hd__mux2_1
XFILLER_105_316 VGND VGND VPWR VPWR sky130_fd_sc_hd__decap_3
X_5456_ _6040_/CLK _5456_/D VGND VGND VPWR VPWR _5456_/Q sky130_fd_sc_hd__dfxtp_2
X_2668_ _6047_/Q _5951_/Q _2971_/S VGND VGND VPWR VPWR _2668_/X sky130_fd_sc_hd__mux2_1
X_4407_ _4509_/A1 _4431_/A2 _4431_/B1 _4407_/B2 VGND VGND VPWR VPWR _5467_/D sky130_fd_sc_hd__a22o_2
Xfanout202 _4540_/Y VGND VGND VPWR VPWR _4557_/B1 sky130_fd_sc_hd__clkdlybuf4s25_1
X_5387_ _6027_/CLK _5387_/D VGND VGND VPWR VPWR _5387_/Q sky130_fd_sc_hd__dfxtp_2
X_2599_ _5404_/Q _5052_/Q _2896_/S VGND VGND VPWR VPWR _2599_/X sky130_fd_sc_hd__mux2_1
XFILLER_101_533 VGND VGND VPWR VPWR sky130_fd_sc_hd__decap_3
XFILLER_113_371 VGND VGND VPWR VPWR sky130_fd_sc_hd__fill_2
XFILLER_115_24 VGND VGND VPWR VPWR sky130_fd_sc_hd__decap_3
XFILLER_115_35 VGND VGND VPWR VPWR sky130_fd_sc_hd__decap_3
XFILLER_86_211 VGND VGND VPWR VPWR sky130_fd_sc_hd__fill_1
Xfanout246 _4333_/Y VGND VGND VPWR VPWR _4365_/B1 sky130_fd_sc_hd__clkdlybuf4s25_1
Xfanout224 _4437_/Y VGND VGND VPWR VPWR fanout224/X sky130_fd_sc_hd__clkdlybuf4s25_1
X_4338_ _4750_/A1 wire462/X wire242/X _4338_/B2 VGND VGND VPWR VPWR _5404_/D sky130_fd_sc_hd__a22o_2
XFILLER_115_57 VGND VGND VPWR VPWR sky130_fd_sc_hd__decap_3
XFILLER_47_609 VGND VGND VPWR VPWR sky130_fd_sc_hd__fill_1
Xfanout268 _4229_/B1 VGND VGND VPWR VPWR wire269/A sky130_fd_sc_hd__clkdlybuf4s25_1
X_4269_ _4509_/A1 wire475/X wire255/A _4269_/B2 VGND VGND VPWR VPWR _5339_/D sky130_fd_sc_hd__a22o_2
XFILLER_101_588 VGND VGND VPWR VPWR sky130_fd_sc_hd__decap_3
XFILLER_55_620 VGND VGND VPWR VPWR sky130_fd_sc_hd__fill_2
XFILLER_86_288 VGND VGND VPWR VPWR sky130_fd_sc_hd__decap_3
X_6008_ _6027_/CLK _6008_/D VGND VGND VPWR VPWR _6008_/Q sky130_fd_sc_hd__dfxtp_2
XFILLER_54_141 VGND VGND VPWR VPWR sky130_fd_sc_hd__fill_1
XFILLER_55_686 VGND VGND VPWR VPWR sky130_fd_sc_hd__fill_2
XFILLER_82_472 VGND VGND VPWR VPWR sky130_fd_sc_hd__decap_3
XFILLER_15_528 VGND VGND VPWR VPWR sky130_fd_sc_hd__fill_1
XFILLER_70_645 VGND VGND VPWR VPWR sky130_fd_sc_hd__decap_3
XTAP_TAPCELL_ROW_25_545 VGND VPWR sky130_fd_sc_hd__tapvpwrvgnd_1
XFILLER_10_200 VGND VGND VPWR VPWR sky130_fd_sc_hd__decap_3
XFILLER_23_572 VGND VGND VPWR VPWR sky130_fd_sc_hd__decap_3
XTAP_TAPCELL_ROW_53_887 VGND VPWR sky130_fd_sc_hd__tapvpwrvgnd_1
XFILLER_10_233 VGND VGND VPWR VPWR sky130_fd_sc_hd__fill_2
Xwire603 wire603/A VGND VGND VPWR VPWR _3347_/A sky130_fd_sc_hd__buf_6
Xwire647 wire647/A VGND VGND VPWR VPWR wire647/X sky130_fd_sc_hd__buf_6
XFILLER_109_666 VGND VGND VPWR VPWR sky130_fd_sc_hd__decap_3
XFILLER_40_53 VGND VGND VPWR VPWR sky130_fd_sc_hd__fill_1
XFILLER_6_237 VGND VGND VPWR VPWR sky130_fd_sc_hd__fill_2
XFILLER_40_97 VGND VGND VPWR VPWR sky130_fd_sc_hd__decap_3
XFILLER_108_187 VGND VGND VPWR VPWR sky130_fd_sc_hd__fill_1
XFILLER_49_95 VGND VGND VPWR VPWR sky130_fd_sc_hd__decap_3
XFILLER_1_36 VGND VGND VPWR VPWR sky130_fd_sc_hd__decap_3
XFILLER_92_203 VGND VGND VPWR VPWR sky130_fd_sc_hd__decap_3
Xfanout791 _3026_/S VGND VGND VPWR VPWR _2777_/S sky130_fd_sc_hd__dlymetal6s2s_1
Xfanout780 input7/X VGND VGND VPWR VPWR _2979_/S1 sky130_fd_sc_hd__buf_6
XTAP_TAPCELL_ROW_88_1307 VGND VPWR sky130_fd_sc_hd__tapvpwrvgnd_1
XFILLER_105_90 VGND VGND VPWR VPWR sky130_fd_sc_hd__decap_3
XFILLER_1_69 VGND VGND VPWR VPWR sky130_fd_sc_hd__decap_3
XFILLER_18_355 VGND VGND VPWR VPWR sky130_fd_sc_hd__fill_1
XFILLER_60_111 VGND VGND VPWR VPWR sky130_fd_sc_hd__decap_3
XFILLER_61_634 VGND VGND VPWR VPWR sky130_fd_sc_hd__decap_3
XTAP_TAPCELL_ROW_99_1436 VGND VPWR sky130_fd_sc_hd__tapvpwrvgnd_1
X_3640_ _3695_/A1 _3638_/X _3639_/X _3694_/A VGND VGND VPWR VPWR _3640_/X sky130_fd_sc_hd__o22a_2
X_3571_ _3898_/A1 _3562_/X _3565_/X _3555_/X _3843_/C1 VGND VGND VPWR VPWR _3571_/X
+ sky130_fd_sc_hd__a32o_2
X_5310_ _5800_/CLK _5310_/D VGND VGND VPWR VPWR _5310_/Q sky130_fd_sc_hd__dfxtp_2
X_2522_ _2608_/A input9/X VGND VGND VPWR VPWR _2522_/X sky130_fd_sc_hd__and2_2
XFILLER_5_281 VGND VGND VPWR VPWR sky130_fd_sc_hd__fill_1
XFILLER_115_669 VGND VGND VPWR VPWR sky130_fd_sc_hd__decap_3
X_5241_ _6035_/CLK _5241_/D VGND VGND VPWR VPWR _5241_/Q sky130_fd_sc_hd__dfxtp_2
XFILLER_114_179 VGND VGND VPWR VPWR sky130_fd_sc_hd__fill_1
X_5172_ _6031_/CLK _5172_/D VGND VGND VPWR VPWR _5172_/Q sky130_fd_sc_hd__dfxtp_2
Xhold1906 _5367_/Q VGND VGND VPWR VPWR _4297_/B2 sky130_fd_sc_hd__dlygate4sd3_1
Xhold1917 _5552_/Q VGND VGND VPWR VPWR _4496_/B2 sky130_fd_sc_hd__dlygate4sd3_1
X_4123_ _5010_/A1 wire516/A _4123_/B1 _4123_/B2 VGND VGND VPWR VPWR _5204_/D sky130_fd_sc_hd__a22o_2
XFILLER_110_385 VGND VGND VPWR VPWR sky130_fd_sc_hd__fill_2
XFILLER_96_586 VGND VGND VPWR VPWR sky130_fd_sc_hd__fill_2
Xhold1928 _5709_/Q VGND VGND VPWR VPWR _4664_/B2 sky130_fd_sc_hd__dlygate4sd3_1
Xhold1939 _5483_/Q VGND VGND VPWR VPWR _4423_/B2 sky130_fd_sc_hd__dlygate4sd3_1
Xinput2 rd[1] VGND VGND VPWR VPWR input2/X sky130_fd_sc_hd__clkdlybuf4s25_1
X_4054_ _5012_/A1 wire533/A _4054_/B1 _4054_/B2 VGND VGND VPWR VPWR _5142_/D sky130_fd_sc_hd__a22o_2
XFILLER_37_642 VGND VGND VPWR VPWR sky130_fd_sc_hd__decap_3
XFILLER_83_225 VGND VGND VPWR VPWR sky130_fd_sc_hd__fill_1
X_3005_ _3005_/A1 _3001_/X _3004_/X _3118_/A1 VGND VGND VPWR VPWR _3005_/X sky130_fd_sc_hd__o211a_2
XFILLER_36_141 VGND VGND VPWR VPWR sky130_fd_sc_hd__decap_3
XTAP_TAPCELL_ROW_108_1543 VGND VPWR sky130_fd_sc_hd__tapvpwrvgnd_1
XFILLER_101_15 VGND VGND VPWR VPWR sky130_fd_sc_hd__decap_3
XFILLER_24_336 VGND VGND VPWR VPWR sky130_fd_sc_hd__fill_2
XFILLER_52_645 VGND VGND VPWR VPWR sky130_fd_sc_hd__fill_1
XFILLER_24_347 VGND VGND VPWR VPWR sky130_fd_sc_hd__decap_3
XFILLER_51_177 VGND VGND VPWR VPWR sky130_fd_sc_hd__fill_2
XTAP_TAPCELL_ROW_22_515 VGND VPWR sky130_fd_sc_hd__tapvpwrvgnd_1
X_4956_ _4990_/A1 _4964_/A2 _4964_/B1 _4956_/B2 VGND VGND VPWR VPWR _5984_/D sky130_fd_sc_hd__a22o_2
XFILLER_32_391 VGND VGND VPWR VPWR sky130_fd_sc_hd__decap_3
XTAP_TAPCELL_ROW_50_846 VGND VPWR sky130_fd_sc_hd__tapvpwrvgnd_1
X_4887_ _5023_/A1 wire360/X _4895_/B1 _4887_/B2 VGND VGND VPWR VPWR _5919_/D sky130_fd_sc_hd__a22o_2
X_3907_ _5206_/Q _5174_/Q _3907_/S VGND VGND VPWR VPWR _3907_/X sky130_fd_sc_hd__mux2_1
XFILLER_20_553 VGND VGND VPWR VPWR sky130_fd_sc_hd__fill_2
X_3838_ _3889_/A _3835_/X _3837_/X wire628/X VGND VGND VPWR VPWR _3838_/X sky130_fd_sc_hd__o211a_2
XFILLER_10_12 VGND VGND VPWR VPWR sky130_fd_sc_hd__decap_3
XFILLER_3_207 VGND VGND VPWR VPWR sky130_fd_sc_hd__decap_3
X_5508_ _5572_/CLK _5508_/D VGND VGND VPWR VPWR _5508_/Q sky130_fd_sc_hd__dfxtp_2
X_3769_ _3918_/A _3765_/X _3768_/X wire630/X VGND VGND VPWR VPWR _3769_/X sky130_fd_sc_hd__o211a_2
XFILLER_106_669 VGND VGND VPWR VPWR sky130_fd_sc_hd__decap_3
XTAP_TAPCELL_ROW_72_1108 VGND VPWR sky130_fd_sc_hd__tapvpwrvgnd_1
XTAP_TAPCELL_ROW_72_1119 VGND VPWR sky130_fd_sc_hd__tapvpwrvgnd_1
X_5439_ _6060_/CLK _5439_/D VGND VGND VPWR VPWR _5439_/Q sky130_fd_sc_hd__dfxtp_2
XFILLER_86_27 VGND VGND VPWR VPWR sky130_fd_sc_hd__fill_1
XFILLER_87_531 VGND VGND VPWR VPWR sky130_fd_sc_hd__decap_3
XFILLER_99_380 VGND VGND VPWR VPWR sky130_fd_sc_hd__decap_3
Xfanout1008 input14/X VGND VGND VPWR VPWR _3612_/C1 sky130_fd_sc_hd__clkdlybuf4s25_1
XFILLER_87_564 VGND VGND VPWR VPWR sky130_fd_sc_hd__fill_1
XFILLER_101_363 VGND VGND VPWR VPWR sky130_fd_sc_hd__decap_3
XFILLER_19_108 VGND VGND VPWR VPWR sky130_fd_sc_hd__decap_3
XFILLER_28_642 VGND VGND VPWR VPWR sky130_fd_sc_hd__fill_2
XTAP_TAPCELL_ROW_58_946 VGND VPWR sky130_fd_sc_hd__tapvpwrvgnd_1
XTAP_TAPCELL_ROW_2_273 VGND VPWR sky130_fd_sc_hd__tapvpwrvgnd_1
XFILLER_28_686 VGND VGND VPWR VPWR sky130_fd_sc_hd__fill_2
XTAP_TAPCELL_ROW_83_1248 VGND VPWR sky130_fd_sc_hd__tapvpwrvgnd_1
XFILLER_42_177 VGND VGND VPWR VPWR sky130_fd_sc_hd__decap_3
XFILLER_70_464 VGND VGND VPWR VPWR sky130_fd_sc_hd__fill_2
XFILLER_70_497 VGND VGND VPWR VPWR sky130_fd_sc_hd__fill_1
XFILLER_51_52 VGND VGND VPWR VPWR sky130_fd_sc_hd__decap_3
Xwire400 wire400/A VGND VGND VPWR VPWR wire400/X sky130_fd_sc_hd__buf_4
XTAP_TAPCELL_ROW_94_1377 VGND VPWR sky130_fd_sc_hd__tapvpwrvgnd_1
XFILLER_111_116 VGND VGND VPWR VPWR sky130_fd_sc_hd__decap_3
XFILLER_112_628 VGND VGND VPWR VPWR sky130_fd_sc_hd__decap_3
Xload_slew405 _4642_/B VGND VGND VPWR VPWR _4668_/A2 sky130_fd_sc_hd__buf_4
XFILLER_111_138 VGND VGND VPWR VPWR sky130_fd_sc_hd__decap_3
XFILLER_78_531 VGND VGND VPWR VPWR sky130_fd_sc_hd__fill_1
Xload_slew449 _4433_/A2 VGND VGND VPWR VPWR _4425_/A2 sky130_fd_sc_hd__clkbuf_2
XFILLER_38_406 VGND VGND VPWR VPWR sky130_fd_sc_hd__decap_3
XFILLER_93_501 VGND VGND VPWR VPWR sky130_fd_sc_hd__decap_3
XFILLER_19_642 VGND VGND VPWR VPWR sky130_fd_sc_hd__decap_3
XFILLER_65_225 VGND VGND VPWR VPWR sky130_fd_sc_hd__fill_1
XFILLER_93_589 VGND VGND VPWR VPWR sky130_fd_sc_hd__fill_1
XFILLER_33_111 VGND VGND VPWR VPWR sky130_fd_sc_hd__fill_1
XFILLER_34_634 VGND VGND VPWR VPWR sky130_fd_sc_hd__decap_3
XFILLER_46_494 VGND VGND VPWR VPWR sky130_fd_sc_hd__decap_3
XFILLER_92_70 VGND VGND VPWR VPWR sky130_fd_sc_hd__fill_2
XFILLER_92_81 VGND VGND VPWR VPWR sky130_fd_sc_hd__decap_3
X_4810_ _5014_/A _4878_/B VGND VGND VPWR VPWR _4810_/Y sky130_fd_sc_hd__nor2_1
XFILLER_33_155 VGND VGND VPWR VPWR sky130_fd_sc_hd__decap_3
X_5790_ _5790_/CLK _5790_/D VGND VGND VPWR VPWR _5790_/Q sky130_fd_sc_hd__dfxtp_2
XFILLER_14_391 VGND VGND VPWR VPWR sky130_fd_sc_hd__decap_3
XTAP_TAPCELL_ROW_103_1484 VGND VPWR sky130_fd_sc_hd__tapvpwrvgnd_1
X_4741_ _4943_/A1 _4741_/A2 _4741_/B1 _4741_/B2 VGND VGND VPWR VPWR _5781_/D sky130_fd_sc_hd__a22o_2
X_4672_ _4775_/A1 wire400/X wire179/A _4672_/B2 VGND VGND VPWR VPWR _5717_/D sky130_fd_sc_hd__a22o_2
X_3623_ _3347_/A _3621_/X _3622_/X _3632_/A VGND VGND VPWR VPWR _3623_/X sky130_fd_sc_hd__o22a_2
X_3554_ _3708_/A1 _3551_/X _3553_/X _3709_/A1 VGND VGND VPWR VPWR _3554_/X sky130_fd_sc_hd__a22o_2
XFILLER_103_617 VGND VGND VPWR VPWR sky130_fd_sc_hd__decap_3
X_3485_ _5123_/Q _5091_/Q _6019_/Q _5987_/Q _3733_/S _3839_/S1 VGND VGND VPWR VPWR
+ _3485_/X sky130_fd_sc_hd__mux4_2
X_2505_ _5560_/Q _5528_/Q _2510_/S VGND VGND VPWR VPWR _2505_/X sky130_fd_sc_hd__mux2_1
XFILLER_102_105 VGND VGND VPWR VPWR sky130_fd_sc_hd__decap_3
X_5224_ _5800_/CLK _5224_/D VGND VGND VPWR VPWR _5224_/Q sky130_fd_sc_hd__dfxtp_2
XFILLER_102_138 VGND VGND VPWR VPWR sky130_fd_sc_hd__fill_2
XFILLER_111_650 VGND VGND VPWR VPWR sky130_fd_sc_hd__decap_3
XFILLER_29_428 VGND VGND VPWR VPWR sky130_fd_sc_hd__decap_3
XFILLER_56_203 VGND VGND VPWR VPWR sky130_fd_sc_hd__decap_3
XFILLER_69_597 VGND VGND VPWR VPWR sky130_fd_sc_hd__fill_1
XPHY_EDGE_ROW_16_Left_132 VGND VGND VPWR VPWR sky130_fd_sc_hd__decap_3
Xhold1703 _5418_/Q VGND VGND VPWR VPWR _4352_/B2 sky130_fd_sc_hd__dlygate4sd3_1
Xhold1714 _5321_/Q VGND VGND VPWR VPWR _4249_/B2 sky130_fd_sc_hd__dlygate4sd3_1
Xhold1725 _5701_/Q VGND VGND VPWR VPWR _4656_/B2 sky130_fd_sc_hd__dlygate4sd3_1
X_5155_ _5513_/CLK _5155_/D VGND VGND VPWR VPWR _5155_/Q sky130_fd_sc_hd__dfxtp_2
Xhold1736 _5779_/Q VGND VGND VPWR VPWR _4739_/B2 sky130_fd_sc_hd__dlygate4sd3_1
Xhold1747 _5668_/Q VGND VGND VPWR VPWR _4621_/B2 sky130_fd_sc_hd__dlygate4sd3_1
Xhold1758 _5926_/Q VGND VGND VPWR VPWR _4894_/B2 sky130_fd_sc_hd__dlygate4sd3_1
Xhold1769 _5273_/Q VGND VGND VPWR VPWR _4199_/B2 sky130_fd_sc_hd__dlygate4sd3_1
X_5086_ _5986_/CLK _5086_/D VGND VGND VPWR VPWR _5086_/Q sky130_fd_sc_hd__dfxtp_2
X_4106_ _4517_/A1 _4111_/A2 _4112_/B1 _4106_/B2 VGND VGND VPWR VPWR _5187_/D sky130_fd_sc_hd__a22o_2
XFILLER_112_25 VGND VGND VPWR VPWR sky130_fd_sc_hd__decap_3
XFILLER_84_589 VGND VGND VPWR VPWR sky130_fd_sc_hd__decap_3
XTAP_TAPCELL_ROW_55_905 VGND VPWR sky130_fd_sc_hd__tapvpwrvgnd_1
X_4037_ _4519_/A1 _4023_/B _4054_/B1 _4037_/B2 VGND VGND VPWR VPWR _5125_/D sky130_fd_sc_hd__a22o_2
XFILLER_112_47 VGND VGND VPWR VPWR sky130_fd_sc_hd__decap_3
XFILLER_24_111 VGND VGND VPWR VPWR sky130_fd_sc_hd__decap_3
XTAP_TAPCELL_ROW_69_1081 VGND VPWR sky130_fd_sc_hd__tapvpwrvgnd_1
XFILLER_72_29 VGND VGND VPWR VPWR sky130_fd_sc_hd__fill_1
XFILLER_24_177 VGND VGND VPWR VPWR sky130_fd_sc_hd__fill_2
XFILLER_52_486 VGND VGND VPWR VPWR sky130_fd_sc_hd__decap_3
XTAP_TAPCELL_ROW_35_673 VGND VPWR sky130_fd_sc_hd__tapvpwrvgnd_1
X_5988_ _6031_/CLK _5988_/D VGND VGND VPWR VPWR _5988_/Q sky130_fd_sc_hd__dfxtp_2
X_4939_ _5041_/A1 wire355/X _4945_/B1 _4939_/B2 VGND VGND VPWR VPWR _5969_/D sky130_fd_sc_hd__a22o_2
XANTENNA_40 _5015_/Y VGND VGND VPWR VPWR sky130_fd_sc_hd__diode_2
XPHY_EDGE_ROW_25_Left_141 VGND VGND VPWR VPWR sky130_fd_sc_hd__decap_3
XFILLER_20_361 VGND VGND VPWR VPWR sky130_fd_sc_hd__decap_3
XFILLER_106_433 VGND VGND VPWR VPWR sky130_fd_sc_hd__decap_3
XFILLER_21_66 VGND VGND VPWR VPWR sky130_fd_sc_hd__decap_3
XFILLER_97_15 VGND VGND VPWR VPWR sky130_fd_sc_hd__decap_3
XFILLER_106_477 VGND VGND VPWR VPWR sky130_fd_sc_hd__decap_3
XTAP_TAPCELL_ROW_7_332 VGND VPWR sky130_fd_sc_hd__tapvpwrvgnd_1
XPHY_EDGE_ROW_34_Left_150 VGND VGND VPWR VPWR sky130_fd_sc_hd__decap_3
XFILLER_102_683 VGND VGND VPWR VPWR sky130_fd_sc_hd__decap_3
XFILLER_94_309 VGND VGND VPWR VPWR sky130_fd_sc_hd__fill_2
XFILLER_101_160 VGND VGND VPWR VPWR sky130_fd_sc_hd__fill_1
XFILLER_47_225 VGND VGND VPWR VPWR sky130_fd_sc_hd__decap_3
XFILLER_87_383 VGND VGND VPWR VPWR sky130_fd_sc_hd__fill_1
XFILLER_62_206 VGND VGND VPWR VPWR sky130_fd_sc_hd__decap_3
XFILLER_90_504 VGND VGND VPWR VPWR sky130_fd_sc_hd__fill_1
XFILLER_16_601 VGND VGND VPWR VPWR sky130_fd_sc_hd__decap_3
XFILLER_16_623 VGND VGND VPWR VPWR sky130_fd_sc_hd__decap_3
XFILLER_46_85 VGND VGND VPWR VPWR sky130_fd_sc_hd__decap_3
XFILLER_16_645 VGND VGND VPWR VPWR sky130_fd_sc_hd__decap_3
XFILLER_31_615 VGND VGND VPWR VPWR sky130_fd_sc_hd__fill_1
XFILLER_62_73 VGND VGND VPWR VPWR sky130_fd_sc_hd__fill_2
XFILLER_7_24 VGND VGND VPWR VPWR sky130_fd_sc_hd__decap_3
XFILLER_7_321 VGND VGND VPWR VPWR sky130_fd_sc_hd__decap_3
XTAP_TAPCELL_ROW_96_1406 VGND VPWR sky130_fd_sc_hd__tapvpwrvgnd_1
XFILLER_7_365 VGND VGND VPWR VPWR sky130_fd_sc_hd__decap_3
XFILLER_7_57 VGND VGND VPWR VPWR sky130_fd_sc_hd__decap_3
XFILLER_109_260 VGND VGND VPWR VPWR sky130_fd_sc_hd__decap_3
XFILLER_7_387 VGND VGND VPWR VPWR sky130_fd_sc_hd__decap_3
XFILLER_112_403 VGND VGND VPWR VPWR sky130_fd_sc_hd__fill_1
Xload_slew213 _4494_/B1 VGND VGND VPWR VPWR _4501_/B1 sky130_fd_sc_hd__buf_4
X_3270_ _5689_/Q _5657_/Q _5625_/Q _5593_/Q _3631_/S _3629_/S1 VGND VGND VPWR VPWR
+ _3271_/B sky130_fd_sc_hd__mux4_2
XFILLER_97_136 VGND VGND VPWR VPWR sky130_fd_sc_hd__decap_3
Xload_slew235 _4375_/B1 VGND VGND VPWR VPWR _4396_/B1 sky130_fd_sc_hd__clkbuf_4
XFILLER_78_361 VGND VGND VPWR VPWR sky130_fd_sc_hd__decap_3
Xload_slew279 _4185_/B1 VGND VGND VPWR VPWR _4191_/B1 sky130_fd_sc_hd__buf_4
Xload_slew257 _4287_/B1 VGND VGND VPWR VPWR _4295_/B1 sky130_fd_sc_hd__buf_2
XFILLER_16_3 VGND VGND VPWR VPWR sky130_fd_sc_hd__decap_3
XFILLER_66_589 VGND VGND VPWR VPWR sky130_fd_sc_hd__decap_3
XTAP_TAPCELL_ROW_105_1513 VGND VPWR sky130_fd_sc_hd__tapvpwrvgnd_1
X_5911_ _5943_/CLK _5911_/D VGND VGND VPWR VPWR _5911_/Q sky130_fd_sc_hd__dfxtp_2
XFILLER_21_103 VGND VGND VPWR VPWR sky130_fd_sc_hd__decap_3
X_5842_ _6066_/CLK _5842_/D VGND VGND VPWR VPWR _5842_/Q sky130_fd_sc_hd__dfxtp_2
XTAP_TAPCELL_ROW_32_632 VGND VPWR sky130_fd_sc_hd__tapvpwrvgnd_1
X_5773_ _5938_/CLK _5773_/D VGND VGND VPWR VPWR _5773_/Q sky130_fd_sc_hd__dfxtp_2
XFILLER_21_158 VGND VGND VPWR VPWR sky130_fd_sc_hd__decap_3
XFILLER_21_169 VGND VGND VPWR VPWR sky130_fd_sc_hd__fill_1
XTAP_TAPCELL_ROW_60_974 VGND VPWR sky130_fd_sc_hd__tapvpwrvgnd_1
X_4724_ _4926_/A1 _4742_/A2 _4740_/B1 _4724_/B2 VGND VGND VPWR VPWR _5764_/D sky130_fd_sc_hd__a22o_2
X_2985_ _2978_/X _2984_/X _3231_/B1 VGND VGND VPWR VPWR _2985_/X sky130_fd_sc_hd__o21a_2
X_4655_ _4926_/A1 wire400/A wire179/X _4655_/B2 VGND VGND VPWR VPWR _5700_/D sky130_fd_sc_hd__a22o_2
X_4586_ _4891_/A1 wire414/X wire193/X _4586_/B2 VGND VGND VPWR VPWR _5635_/D sky130_fd_sc_hd__a22o_2
X_3606_ _3611_/A1 _3603_/X _3605_/X _3896_/A1 VGND VGND VPWR VPWR _3606_/X sky130_fd_sc_hd__o22a_2
X_3537_ wire591/A _3535_/X _3536_/X _3547_/B2 VGND VGND VPWR VPWR _3537_/X sky130_fd_sc_hd__o22a_2
XFILLER_107_36 VGND VGND VPWR VPWR sky130_fd_sc_hd__decap_3
XFILLER_89_626 VGND VGND VPWR VPWR sky130_fd_sc_hd__decap_3
XFILLER_107_69 VGND VGND VPWR VPWR sky130_fd_sc_hd__decap_3
X_3468_ _5922_/Q _5890_/Q _5858_/Q _5762_/Q _3379_/S _3469_/S1 VGND VGND VPWR VPWR
+ _3468_/X sky130_fd_sc_hd__mux4_2
XFILLER_57_501 VGND VGND VPWR VPWR sky130_fd_sc_hd__decap_3
XFILLER_76_309 VGND VGND VPWR VPWR sky130_fd_sc_hd__fill_1
XTAP_TAPCELL_ROW_4_302 VGND VPWR sky130_fd_sc_hd__tapvpwrvgnd_1
Xhold1500 _5176_/Q VGND VGND VPWR VPWR _4095_/B2 sky130_fd_sc_hd__dlygate4sd3_1
X_5207_ _5815_/CLK _5207_/D VGND VGND VPWR VPWR _5207_/Q sky130_fd_sc_hd__dfxtp_2
X_3399_ _3399_/A1 _3396_/X _3398_/X _3385_/A VGND VGND VPWR VPWR _3399_/X sky130_fd_sc_hd__a22o_2
XFILLER_29_214 VGND VGND VPWR VPWR sky130_fd_sc_hd__fill_2
XFILLER_29_225 VGND VGND VPWR VPWR sky130_fd_sc_hd__fill_2
Xhold1511 _5298_/Q VGND VGND VPWR VPWR _4224_/B2 sky130_fd_sc_hd__dlygate4sd3_1
Xhold1522 _5750_/Q VGND VGND VPWR VPWR _4707_/B2 sky130_fd_sc_hd__dlygate4sd3_1
Xhold1533 _5747_/Q VGND VGND VPWR VPWR _4704_/B2 sky130_fd_sc_hd__dlygate4sd3_1
Xhold1544 _5096_/Q VGND VGND VPWR VPWR _4005_/B2 sky130_fd_sc_hd__dlygate4sd3_1
X_5138_ _6034_/CLK _5138_/D VGND VGND VPWR VPWR _5138_/Q sky130_fd_sc_hd__dfxtp_2
XFILLER_29_247 VGND VGND VPWR VPWR sky130_fd_sc_hd__decap_3
XFILLER_72_504 VGND VGND VPWR VPWR sky130_fd_sc_hd__decap_3
Xhold1555 _6022_/Q VGND VGND VPWR VPWR _4996_/B2 sky130_fd_sc_hd__dlygate4sd3_1
Xhold1566 _5445_/Q VGND VGND VPWR VPWR _4382_/B2 sky130_fd_sc_hd__dlygate4sd3_1
Xhold1577 _5056_/Q VGND VGND VPWR VPWR _3960_/B2 sky130_fd_sc_hd__dlygate4sd3_1
XFILLER_44_217 VGND VGND VPWR VPWR sky130_fd_sc_hd__decap_3
XFILLER_57_589 VGND VGND VPWR VPWR sky130_fd_sc_hd__decap_3
Xhold1588 _5439_/Q VGND VGND VPWR VPWR _4376_/B2 sky130_fd_sc_hd__dlygate4sd3_1
Xhold1599 _5261_/Q VGND VGND VPWR VPWR _4184_/B2 sky130_fd_sc_hd__dlygate4sd3_1
X_5069_ _5805_/CLK _5069_/D VGND VGND VPWR VPWR _5069_/Q sky130_fd_sc_hd__dfxtp_2
XTAP_TAPCELL_ROW_80_1207 VGND VPWR sky130_fd_sc_hd__tapvpwrvgnd_1
XFILLER_13_648 VGND VGND VPWR VPWR sky130_fd_sc_hd__decap_3
XFILLER_12_147 VGND VGND VPWR VPWR sky130_fd_sc_hd__decap_3
XFILLER_40_467 VGND VGND VPWR VPWR sky130_fd_sc_hd__fill_1
XFILLER_21_670 VGND VGND VPWR VPWR sky130_fd_sc_hd__fill_2
XFILLER_20_180 VGND VGND VPWR VPWR sky130_fd_sc_hd__decap_3
XFILLER_106_241 VGND VGND VPWR VPWR sky130_fd_sc_hd__decap_3
XFILLER_79_103 VGND VGND VPWR VPWR sky130_fd_sc_hd__decap_3
XTAP_TAPCELL_ROW_91_1347 VGND VPWR sky130_fd_sc_hd__tapvpwrvgnd_1
XTAP_TAPCELL_ROW_91_1336 VGND VPWR sky130_fd_sc_hd__tapvpwrvgnd_1
XFILLER_79_125 VGND VGND VPWR VPWR sky130_fd_sc_hd__decap_3
XFILLER_102_480 VGND VGND VPWR VPWR sky130_fd_sc_hd__decap_3
XFILLER_35_228 VGND VGND VPWR VPWR sky130_fd_sc_hd__fill_1
XFILLER_48_589 VGND VGND VPWR VPWR sky130_fd_sc_hd__decap_3
XFILLER_90_312 VGND VGND VPWR VPWR sky130_fd_sc_hd__decap_3
XFILLER_113_90 VGND VGND VPWR VPWR sky130_fd_sc_hd__decap_3
XFILLER_90_345 VGND VGND VPWR VPWR sky130_fd_sc_hd__decap_3
XFILLER_31_445 VGND VGND VPWR VPWR sky130_fd_sc_hd__decap_3
XFILLER_12_681 VGND VGND VPWR VPWR sky130_fd_sc_hd__decap_3
XTAP_TAPCELL_ROW_100_1454 VGND VPWR sky130_fd_sc_hd__tapvpwrvgnd_1
X_2770_ _3019_/A _2770_/B VGND VGND VPWR VPWR _2770_/X sky130_fd_sc_hd__or2_2
XFILLER_8_674 VGND VGND VPWR VPWR sky130_fd_sc_hd__decap_3
XFILLER_7_151 VGND VGND VPWR VPWR sky130_fd_sc_hd__fill_2
X_4440_ _4508_/A1 _4465_/A2 _4465_/B1 _4440_/B2 VGND VGND VPWR VPWR _5498_/D sky130_fd_sc_hd__a22o_2
X_4371_ _5018_/A1 _4396_/A2 _4375_/B1 _4371_/B2 VGND VGND VPWR VPWR _5434_/D sky130_fd_sc_hd__a22o_2
XFILLER_98_91 VGND VGND VPWR VPWR sky130_fd_sc_hd__decap_3
X_3322_ _5819_/Q _5435_/Q _6043_/Q _5947_/Q _3325_/S _3566_/S1 VGND VGND VPWR VPWR
+ _3322_/X sky130_fd_sc_hd__mux4_2
X_6041_ _6041_/CLK _6041_/D VGND VGND VPWR VPWR _6041_/Q sky130_fd_sc_hd__dfxtp_2
X_3253_ _3261_/A _3261_/B VGND VGND VPWR VPWR _3253_/X sky130_fd_sc_hd__and2b_2
XFILLER_78_180 VGND VGND VPWR VPWR sky130_fd_sc_hd__decap_3
XTAP_TAPCELL_ROW_111_1583 VGND VPWR sky130_fd_sc_hd__tapvpwrvgnd_1
X_3184_ _3184_/A1 _3181_/X _3183_/X VGND VGND VPWR VPWR _3184_/X sky130_fd_sc_hd__a21o_2
XFILLER_93_172 VGND VGND VPWR VPWR sky130_fd_sc_hd__decap_3
XFILLER_22_401 VGND VGND VPWR VPWR sky130_fd_sc_hd__fill_2
XFILLER_81_389 VGND VGND VPWR VPWR sky130_fd_sc_hd__decap_3
XTAP_TAPCELL_ROW_66_1040 VGND VPWR sky130_fd_sc_hd__tapvpwrvgnd_1
XTAP_TAPCELL_ROW_45_790 VGND VPWR sky130_fd_sc_hd__tapvpwrvgnd_1
X_5825_ _5825_/CLK _5825_/D VGND VGND VPWR VPWR _5825_/Q sky130_fd_sc_hd__dfxtp_2
X_5756_ _6044_/CLK _5756_/D VGND VGND VPWR VPWR _5756_/Q sky130_fd_sc_hd__dfxtp_2
X_2968_ _5932_/Q _5900_/Q _5868_/Q _5772_/Q _2971_/S _2973_/S1 VGND VGND VPWR VPWR
+ _2969_/B sky130_fd_sc_hd__mux4_2
X_5687_ _5815_/CLK _5687_/D VGND VGND VPWR VPWR _5687_/Q sky130_fd_sc_hd__dfxtp_2
X_4707_ _4776_/A1 _4707_/A2 _4707_/B1 _4707_/B2 VGND VGND VPWR VPWR _5750_/D sky130_fd_sc_hd__a22o_2
XFILLER_108_528 VGND VGND VPWR VPWR sky130_fd_sc_hd__decap_3
X_4638_ _4775_/A1 wire407/X wire186/A _4638_/B2 VGND VGND VPWR VPWR _5685_/D sky130_fd_sc_hd__a22o_2
X_2899_ _2904_/A1 _2896_/X _2898_/X input9/X VGND VGND VPWR VPWR _2899_/X sky130_fd_sc_hd__o211a_2
X_4569_ _4908_/A1 _4571_/A2 _4571_/B1 _4569_/B2 VGND VGND VPWR VPWR _5620_/D sky130_fd_sc_hd__a22o_2
Xhold2020 _5226_/Q VGND VGND VPWR VPWR _4147_/B2 sky130_fd_sc_hd__dlygate4sd3_1
Xhold2031 _5852_/Q VGND VGND VPWR VPWR _4816_/B2 sky130_fd_sc_hd__dlygate4sd3_1
Xhold2042 _5051_/Q VGND VGND VPWR VPWR _3955_/B2 sky130_fd_sc_hd__dlygate4sd3_1
Xhold2053 _5976_/Q VGND VGND VPWR VPWR _4948_/B2 sky130_fd_sc_hd__dlygate4sd3_1
Xhold1330 _5990_/Q VGND VGND VPWR VPWR _4962_/B2 sky130_fd_sc_hd__dlygate4sd3_1
Xhold1341 _5911_/Q VGND VGND VPWR VPWR _4877_/B2 sky130_fd_sc_hd__dlygate4sd3_1
Xhold1352 _5939_/Q VGND VGND VPWR VPWR _4907_/B2 sky130_fd_sc_hd__dlygate4sd3_1
Xhold2064 _5528_/Q VGND VGND VPWR VPWR _4472_/B2 sky130_fd_sc_hd__dlygate4sd3_1
Xhold2075 _5352_/Q VGND VGND VPWR VPWR _4282_/B2 sky130_fd_sc_hd__dlygate4sd3_1
Xhold2086 _5351_/Q VGND VGND VPWR VPWR _4281_/B2 sky130_fd_sc_hd__dlygate4sd3_1
Xhold2097 _5080_/Q VGND VGND VPWR VPWR _3989_/B2 sky130_fd_sc_hd__dlygate4sd3_1
XFILLER_17_228 VGND VGND VPWR VPWR sky130_fd_sc_hd__fill_2
XFILLER_27_21 VGND VGND VPWR VPWR sky130_fd_sc_hd__decap_3
XFILLER_85_673 VGND VGND VPWR VPWR sky130_fd_sc_hd__decap_3
Xhold1363 _5311_/Q VGND VGND VPWR VPWR _4239_/B2 sky130_fd_sc_hd__dlygate4sd3_1
Xhold1374 _5806_/Q VGND VGND VPWR VPWR _4768_/B2 sky130_fd_sc_hd__dlygate4sd3_1
Xhold1385 _5188_/Q VGND VGND VPWR VPWR _4107_/B2 sky130_fd_sc_hd__dlygate4sd3_1
Xhold1396 _5710_/Q VGND VGND VPWR VPWR _4665_/B2 sky130_fd_sc_hd__dlygate4sd3_1
XFILLER_27_98 VGND VGND VPWR VPWR sky130_fd_sc_hd__decap_3
XTAP_TAPCELL_ROW_15_429 VGND VPWR sky130_fd_sc_hd__tapvpwrvgnd_1
XFILLER_40_286 VGND VGND VPWR VPWR sky130_fd_sc_hd__decap_3
XFILLER_9_449 VGND VGND VPWR VPWR sky130_fd_sc_hd__decap_3
XFILLER_5_644 VGND VGND VPWR VPWR sky130_fd_sc_hd__decap_3
XFILLER_107_561 VGND VGND VPWR VPWR sky130_fd_sc_hd__decap_3
XFILLER_4_165 VGND VGND VPWR VPWR sky130_fd_sc_hd__fill_1
XFILLER_4_47 VGND VGND VPWR VPWR sky130_fd_sc_hd__decap_3
XFILLER_67_106 VGND VGND VPWR VPWR sky130_fd_sc_hd__decap_3
XFILLER_68_50 VGND VGND VPWR VPWR sky130_fd_sc_hd__decap_3
XFILLER_68_607 VGND VGND VPWR VPWR sky130_fd_sc_hd__fill_1
XFILLER_0_393 VGND VGND VPWR VPWR sky130_fd_sc_hd__decap_3
XFILLER_75_172 VGND VGND VPWR VPWR sky130_fd_sc_hd__fill_1
XFILLER_76_684 VGND VGND VPWR VPWR sky130_fd_sc_hd__decap_3
XFILLER_91_687 VGND VGND VPWR VPWR sky130_fd_sc_hd__fill_1
X_3940_ _5719_/Q _5687_/Q _5655_/Q _5623_/Q _3936_/S _3940_/S1 VGND VGND VPWR VPWR
+ _3941_/B sky130_fd_sc_hd__mux4_2
XFILLER_44_592 VGND VGND VPWR VPWR sky130_fd_sc_hd__fill_2
XFILLER_90_197 VGND VGND VPWR VPWR sky130_fd_sc_hd__fill_1
XFILLER_31_242 VGND VGND VPWR VPWR sky130_fd_sc_hd__fill_2
X_3871_ _5268_/Q _5236_/Q _3873_/S VGND VGND VPWR VPWR _3872_/B sky130_fd_sc_hd__mux2_1
XFILLER_83_3 VGND VGND VPWR VPWR sky130_fd_sc_hd__decap_3
X_5610_ _5804_/CLK _5610_/D VGND VGND VPWR VPWR _5610_/Q sky130_fd_sc_hd__dfxtp_2
X_2822_ _5509_/Q _5477_/Q _2856_/S VGND VGND VPWR VPWR _2822_/X sky130_fd_sc_hd__mux2_1
X_5541_ _5832_/CLK _5541_/D VGND VGND VPWR VPWR _5541_/Q sky130_fd_sc_hd__dfxtp_2
X_2753_ _5570_/Q _5538_/Q _3221_/S VGND VGND VPWR VPWR _2753_/X sky130_fd_sc_hd__mux2_1
XFILLER_8_471 VGND VGND VPWR VPWR sky130_fd_sc_hd__decap_3
X_5472_ _6024_/CLK _5472_/D VGND VGND VPWR VPWR _5472_/Q sky130_fd_sc_hd__dfxtp_2
X_2684_ _5503_/Q _5471_/Q _2971_/S VGND VGND VPWR VPWR _2684_/X sky130_fd_sc_hd__mux2_1
XTAP_TAPCELL_ROW_113_1601 VGND VPWR sky130_fd_sc_hd__tapvpwrvgnd_1
X_4423_ _5001_/A1 _4426_/A2 _4426_/B1 _4423_/B2 VGND VGND VPWR VPWR _5483_/D sky130_fd_sc_hd__a22o_2
X_4354_ _5036_/A1 _4365_/A2 _4365_/B1 _4354_/B2 VGND VGND VPWR VPWR _5420_/D sky130_fd_sc_hd__a22o_2
XFILLER_113_575 VGND VGND VPWR VPWR sky130_fd_sc_hd__decap_3
Xfanout439 _4436_/Y VGND VGND VPWR VPWR _4465_/A2 sky130_fd_sc_hd__clkdlybuf4s25_1
Xfanout406 _4607_/Y VGND VGND VPWR VPWR wire407/A sky130_fd_sc_hd__clkdlybuf4s25_1
X_3305_ _3305_/A _3305_/B VGND VGND VPWR VPWR _3305_/X sky130_fd_sc_hd__or2_2
XFILLER_100_203 VGND VGND VPWR VPWR sky130_fd_sc_hd__decap_3
X_6024_ _6024_/CLK _6024_/D VGND VGND VPWR VPWR _6024_/Q sky130_fd_sc_hd__dfxtp_2
X_4285_ _4525_/A1 wire475/A wire255/X _4285_/B2 VGND VGND VPWR VPWR _5355_/D sky130_fd_sc_hd__a22o_2
XFILLER_100_247 VGND VGND VPWR VPWR sky130_fd_sc_hd__decap_3
XFILLER_104_15 VGND VGND VPWR VPWR sky130_fd_sc_hd__decap_3
XFILLER_67_640 VGND VGND VPWR VPWR sky130_fd_sc_hd__decap_3
X_3236_ _5912_/Q _5880_/Q _5848_/Q _5752_/Q _3774_/S _3788_/S1 VGND VGND VPWR VPWR
+ _3236_/X sky130_fd_sc_hd__mux4_2
XFILLER_100_269 VGND VGND VPWR VPWR sky130_fd_sc_hd__decap_3
XFILLER_67_673 VGND VGND VPWR VPWR sky130_fd_sc_hd__decap_3
X_3167_ _3183_/A1 _3164_/X _3166_/X _3184_/A1 VGND VGND VPWR VPWR _3167_/X sky130_fd_sc_hd__a22o_2
X_3098_ _5842_/Q _5458_/Q _3099_/S VGND VGND VPWR VPWR _3098_/X sky130_fd_sc_hd__mux2_1
XFILLER_35_592 VGND VGND VPWR VPWR sky130_fd_sc_hd__decap_3
XFILLER_80_29 VGND VGND VPWR VPWR sky130_fd_sc_hd__fill_2
XFILLER_13_12 VGND VGND VPWR VPWR sky130_fd_sc_hd__decap_3
XFILLER_22_253 VGND VGND VPWR VPWR sky130_fd_sc_hd__fill_1
X_5808_ _6064_/CLK _5808_/D VGND VGND VPWR VPWR _5808_/Q sky130_fd_sc_hd__dfxtp_2
XFILLER_10_448 VGND VGND VPWR VPWR sky130_fd_sc_hd__decap_3
X_5739_ _5963_/CLK _5739_/D VGND VGND VPWR VPWR _5739_/Q sky130_fd_sc_hd__dfxtp_2
XFILLER_13_89 VGND VGND VPWR VPWR sky130_fd_sc_hd__decap_3
XFILLER_6_419 VGND VGND VPWR VPWR sky130_fd_sc_hd__fill_1
XTAP_TAPCELL_ROW_20_487 VGND VPWR sky130_fd_sc_hd__tapvpwrvgnd_1
XFILLER_104_520 VGND VGND VPWR VPWR sky130_fd_sc_hd__decap_3
XFILLER_1_113 VGND VGND VPWR VPWR sky130_fd_sc_hd__fill_2
XFILLER_2_625 VGND VGND VPWR VPWR sky130_fd_sc_hd__decap_3
XFILLER_89_231 VGND VGND VPWR VPWR sky130_fd_sc_hd__decap_3
XFILLER_2_669 VGND VGND VPWR VPWR sky130_fd_sc_hd__decap_3
XPHY_EDGE_ROW_8_Left_124 VGND VGND VPWR VPWR sky130_fd_sc_hd__decap_3
XFILLER_104_597 VGND VGND VPWR VPWR sky130_fd_sc_hd__decap_3
XFILLER_77_426 VGND VGND VPWR VPWR sky130_fd_sc_hd__fill_2
Xfanout951 input27/X VGND VGND VPWR VPWR _4525_/A1 sky130_fd_sc_hd__clkdlybuf4s25_1
Xfanout940 input30/X VGND VGND VPWR VPWR _4767_/A1 sky130_fd_sc_hd__clkdlybuf4s25_1
Xfanout973 input21/X VGND VGND VPWR VPWR _4995_/A1 sky130_fd_sc_hd__clkdlybuf4s25_1
Xfanout984 _5026_/A1 VGND VGND VPWR VPWR _4822_/A1 sky130_fd_sc_hd__clkdlybuf4s25_1
Xfanout962 _4762_/A1 VGND VGND VPWR VPWR _4659_/A1 sky130_fd_sc_hd__clkdlybuf4s25_1
XFILLER_58_684 VGND VGND VPWR VPWR sky130_fd_sc_hd__decap_3
Xhold1160 _5517_/Q VGND VGND VPWR VPWR _4459_/B2 sky130_fd_sc_hd__dlygate4sd3_1
XFILLER_57_183 VGND VGND VPWR VPWR sky130_fd_sc_hd__decap_3
Xhold1171 _5310_/Q VGND VGND VPWR VPWR _4238_/B2 sky130_fd_sc_hd__dlygate4sd3_1
Xhold1182 _5402_/Q VGND VGND VPWR VPWR _4336_/B2 sky130_fd_sc_hd__dlygate4sd3_1
Xhold1193 _5305_/Q VGND VGND VPWR VPWR _4233_/B2 sky130_fd_sc_hd__dlygate4sd3_1
XFILLER_72_153 VGND VGND VPWR VPWR sky130_fd_sc_hd__decap_3
XFILLER_73_687 VGND VGND VPWR VPWR sky130_fd_sc_hd__fill_1
XTAP_TAPCELL_ROW_86_1279 VGND VPWR sky130_fd_sc_hd__tapvpwrvgnd_1
XFILLER_26_592 VGND VGND VPWR VPWR sky130_fd_sc_hd__decap_3
XFILLER_72_197 VGND VGND VPWR VPWR sky130_fd_sc_hd__fill_1
XTAP_TAPCELL_ROW_28_587 VGND VPWR sky130_fd_sc_hd__tapvpwrvgnd_1
XFILLER_13_242 VGND VGND VPWR VPWR sky130_fd_sc_hd__decap_3
XFILLER_54_85 VGND VGND VPWR VPWR sky130_fd_sc_hd__decap_3
XFILLER_110_80 VGND VGND VPWR VPWR sky130_fd_sc_hd__decap_3
XFILLER_41_584 VGND VGND VPWR VPWR sky130_fd_sc_hd__decap_3
XFILLER_9_213 VGND VGND VPWR VPWR sky130_fd_sc_hd__fill_1
XFILLER_110_91 VGND VGND VPWR VPWR sky130_fd_sc_hd__decap_3
Xclkload16 _6056_/CLK VGND VGND VPWR VPWR clkload16/Y sky130_fd_sc_hd__clkinv_2
Xclkload49 _6017_/CLK VGND VGND VPWR VPWR clkload49/Y sky130_fd_sc_hd__clkinv_2
Xclkload38 _5832_/CLK VGND VGND VPWR VPWR clkload38/X sky130_fd_sc_hd__clkbuf_4
Xclkload27 _6050_/CLK VGND VGND VPWR VPWR clkload27/Y sky130_fd_sc_hd__clkinv_2
XFILLER_107_391 VGND VGND VPWR VPWR sky130_fd_sc_hd__fill_1
XFILLER_48_6 VGND VGND VPWR VPWR sky130_fd_sc_hd__decap_3
XFILLER_79_60 VGND VGND VPWR VPWR sky130_fd_sc_hd__decap_3
XFILLER_95_212 VGND VGND VPWR VPWR sky130_fd_sc_hd__decap_3
XFILLER_0_190 VGND VGND VPWR VPWR sky130_fd_sc_hd__decap_3
XFILLER_49_640 VGND VGND VPWR VPWR sky130_fd_sc_hd__decap_3
XFILLER_95_245 VGND VGND VPWR VPWR sky130_fd_sc_hd__fill_1
X_4070_ _4653_/A1 wire524/X wire306/X _4070_/B2 VGND VGND VPWR VPWR _5154_/D sky130_fd_sc_hd__a22o_2
XFILLER_110_589 VGND VGND VPWR VPWR sky130_fd_sc_hd__decap_3
XFILLER_49_684 VGND VGND VPWR VPWR sky130_fd_sc_hd__decap_3
X_3021_ _5198_/Q _5166_/Q _3021_/S VGND VGND VPWR VPWR _3021_/X sky130_fd_sc_hd__mux2_1
XFILLER_63_153 VGND VGND VPWR VPWR sky130_fd_sc_hd__decap_3
XFILLER_64_676 VGND VGND VPWR VPWR sky130_fd_sc_hd__fill_2
XFILLER_63_175 VGND VGND VPWR VPWR sky130_fd_sc_hd__decap_3
XTAP_TAPCELL_ROW_63_1010 VGND VPWR sky130_fd_sc_hd__tapvpwrvgnd_1
X_4972_ input33/X _4947_/B _4976_/B1 _4972_/B2 VGND VGND VPWR VPWR _6000_/D sky130_fd_sc_hd__a22o_2
X_3923_ _3921_/X _3922_/X wire553/X VGND VGND VPWR VPWR _3923_/X sky130_fd_sc_hd__o21a_2
X_3854_ _3341_/A _3845_/X _3848_/X _3853_/X VGND VGND VPWR VPWR _3854_/X sky130_fd_sc_hd__a31o_2
X_2805_ _5701_/Q _5669_/Q _5637_/Q _5605_/Q _3199_/S _3091_/S1 VGND VGND VPWR VPWR
+ _2805_/X sky130_fd_sc_hd__mux4_2
X_3785_ _6064_/Q _5968_/Q _3785_/S VGND VGND VPWR VPWR _3785_/X sky130_fd_sc_hd__mux2_1
X_5524_ _5956_/CLK _5524_/D VGND VGND VPWR VPWR _5524_/Q sky130_fd_sc_hd__dfxtp_2
X_2736_ _5922_/Q _5890_/Q _5858_/Q _5762_/Q _2736_/S0 _3107_/S1 VGND VGND VPWR VPWR
+ _2736_/X sky130_fd_sc_hd__mux4_2
X_5455_ _6063_/CLK _5455_/D VGND VGND VPWR VPWR _5455_/Q sky130_fd_sc_hd__dfxtp_2
X_2667_ _5823_/Q _5439_/Q _3077_/S VGND VGND VPWR VPWR _2667_/X sky130_fd_sc_hd__mux2_1
X_4406_ _4508_/A1 _4431_/A2 _4431_/B1 _4406_/B2 VGND VGND VPWR VPWR _5466_/D sky130_fd_sc_hd__a22o_2
XFILLER_99_551 VGND VGND VPWR VPWR sky130_fd_sc_hd__fill_1
Xfanout214 _4471_/Y VGND VGND VPWR VPWR _4498_/B1 sky130_fd_sc_hd__clkdlybuf4s25_1
X_5386_ _5514_/CLK _5386_/D VGND VGND VPWR VPWR _5386_/Q sky130_fd_sc_hd__dfxtp_2
X_2598_ _5692_/Q _5660_/Q _5628_/Q _5596_/Q _2529_/S _2610_/S1 VGND VGND VPWR VPWR
+ _2598_/X sky130_fd_sc_hd__mux4_2
XFILLER_101_501 VGND VGND VPWR VPWR sky130_fd_sc_hd__decap_3
XFILLER_86_223 VGND VGND VPWR VPWR sky130_fd_sc_hd__decap_3
XFILLER_99_584 VGND VGND VPWR VPWR sky130_fd_sc_hd__decap_3
Xfanout247 _4331_/B1 VGND VGND VPWR VPWR wire248/A sky130_fd_sc_hd__clkdlybuf4s25_1
Xfanout236 _4368_/Y VGND VGND VPWR VPWR _4398_/B1 sky130_fd_sc_hd__clkdlybuf4s25_1
X_4337_ _4749_/A1 wire465/X _4350_/B1 _4337_/B2 VGND VGND VPWR VPWR _5403_/D sky130_fd_sc_hd__a22o_2
XFILLER_101_567 VGND VGND VPWR VPWR sky130_fd_sc_hd__decap_3
XFILLER_115_47 VGND VGND VPWR VPWR sky130_fd_sc_hd__decap_3
XFILLER_115_69 VGND VGND VPWR VPWR sky130_fd_sc_hd__decap_3
Xfanout258 _4297_/B1 VGND VGND VPWR VPWR _4284_/B1 sky130_fd_sc_hd__clkdlybuf4s25_1
X_4268_ _4645_/A1 wire475/X wire255/A _4268_/B2 VGND VGND VPWR VPWR _5338_/D sky130_fd_sc_hd__a22o_2
XFILLER_74_418 VGND VGND VPWR VPWR sky130_fd_sc_hd__fill_2
X_6007_ _6071_/CLK _6007_/D VGND VGND VPWR VPWR _6007_/Q sky130_fd_sc_hd__dfxtp_2
X_3219_ _5399_/Q _5367_/Q _5335_/Q _5303_/Q _3221_/S _2503_/B VGND VGND VPWR VPWR
+ _3219_/X sky130_fd_sc_hd__mux4_2
XFILLER_55_643 VGND VGND VPWR VPWR sky130_fd_sc_hd__fill_1
X_4199_ _4507_/A1 wire489/X wire269/X _4199_/B2 VGND VGND VPWR VPWR _5273_/D sky130_fd_sc_hd__a22o_2
XFILLER_27_345 VGND VGND VPWR VPWR sky130_fd_sc_hd__decap_3
XFILLER_54_186 VGND VGND VPWR VPWR sky130_fd_sc_hd__fill_1
XFILLER_91_28 VGND VGND VPWR VPWR sky130_fd_sc_hd__fill_1
XTAP_TAPCELL_ROW_25_546 VGND VPWR sky130_fd_sc_hd__tapvpwrvgnd_1
XTAP_TAPCELL_ROW_53_888 VGND VPWR sky130_fd_sc_hd__tapvpwrvgnd_1
XFILLER_109_601 VGND VGND VPWR VPWR sky130_fd_sc_hd__decap_3
XFILLER_6_205 VGND VGND VPWR VPWR sky130_fd_sc_hd__decap_3
XFILLER_109_645 VGND VGND VPWR VPWR sky130_fd_sc_hd__decap_3
Xwire659 wire659/A VGND VGND VPWR VPWR wire659/X sky130_fd_sc_hd__buf_4
Xload_slew609 _3370_/A1 VGND VGND VPWR VPWR _3831_/A1 sky130_fd_sc_hd__clkbuf_4
XFILLER_49_52 VGND VGND VPWR VPWR sky130_fd_sc_hd__decap_3
XFILLER_49_63 VGND VGND VPWR VPWR sky130_fd_sc_hd__decap_3
XFILLER_77_223 VGND VGND VPWR VPWR sky130_fd_sc_hd__fill_1
XFILLER_1_15 VGND VGND VPWR VPWR sky130_fd_sc_hd__decap_3
Xfanout781 _2913_/S VGND VGND VPWR VPWR _2896_/S sky130_fd_sc_hd__clkbuf_2
Xfanout770 wire772/X VGND VGND VPWR VPWR _3202_/S1 sky130_fd_sc_hd__clkdlybuf4s25_1
XTAP_TAPCELL_ROW_88_1308 VGND VPWR sky130_fd_sc_hd__tapvpwrvgnd_1
XFILLER_1_48 VGND VGND VPWR VPWR sky130_fd_sc_hd__decap_3
XFILLER_46_643 VGND VGND VPWR VPWR sky130_fd_sc_hd__fill_1
XFILLER_65_51 VGND VGND VPWR VPWR sky130_fd_sc_hd__decap_3
XFILLER_92_259 VGND VGND VPWR VPWR sky130_fd_sc_hd__decap_3
XFILLER_33_337 VGND VGND VPWR VPWR sky130_fd_sc_hd__decap_3
XFILLER_61_646 VGND VGND VPWR VPWR sky130_fd_sc_hd__decap_3
XFILLER_33_359 VGND VGND VPWR VPWR sky130_fd_sc_hd__decap_3
XTAP_TAPCELL_ROW_99_1437 VGND VPWR sky130_fd_sc_hd__tapvpwrvgnd_1
X_3570_ _3562_/A _3566_/X _3569_/X _3833_/B2 VGND VGND VPWR VPWR _3570_/X sky130_fd_sc_hd__o211a_2
XFILLER_115_604 VGND VGND VPWR VPWR sky130_fd_sc_hd__decap_3
XFILLER_115_626 VGND VGND VPWR VPWR sky130_fd_sc_hd__decap_3
X_2521_ _5176_/Q _5144_/Q _2789_/S VGND VGND VPWR VPWR _2521_/X sky130_fd_sc_hd__mux2_1
XFILLER_114_103 VGND VGND VPWR VPWR sky130_fd_sc_hd__decap_3
XFILLER_115_648 VGND VGND VPWR VPWR sky130_fd_sc_hd__decap_3
X_5240_ _6038_/CLK _5240_/D VGND VGND VPWR VPWR _5240_/Q sky130_fd_sc_hd__dfxtp_2
XFILLER_46_3 VGND VGND VPWR VPWR sky130_fd_sc_hd__decap_3
XPHY_EDGE_ROW_18_Right_18 VGND VGND VPWR VPWR sky130_fd_sc_hd__decap_3
X_5171_ _6037_/CLK _5171_/D VGND VGND VPWR VPWR _5171_/Q sky130_fd_sc_hd__dfxtp_2
Xhold1907 _5410_/Q VGND VGND VPWR VPWR _4344_/B2 sky130_fd_sc_hd__dlygate4sd3_1
Xhold1918 _5451_/Q VGND VGND VPWR VPWR _4388_/B2 sky130_fd_sc_hd__dlygate4sd3_1
X_4122_ _5009_/A1 _4124_/A2 _4124_/B1 _4122_/B2 VGND VGND VPWR VPWR _5203_/D sky130_fd_sc_hd__a22o_2
XFILLER_96_598 VGND VGND VPWR VPWR sky130_fd_sc_hd__fill_1
Xhold1929 _5388_/Q VGND VGND VPWR VPWR _4320_/B2 sky130_fd_sc_hd__dlygate4sd3_1
X_4053_ _5045_/A1 _4053_/A2 _4053_/B1 _4053_/B2 VGND VGND VPWR VPWR _5141_/D sky130_fd_sc_hd__a22o_2
Xinput3 rd[2] VGND VGND VPWR VPWR input3/X sky130_fd_sc_hd__clkdlybuf4s25_1
X_3004_ _3004_/A1 _3002_/X _3003_/X _3004_/B2 VGND VGND VPWR VPWR _3004_/X sky130_fd_sc_hd__o22a_2
XTAP_TAPCELL_ROW_108_1544 VGND VPWR sky130_fd_sc_hd__tapvpwrvgnd_1
XFILLER_24_326 VGND VGND VPWR VPWR sky130_fd_sc_hd__fill_2
XFILLER_37_687 VGND VGND VPWR VPWR sky130_fd_sc_hd__fill_1
XFILLER_24_359 VGND VGND VPWR VPWR sky130_fd_sc_hd__decap_3
XFILLER_36_197 VGND VGND VPWR VPWR sky130_fd_sc_hd__decap_3
XPHY_EDGE_ROW_27_Right_27 VGND VGND VPWR VPWR sky130_fd_sc_hd__decap_3
X_4955_ _4989_/A1 _4979_/A2 _4979_/B1 _4955_/B2 VGND VGND VPWR VPWR _5983_/D sky130_fd_sc_hd__a22o_2
XFILLER_51_167 VGND VGND VPWR VPWR sky130_fd_sc_hd__fill_1
XTAP_TAPCELL_ROW_22_516 VGND VPWR sky130_fd_sc_hd__tapvpwrvgnd_1
X_3906_ _3906_/A _3906_/B VGND VGND VPWR VPWR _3906_/X sky130_fd_sc_hd__or2_2
XTAP_TAPCELL_ROW_50_847 VGND VPWR sky130_fd_sc_hd__tapvpwrvgnd_1
X_4886_ _4886_/A1 _4909_/A2 _4909_/B1 _4886_/B2 VGND VGND VPWR VPWR _5918_/D sky130_fd_sc_hd__a22o_2
X_3837_ _3837_/A _3837_/B VGND VGND VPWR VPWR _3837_/X sky130_fd_sc_hd__or2_2
XPHY_EDGE_ROW_89_Left_205 VGND VGND VPWR VPWR sky130_fd_sc_hd__decap_3
X_3768_ _3916_/A1 _3766_/X _3767_/X _3914_/A VGND VGND VPWR VPWR _3768_/X sky130_fd_sc_hd__o22a_2
X_5507_ _5513_/CLK _5507_/D VGND VGND VPWR VPWR _5507_/Q sky130_fd_sc_hd__dfxtp_2
X_2719_ _2730_/A _2719_/B VGND VGND VPWR VPWR _2719_/X sky130_fd_sc_hd__or2_2
XFILLER_106_648 VGND VGND VPWR VPWR sky130_fd_sc_hd__decap_3
XFILLER_3_219 VGND VGND VPWR VPWR sky130_fd_sc_hd__decap_3
X_3699_ _5420_/Q _5068_/Q _3700_/S VGND VGND VPWR VPWR _3699_/X sky130_fd_sc_hd__mux2_1
XFILLER_105_158 VGND VGND VPWR VPWR sky130_fd_sc_hd__decap_3
XFILLER_105_169 VGND VGND VPWR VPWR sky130_fd_sc_hd__fill_1
XPHY_EDGE_ROW_36_Right_36 VGND VGND VPWR VPWR sky130_fd_sc_hd__decap_3
XTAP_TAPCELL_ROW_72_1109 VGND VPWR sky130_fd_sc_hd__tapvpwrvgnd_1
X_5438_ _6046_/CLK _5438_/D VGND VGND VPWR VPWR _5438_/Q sky130_fd_sc_hd__dfxtp_2
XFILLER_114_681 VGND VGND VPWR VPWR sky130_fd_sc_hd__decap_3
Xfanout1009 _3745_/A1 VGND VGND VPWR VPWR _3433_/A sky130_fd_sc_hd__clkdlybuf4s25_1
X_5369_ _5692_/CLK _5369_/D VGND VGND VPWR VPWR _5369_/Q sky130_fd_sc_hd__dfxtp_2
XFILLER_101_320 VGND VGND VPWR VPWR sky130_fd_sc_hd__decap_3
XFILLER_19_11 VGND VGND VPWR VPWR sky130_fd_sc_hd__decap_3
XFILLER_87_543 VGND VGND VPWR VPWR sky130_fd_sc_hd__decap_3
XFILLER_19_55 VGND VGND VPWR VPWR sky130_fd_sc_hd__fill_1
XFILLER_59_278 VGND VGND VPWR VPWR sky130_fd_sc_hd__fill_2
XPHY_EDGE_ROW_98_Left_214 VGND VGND VPWR VPWR sky130_fd_sc_hd__decap_3
XFILLER_28_621 VGND VGND VPWR VPWR sky130_fd_sc_hd__decap_3
XFILLER_74_215 VGND VGND VPWR VPWR sky130_fd_sc_hd__decap_3
XTAP_TAPCELL_ROW_58_947 VGND VPWR sky130_fd_sc_hd__tapvpwrvgnd_1
XTAP_TAPCELL_ROW_2_274 VGND VPWR sky130_fd_sc_hd__tapvpwrvgnd_1
XFILLER_15_304 VGND VGND VPWR VPWR sky130_fd_sc_hd__fill_2
XFILLER_82_270 VGND VGND VPWR VPWR sky130_fd_sc_hd__fill_2
XPHY_EDGE_ROW_45_Right_45 VGND VGND VPWR VPWR sky130_fd_sc_hd__decap_3
XFILLER_15_337 VGND VGND VPWR VPWR sky130_fd_sc_hd__decap_3
XFILLER_43_657 VGND VGND VPWR VPWR sky130_fd_sc_hd__fill_1
XTAP_TAPCELL_ROW_83_1249 VGND VPWR sky130_fd_sc_hd__tapvpwrvgnd_1
XFILLER_30_318 VGND VGND VPWR VPWR sky130_fd_sc_hd__decap_3
XFILLER_43_679 VGND VGND VPWR VPWR sky130_fd_sc_hd__fill_1
XFILLER_11_532 VGND VGND VPWR VPWR sky130_fd_sc_hd__decap_3
Xwire489 wire489/A VGND VGND VPWR VPWR wire489/X sky130_fd_sc_hd__clkbuf_4
XPHY_EDGE_ROW_54_Right_54 VGND VGND VPWR VPWR sky130_fd_sc_hd__decap_3
XFILLER_112_607 VGND VGND VPWR VPWR sky130_fd_sc_hd__decap_3
XTAP_TAPCELL_ROW_94_1378 VGND VPWR sky130_fd_sc_hd__tapvpwrvgnd_1
XFILLER_32_9 VGND VGND VPWR VPWR sky130_fd_sc_hd__decap_3
Xload_slew428 _4528_/A2 VGND VGND VPWR VPWR _4535_/A2 sky130_fd_sc_hd__clkbuf_4
Xload_slew417 _4591_/A2 VGND VGND VPWR VPWR _4606_/A2 sky130_fd_sc_hd__buf_4
XFILLER_38_418 VGND VGND VPWR VPWR sky130_fd_sc_hd__fill_2
XFILLER_78_587 VGND VGND VPWR VPWR sky130_fd_sc_hd__fill_1
XFILLER_18_120 VGND VGND VPWR VPWR sky130_fd_sc_hd__fill_1
XFILLER_19_676 VGND VGND VPWR VPWR sky130_fd_sc_hd__decap_3
XFILLER_93_557 VGND VGND VPWR VPWR sky130_fd_sc_hd__decap_3
XPHY_EDGE_ROW_63_Right_63 VGND VGND VPWR VPWR sky130_fd_sc_hd__decap_3
XFILLER_18_197 VGND VGND VPWR VPWR sky130_fd_sc_hd__fill_1
XFILLER_61_432 VGND VGND VPWR VPWR sky130_fd_sc_hd__decap_3
XFILLER_73_281 VGND VGND VPWR VPWR sky130_fd_sc_hd__fill_1
XFILLER_33_167 VGND VGND VPWR VPWR sky130_fd_sc_hd__fill_1
XFILLER_61_465 VGND VGND VPWR VPWR sky130_fd_sc_hd__decap_3
XTAP_TAPCELL_ROW_103_1485 VGND VPWR sky130_fd_sc_hd__tapvpwrvgnd_1
X_4740_ _4908_/A1 _4742_/A2 _4740_/B1 _4740_/B2 VGND VGND VPWR VPWR _5780_/D sky130_fd_sc_hd__a22o_2
X_4671_ _4908_/A1 _4673_/A2 _4673_/B1 _4671_/B2 VGND VGND VPWR VPWR _5716_/D sky130_fd_sc_hd__a22o_2
X_3622_ _5193_/Q _5161_/Q _3622_/S VGND VGND VPWR VPWR _3622_/X sky130_fd_sc_hd__mux2_1
XPHY_EDGE_ROW_72_Right_72 VGND VGND VPWR VPWR sky130_fd_sc_hd__decap_3
X_3553_ _5574_/Q _5542_/Q _3558_/S VGND VGND VPWR VPWR _3553_/X sky130_fd_sc_hd__mux2_1
X_3484_ _3614_/A _3484_/B _3484_/C VGND VGND VPWR VPWR _3484_/X sky130_fd_sc_hd__and3_2
X_2504_ _5496_/Q _5464_/Q _2510_/S VGND VGND VPWR VPWR _2504_/X sky130_fd_sc_hd__mux2_1
XFILLER_102_117 VGND VGND VPWR VPWR sky130_fd_sc_hd__decap_3
XFILLER_103_629 VGND VGND VPWR VPWR sky130_fd_sc_hd__decap_3
X_5223_ _5258_/CLK _5223_/D VGND VGND VPWR VPWR _5223_/Q sky130_fd_sc_hd__dfxtp_2
X_5154_ _5799_/CLK _5154_/D VGND VGND VPWR VPWR _5154_/Q sky130_fd_sc_hd__dfxtp_2
XFILLER_111_662 VGND VGND VPWR VPWR sky130_fd_sc_hd__decap_3
XFILLER_111_673 VGND VGND VPWR VPWR sky130_fd_sc_hd__decap_3
Xhold1704 _5958_/Q VGND VGND VPWR VPWR _4928_/B2 sky130_fd_sc_hd__dlygate4sd3_1
Xhold1715 _6007_/Q VGND VGND VPWR VPWR _4979_/B2 sky130_fd_sc_hd__dlygate4sd3_1
Xhold1726 _5293_/Q VGND VGND VPWR VPWR _4219_/B2 sky130_fd_sc_hd__dlygate4sd3_1
X_4105_ _4653_/A1 wire516/X wire298/X _4105_/B2 VGND VGND VPWR VPWR _5186_/D sky130_fd_sc_hd__a22o_2
XFILLER_96_384 VGND VGND VPWR VPWR sky130_fd_sc_hd__fill_2
XPHY_EDGE_ROW_81_Right_81 VGND VGND VPWR VPWR sky130_fd_sc_hd__decap_3
Xhold1737 _6002_/Q VGND VGND VPWR VPWR _4974_/B2 sky130_fd_sc_hd__dlygate4sd3_1
Xhold1748 _5546_/Q VGND VGND VPWR VPWR _4490_/B2 sky130_fd_sc_hd__dlygate4sd3_1
Xhold1759 _5663_/Q VGND VGND VPWR VPWR _4616_/B2 sky130_fd_sc_hd__dlygate4sd3_1
Xload_slew995 _3948_/B VGND VGND VPWR VPWR _4981_/A sky130_fd_sc_hd__buf_2
X_5085_ _6013_/CLK _5085_/D VGND VGND VPWR VPWR _5085_/Q sky130_fd_sc_hd__dfxtp_2
XTAP_TAPCELL_ROW_55_906 VGND VPWR sky130_fd_sc_hd__tapvpwrvgnd_1
X_4036_ _4312_/A1 _4052_/A2 _4052_/B1 _4036_/B2 VGND VGND VPWR VPWR _5124_/D sky130_fd_sc_hd__a22o_2
XFILLER_112_59 VGND VGND VPWR VPWR sky130_fd_sc_hd__decap_3
XFILLER_52_432 VGND VGND VPWR VPWR sky130_fd_sc_hd__decap_3
XTAP_TAPCELL_ROW_69_1082 VGND VPWR sky130_fd_sc_hd__tapvpwrvgnd_1
XFILLER_25_679 VGND VGND VPWR VPWR sky130_fd_sc_hd__decap_3
XTAP_TAPCELL_ROW_35_674 VGND VPWR sky130_fd_sc_hd__tapvpwrvgnd_1
X_5987_ _6019_/CLK _5987_/D VGND VGND VPWR VPWR _5987_/Q sky130_fd_sc_hd__dfxtp_2
XFILLER_40_638 VGND VGND VPWR VPWR sky130_fd_sc_hd__decap_3
X_4938_ _5040_/A1 _4913_/B wire136/X _4938_/B2 VGND VGND VPWR VPWR _5968_/D sky130_fd_sc_hd__a22o_2
XANTENNA_30 wire1038/A VGND VGND VPWR VPWR sky130_fd_sc_hd__diode_2
XANTENNA_41 _5015_/Y VGND VGND VPWR VPWR sky130_fd_sc_hd__diode_2
X_4869_ _4903_/A1 _4876_/A2 _4874_/B1 _4869_/B2 VGND VGND VPWR VPWR _5903_/D sky130_fd_sc_hd__a22o_2
XPHY_EDGE_ROW_90_Right_90 VGND VGND VPWR VPWR sky130_fd_sc_hd__decap_3
XFILLER_115_6 VGND VGND VPWR VPWR sky130_fd_sc_hd__decap_3
XFILLER_106_445 VGND VGND VPWR VPWR sky130_fd_sc_hd__decap_3
XTAP_TAPCELL_ROW_7_333 VGND VPWR sky130_fd_sc_hd__tapvpwrvgnd_1
XFILLER_87_351 VGND VGND VPWR VPWR sky130_fd_sc_hd__decap_3
XFILLER_101_183 VGND VGND VPWR VPWR sky130_fd_sc_hd__decap_3
XFILLER_28_440 VGND VGND VPWR VPWR sky130_fd_sc_hd__fill_1
XFILLER_46_53 VGND VGND VPWR VPWR sky130_fd_sc_hd__decap_3
XFILLER_55_281 VGND VGND VPWR VPWR sky130_fd_sc_hd__fill_1
XFILLER_62_63 VGND VGND VPWR VPWR sky130_fd_sc_hd__fill_2
XFILLER_11_340 VGND VGND VPWR VPWR sky130_fd_sc_hd__fill_1
XFILLER_62_85 VGND VGND VPWR VPWR sky130_fd_sc_hd__decap_3
XFILLER_11_373 VGND VGND VPWR VPWR sky130_fd_sc_hd__fill_2
XFILLER_7_36 VGND VGND VPWR VPWR sky130_fd_sc_hd__decap_3
XTAP_TAPCELL_ROW_96_1407 VGND VPWR sky130_fd_sc_hd__tapvpwrvgnd_1
Xwire242 wire242/A VGND VGND VPWR VPWR wire242/X sky130_fd_sc_hd__clkbuf_4
XFILLER_7_399 VGND VGND VPWR VPWR sky130_fd_sc_hd__decap_3
XFILLER_3_572 VGND VGND VPWR VPWR sky130_fd_sc_hd__decap_3
XFILLER_98_627 VGND VGND VPWR VPWR sky130_fd_sc_hd__decap_3
Xload_slew203 _4557_/B1 VGND VGND VPWR VPWR _4572_/B1 sky130_fd_sc_hd__buf_4
XFILLER_30_6 VGND VGND VPWR VPWR sky130_fd_sc_hd__fill_1
XFILLER_87_60 VGND VGND VPWR VPWR sky130_fd_sc_hd__decap_3
Xload_slew225 fanout224/X VGND VGND VPWR VPWR _4469_/B1 sky130_fd_sc_hd__buf_2
XFILLER_66_524 VGND VGND VPWR VPWR sky130_fd_sc_hd__decap_3
XFILLER_81_505 VGND VGND VPWR VPWR sky130_fd_sc_hd__decap_3
XFILLER_93_332 VGND VGND VPWR VPWR sky130_fd_sc_hd__decap_3
XFILLER_93_354 VGND VGND VPWR VPWR sky130_fd_sc_hd__decap_3
XTAP_TAPCELL_ROW_105_1514 VGND VPWR sky130_fd_sc_hd__tapvpwrvgnd_1
X_5910_ _6070_/CLK _5910_/D VGND VGND VPWR VPWR _5910_/Q sky130_fd_sc_hd__dfxtp_2
XFILLER_34_465 VGND VGND VPWR VPWR sky130_fd_sc_hd__decap_3
XFILLER_61_251 VGND VGND VPWR VPWR sky130_fd_sc_hd__decap_3
X_5841_ _6065_/CLK _5841_/D VGND VGND VPWR VPWR _5841_/Q sky130_fd_sc_hd__dfxtp_2
XFILLER_61_284 VGND VGND VPWR VPWR sky130_fd_sc_hd__fill_2
XTAP_TAPCELL_ROW_32_633 VGND VPWR sky130_fd_sc_hd__tapvpwrvgnd_1
X_5772_ _5932_/CLK _5772_/D VGND VGND VPWR VPWR _5772_/Q sky130_fd_sc_hd__dfxtp_2
X_2984_ _3230_/B2 _2967_/X _2983_/X _3223_/C1 VGND VGND VPWR VPWR _2984_/X sky130_fd_sc_hd__a22o_2
XTAP_TAPCELL_ROW_60_964 VGND VPWR sky130_fd_sc_hd__tapvpwrvgnd_1
XTAP_TAPCELL_ROW_60_975 VGND VPWR sky130_fd_sc_hd__tapvpwrvgnd_1
X_4723_ _4891_/A1 wire386/A wire166/X _4723_/B2 VGND VGND VPWR VPWR _5763_/D sky130_fd_sc_hd__a22o_2
XTAP_TAPCELL_ROW_12_390 VGND VPWR sky130_fd_sc_hd__tapvpwrvgnd_1
X_4654_ _4891_/A1 wire400/X wire179/X _4654_/B2 VGND VGND VPWR VPWR _5699_/D sky130_fd_sc_hd__a22o_2
X_4585_ _4992_/A1 _4606_/A2 _4606_/B1 _4585_/B2 VGND VGND VPWR VPWR _5634_/D sky130_fd_sc_hd__a22o_2
X_3605_ _5512_/Q _5480_/Q _3880_/S VGND VGND VPWR VPWR _3605_/X sky130_fd_sc_hd__mux2_1
X_3536_ _5413_/Q _5061_/Q _3810_/S VGND VGND VPWR VPWR _3536_/X sky130_fd_sc_hd__mux2_1
XFILLER_107_15 VGND VGND VPWR VPWR sky130_fd_sc_hd__decap_3
XFILLER_107_48 VGND VGND VPWR VPWR sky130_fd_sc_hd__decap_3
XFILLER_115_253 VGND VGND VPWR VPWR sky130_fd_sc_hd__decap_3
X_5206_ _6038_/CLK _5206_/D VGND VGND VPWR VPWR _5206_/Q sky130_fd_sc_hd__dfxtp_2
X_3467_ _3465_/X _3466_/X _3470_/S VGND VGND VPWR VPWR _3467_/X sky130_fd_sc_hd__mux2_1
XTAP_TAPCELL_ROW_4_303 VGND VPWR sky130_fd_sc_hd__tapvpwrvgnd_1
Xhold1501 _5565_/Q VGND VGND VPWR VPWR _4511_/B2 sky130_fd_sc_hd__dlygate4sd3_1
X_3398_ _5567_/Q _5535_/Q _3398_/S VGND VGND VPWR VPWR _3398_/X sky130_fd_sc_hd__mux2_1
Xhold1512 _5815_/Q VGND VGND VPWR VPWR _4777_/B2 sky130_fd_sc_hd__dlygate4sd3_1
Xhold1523 _5525_/Q VGND VGND VPWR VPWR _4467_/B2 sky130_fd_sc_hd__dlygate4sd3_1
Xhold1534 _5472_/Q VGND VGND VPWR VPWR _4412_/B2 sky130_fd_sc_hd__dlygate4sd3_1
Xload_slew792 _2777_/S VGND VGND VPWR VPWR _2760_/S sky130_fd_sc_hd__clkbuf_2
X_5137_ _5866_/CLK _5137_/D VGND VGND VPWR VPWR _5137_/Q sky130_fd_sc_hd__dfxtp_2
XFILLER_84_354 VGND VGND VPWR VPWR sky130_fd_sc_hd__fill_2
Xhold1545 _6000_/Q VGND VGND VPWR VPWR _4972_/B2 sky130_fd_sc_hd__dlygate4sd3_1
Xhold1556 _5275_/Q VGND VGND VPWR VPWR _4201_/B2 sky130_fd_sc_hd__dlygate4sd3_1
Xhold1567 _5995_/Q VGND VGND VPWR VPWR _4967_/B2 sky130_fd_sc_hd__dlygate4sd3_1
X_5068_ _5804_/CLK _5068_/D VGND VGND VPWR VPWR _5068_/Q sky130_fd_sc_hd__dfxtp_2
Xhold1578 _6033_/Q VGND VGND VPWR VPWR _5007_/B2 sky130_fd_sc_hd__dlygate4sd3_1
Xhold1589 _5700_/Q VGND VGND VPWR VPWR _4655_/B2 sky130_fd_sc_hd__dlygate4sd3_1
X_4019_ _5012_/A1 wire540/A _4019_/B1 _4019_/B2 VGND VGND VPWR VPWR _5110_/D sky130_fd_sc_hd__a22o_2
XFILLER_16_12 VGND VGND VPWR VPWR sky130_fd_sc_hd__decap_3
XFILLER_25_421 VGND VGND VPWR VPWR sky130_fd_sc_hd__decap_3
XFILLER_37_270 VGND VGND VPWR VPWR sky130_fd_sc_hd__decap_3
XFILLER_37_281 VGND VGND VPWR VPWR sky130_fd_sc_hd__decap_3
XFILLER_16_45 VGND VGND VPWR VPWR sky130_fd_sc_hd__decap_3
XFILLER_40_402 VGND VGND VPWR VPWR sky130_fd_sc_hd__decap_3
XPHY_EDGE_ROW_0_Right_0 VGND VGND VPWR VPWR sky130_fd_sc_hd__decap_3
XTAP_TAPCELL_ROW_80_1208 VGND VPWR sky130_fd_sc_hd__tapvpwrvgnd_1
XFILLER_25_498 VGND VGND VPWR VPWR sky130_fd_sc_hd__decap_3
XFILLER_80_582 VGND VGND VPWR VPWR sky130_fd_sc_hd__decap_3
XFILLER_21_682 VGND VGND VPWR VPWR sky130_fd_sc_hd__decap_3
XFILLER_4_347 VGND VGND VPWR VPWR sky130_fd_sc_hd__decap_3
XFILLER_106_275 VGND VGND VPWR VPWR sky130_fd_sc_hd__decap_3
XTAP_TAPCELL_ROW_91_1337 VGND VPWR sky130_fd_sc_hd__tapvpwrvgnd_1
XFILLER_0_531 VGND VGND VPWR VPWR sky130_fd_sc_hd__fill_1
XFILLER_79_137 VGND VGND VPWR VPWR sky130_fd_sc_hd__decap_3
XFILLER_0_564 VGND VGND VPWR VPWR sky130_fd_sc_hd__decap_3
XFILLER_16_421 VGND VGND VPWR VPWR sky130_fd_sc_hd__decap_3
XFILLER_63_549 VGND VGND VPWR VPWR sky130_fd_sc_hd__fill_2
XFILLER_31_402 VGND VGND VPWR VPWR sky130_fd_sc_hd__decap_3
XFILLER_31_424 VGND VGND VPWR VPWR sky130_fd_sc_hd__decap_3
XFILLER_71_593 VGND VGND VPWR VPWR sky130_fd_sc_hd__decap_3
XFILLER_73_84 VGND VGND VPWR VPWR sky130_fd_sc_hd__fill_2
XFILLER_73_95 VGND VGND VPWR VPWR sky130_fd_sc_hd__fill_1
XFILLER_31_468 VGND VGND VPWR VPWR sky130_fd_sc_hd__fill_2
XTAP_TAPCELL_ROW_100_1444 VGND VPWR sky130_fd_sc_hd__tapvpwrvgnd_1
XTAP_TAPCELL_ROW_100_1455 VGND VPWR sky130_fd_sc_hd__tapvpwrvgnd_1
XFILLER_8_686 VGND VGND VPWR VPWR sky130_fd_sc_hd__fill_2
X_4370_ _5017_/A1 _4396_/A2 _4396_/B1 _4370_/B2 VGND VGND VPWR VPWR _5433_/D sky130_fd_sc_hd__a22o_2
X_3321_ _5915_/Q _5883_/Q _5851_/Q _5755_/Q _3300_/S _3566_/S1 VGND VGND VPWR VPWR
+ _3321_/X sky130_fd_sc_hd__mux4_2
XFILLER_98_435 VGND VGND VPWR VPWR sky130_fd_sc_hd__decap_3
XFILLER_98_81 VGND VGND VPWR VPWR sky130_fd_sc_hd__decap_3
XFILLER_112_256 VGND VGND VPWR VPWR sky130_fd_sc_hd__fill_1
XFILLER_39_502 VGND VGND VPWR VPWR sky130_fd_sc_hd__fill_2
XFILLER_3_391 VGND VGND VPWR VPWR sky130_fd_sc_hd__fill_1
XFILLER_85_107 VGND VGND VPWR VPWR sky130_fd_sc_hd__decap_3
X_6040_ _6040_/CLK _6040_/D VGND VGND VPWR VPWR _6040_/Q sky130_fd_sc_hd__dfxtp_2
X_3252_ _5784_/Q _5720_/Q _3863_/S VGND VGND VPWR VPWR _3252_/X sky130_fd_sc_hd__mux2_1
XFILLER_79_671 VGND VGND VPWR VPWR sky130_fd_sc_hd__fill_1
XTAP_TAPCELL_ROW_111_1584 VGND VPWR sky130_fd_sc_hd__tapvpwrvgnd_1
X_3183_ _3183_/A1 _3180_/X _3182_/X _2558_/A VGND VGND VPWR VPWR _3183_/X sky130_fd_sc_hd__a22o_2
XFILLER_93_140 VGND VGND VPWR VPWR sky130_fd_sc_hd__decap_3
XFILLER_93_162 VGND VGND VPWR VPWR sky130_fd_sc_hd__decap_3
XFILLER_19_281 VGND VGND VPWR VPWR sky130_fd_sc_hd__decap_3
XFILLER_81_324 VGND VGND VPWR VPWR sky130_fd_sc_hd__decap_3
XPHY_EDGE_ROW_53_Left_169 VGND VGND VPWR VPWR sky130_fd_sc_hd__decap_3
XTAP_TAPCELL_ROW_66_1041 VGND VPWR sky130_fd_sc_hd__tapvpwrvgnd_1
XTAP_TAPCELL_ROW_45_791 VGND VPWR sky130_fd_sc_hd__tapvpwrvgnd_1
X_5824_ _5824_/CLK _5824_/D VGND VGND VPWR VPWR _5824_/Q sky130_fd_sc_hd__dfxtp_2
XFILLER_22_446 VGND VGND VPWR VPWR sky130_fd_sc_hd__decap_3
X_5755_ _6042_/CLK _5755_/D VGND VGND VPWR VPWR _5755_/Q sky130_fd_sc_hd__dfxtp_2
X_2967_ _3228_/B2 _2964_/X _2966_/X VGND VGND VPWR VPWR _2967_/X sky130_fd_sc_hd__a21o_2
X_5686_ _6070_/CLK _5686_/D VGND VGND VPWR VPWR _5686_/Q sky130_fd_sc_hd__dfxtp_2
X_4706_ _4775_/A1 _4706_/A2 _4706_/B1 _4706_/B2 VGND VGND VPWR VPWR _5749_/D sky130_fd_sc_hd__a22o_2
X_2898_ _3131_/A _2895_/X _2897_/X _3134_/A1 VGND VGND VPWR VPWR _2898_/X sky130_fd_sc_hd__o22a_2
XPHY_EDGE_ROW_62_Left_178 VGND VGND VPWR VPWR sky130_fd_sc_hd__decap_3
X_4637_ _4908_/A1 _4639_/A2 _4639_/B1 _4637_/B2 VGND VGND VPWR VPWR _5684_/D sky130_fd_sc_hd__a22o_2
XFILLER_78_29 VGND VGND VPWR VPWR sky130_fd_sc_hd__decap_3
XTAP_TAPCELL_ROW_77_1170 VGND VPWR sky130_fd_sc_hd__tapvpwrvgnd_1
X_4568_ _4773_/A1 wire421/X _4570_/B1 _4568_/B2 VGND VGND VPWR VPWR _5619_/D sky130_fd_sc_hd__a22o_2
XFILLER_103_223 VGND VGND VPWR VPWR sky130_fd_sc_hd__fill_1
XFILLER_103_234 VGND VGND VPWR VPWR sky130_fd_sc_hd__decap_3
X_4499_ _4533_/A1 _4501_/A2 _4501_/B1 _4499_/B2 VGND VGND VPWR VPWR _5555_/D sky130_fd_sc_hd__a22o_2
X_3519_ _5828_/Q _5444_/Q _6052_/Q _5956_/Q _3858_/S _3868_/S1 VGND VGND VPWR VPWR
+ _3520_/B sky130_fd_sc_hd__mux4_2
Xhold2010 _5164_/Q VGND VGND VPWR VPWR _4080_/B2 sky130_fd_sc_hd__dlygate4sd3_1
Xhold2021 _5237_/Q VGND VGND VPWR VPWR _4158_/B2 sky130_fd_sc_hd__dlygate4sd3_1
XFILLER_94_17 VGND VGND VPWR VPWR sky130_fd_sc_hd__decap_3
Xhold2032 _5083_/Q VGND VGND VPWR VPWR _3992_/B2 sky130_fd_sc_hd__dlygate4sd3_1
Xhold2043 _5284_/Q VGND VGND VPWR VPWR _4210_/B2 sky130_fd_sc_hd__dlygate4sd3_1
Xhold2054 _5125_/Q VGND VGND VPWR VPWR _4037_/B2 sky130_fd_sc_hd__dlygate4sd3_1
XPHY_EDGE_ROW_71_Left_187 VGND VGND VPWR VPWR sky130_fd_sc_hd__decap_3
Xhold1320 _5329_/Q VGND VGND VPWR VPWR _4257_/B2 sky130_fd_sc_hd__dlygate4sd3_1
Xhold1331 _5705_/Q VGND VGND VPWR VPWR _4660_/B2 sky130_fd_sc_hd__dlygate4sd3_1
Xhold1342 _6062_/Q VGND VGND VPWR VPWR _5038_/B2 sky130_fd_sc_hd__dlygate4sd3_1
Xhold2065 _5392_/Q VGND VGND VPWR VPWR _4324_/B2 sky130_fd_sc_hd__dlygate4sd3_1
Xhold2076 _5950_/Q VGND VGND VPWR VPWR _4920_/B2 sky130_fd_sc_hd__dlygate4sd3_1
Xhold2087 _5072_/Q VGND VGND VPWR VPWR _3976_/B2 sky130_fd_sc_hd__dlygate4sd3_1
Xclkbuf_leaf_96_clk clkload0/A VGND VGND VPWR VPWR _6069_/CLK sky130_fd_sc_hd__clkbuf_8
XFILLER_45_516 VGND VGND VPWR VPWR sky130_fd_sc_hd__fill_1
Xhold1353 _5782_/Q VGND VGND VPWR VPWR _4742_/B2 sky130_fd_sc_hd__dlygate4sd3_1
Xhold1364 _5260_/Q VGND VGND VPWR VPWR _4183_/B2 sky130_fd_sc_hd__dlygate4sd3_1
Xhold1375 _5365_/Q VGND VGND VPWR VPWR _4295_/B2 sky130_fd_sc_hd__dlygate4sd3_1
Xhold1386 _5881_/Q VGND VGND VPWR VPWR _4847_/B2 sky130_fd_sc_hd__dlygate4sd3_1
Xhold2098 _5221_/Q VGND VGND VPWR VPWR _4142_/B2 sky130_fd_sc_hd__dlygate4sd3_1
XFILLER_27_55 VGND VGND VPWR VPWR sky130_fd_sc_hd__fill_1
XFILLER_27_66 VGND VGND VPWR VPWR sky130_fd_sc_hd__decap_3
XFILLER_45_538 VGND VGND VPWR VPWR sky130_fd_sc_hd__decap_3
XFILLER_84_195 VGND VGND VPWR VPWR sky130_fd_sc_hd__fill_1
Xhold1397 _5864_/Q VGND VGND VPWR VPWR _4828_/B2 sky130_fd_sc_hd__dlygate4sd3_1
XFILLER_60_519 VGND VGND VPWR VPWR sky130_fd_sc_hd__decap_3
XFILLER_53_571 VGND VGND VPWR VPWR sky130_fd_sc_hd__fill_2
XFILLER_53_593 VGND VGND VPWR VPWR sky130_fd_sc_hd__fill_2
XFILLER_13_457 VGND VGND VPWR VPWR sky130_fd_sc_hd__decap_3
XFILLER_9_417 VGND VGND VPWR VPWR sky130_fd_sc_hd__decap_3
XPHY_EDGE_ROW_80_Left_196 VGND VGND VPWR VPWR sky130_fd_sc_hd__decap_3
Xclkbuf_leaf_20_clk clkbuf_4_8_0_clk/X VGND VGND VPWR VPWR _6064_/CLK sky130_fd_sc_hd__clkbuf_8
XFILLER_5_623 VGND VGND VPWR VPWR sky130_fd_sc_hd__decap_3
XFILLER_5_656 VGND VGND VPWR VPWR sky130_fd_sc_hd__decap_3
XFILLER_4_144 VGND VGND VPWR VPWR sky130_fd_sc_hd__decap_3
XFILLER_4_15 VGND VGND VPWR VPWR sky130_fd_sc_hd__decap_3
XFILLER_108_80 VGND VGND VPWR VPWR sky130_fd_sc_hd__decap_3
XFILLER_4_59 VGND VGND VPWR VPWR sky130_fd_sc_hd__decap_3
XFILLER_108_91 VGND VGND VPWR VPWR sky130_fd_sc_hd__decap_3
XFILLER_0_350 VGND VGND VPWR VPWR sky130_fd_sc_hd__decap_3
XFILLER_68_95 VGND VGND VPWR VPWR sky130_fd_sc_hd__decap_3
XFILLER_95_449 VGND VGND VPWR VPWR sky130_fd_sc_hd__decap_3
Xclkbuf_leaf_87_clk clkbuf_4_6_0_clk/X VGND VGND VPWR VPWR _5658_/CLK sky130_fd_sc_hd__clkbuf_8
XFILLER_29_590 VGND VGND VPWR VPWR sky130_fd_sc_hd__decap_3
XFILLER_63_346 VGND VGND VPWR VPWR sky130_fd_sc_hd__fill_2
XFILLER_91_633 VGND VGND VPWR VPWR sky130_fd_sc_hd__decap_3
XFILLER_51_519 VGND VGND VPWR VPWR sky130_fd_sc_hd__decap_3
X_3870_ _5140_/Q _5108_/Q _6036_/Q _6004_/Q _3858_/S _3870_/S1 VGND VGND VPWR VPWR
+ _3870_/X sky130_fd_sc_hd__mux4_2
XFILLER_31_265 VGND VGND VPWR VPWR sky130_fd_sc_hd__decap_3
XTAP_TAPCELL_ROW_42_750 VGND VPWR sky130_fd_sc_hd__tapvpwrvgnd_1
X_2821_ _5573_/Q _5541_/Q _2856_/S VGND VGND VPWR VPWR _2821_/X sky130_fd_sc_hd__mux2_1
Xclkbuf_leaf_11_clk clkload1/A VGND VGND VPWR VPWR _6030_/CLK sky130_fd_sc_hd__clkbuf_8
X_5540_ _5572_/CLK _5540_/D VGND VGND VPWR VPWR _5540_/Q sky130_fd_sc_hd__dfxtp_2
X_2752_ _5378_/Q _5346_/Q _5314_/Q _5282_/Q _3221_/S _2503_/B VGND VGND VPWR VPWR
+ _2752_/X sky130_fd_sc_hd__mux4_2
X_5471_ _6060_/CLK _5471_/D VGND VGND VPWR VPWR _5471_/Q sky130_fd_sc_hd__dfxtp_2
X_4422_ _4830_/A1 _4435_/A2 _4435_/B1 _4422_/B2 VGND VGND VPWR VPWR _5482_/D sky130_fd_sc_hd__a22o_2
X_2683_ _5567_/Q _5535_/Q _3093_/S VGND VGND VPWR VPWR _2683_/X sky130_fd_sc_hd__mux2_1
XTAP_TAPCELL_ROW_113_1602 VGND VPWR sky130_fd_sc_hd__tapvpwrvgnd_1
X_4353_ _5035_/A1 _4364_/A2 _4364_/B1 _4353_/B2 VGND VGND VPWR VPWR _5419_/D sky130_fd_sc_hd__a22o_2
Xfanout429 _4504_/Y VGND VGND VPWR VPWR _4532_/A2 sky130_fd_sc_hd__clkdlybuf4s25_1
Xfanout418 _4573_/Y VGND VGND VPWR VPWR _4574_/B sky130_fd_sc_hd__clkdlybuf4s25_1
X_4284_ _4830_/A1 _4297_/A2 _4284_/B1 _4284_/B2 VGND VGND VPWR VPWR _5354_/D sky130_fd_sc_hd__a22o_2
X_3304_ _5690_/Q _5658_/Q _5626_/Q _5594_/Q _3318_/S _3304_/S1 VGND VGND VPWR VPWR
+ _3305_/B sky130_fd_sc_hd__mux4_2
XFILLER_113_587 VGND VGND VPWR VPWR sky130_fd_sc_hd__decap_3
XFILLER_98_276 VGND VGND VPWR VPWR sky130_fd_sc_hd__decap_3
X_6023_ _6023_/CLK _6023_/D VGND VGND VPWR VPWR _6023_/Q sky130_fd_sc_hd__dfxtp_2
X_3235_ _3926_/S _3235_/B wire630/A VGND VGND VPWR VPWR _3235_/X sky130_fd_sc_hd__or3b_4
XFILLER_104_27 VGND VGND VPWR VPWR sky130_fd_sc_hd__fill_1
Xclkbuf_leaf_78_clk clkload2/A VGND VGND VPWR VPWR _6066_/CLK sky130_fd_sc_hd__clkbuf_8
XFILLER_27_505 VGND VGND VPWR VPWR sky130_fd_sc_hd__decap_3
X_3166_ _5589_/Q _5557_/Q _3166_/S VGND VGND VPWR VPWR _3166_/X sky130_fd_sc_hd__mux2_1
XFILLER_27_549 VGND VGND VPWR VPWR sky130_fd_sc_hd__decap_3
XFILLER_54_335 VGND VGND VPWR VPWR sky130_fd_sc_hd__fill_2
XFILLER_66_195 VGND VGND VPWR VPWR sky130_fd_sc_hd__fill_1
X_3097_ _5938_/Q _5906_/Q _5874_/Q _5778_/Q _2593_/S _3102_/S1 VGND VGND VPWR VPWR
+ _3097_/X sky130_fd_sc_hd__mux4_2
XFILLER_50_530 VGND VGND VPWR VPWR sky130_fd_sc_hd__fill_2
X_5807_ _5871_/CLK _5807_/D VGND VGND VPWR VPWR _5807_/Q sky130_fd_sc_hd__dfxtp_2
X_3999_ _4653_/A1 wire540/X _4020_/B1 _3999_/B2 VGND VGND VPWR VPWR _5090_/D sky130_fd_sc_hd__a22o_2
XFILLER_10_427 VGND VGND VPWR VPWR sky130_fd_sc_hd__fill_1
X_5738_ _5802_/CLK _5738_/D VGND VGND VPWR VPWR _5738_/Q sky130_fd_sc_hd__dfxtp_2
XTAP_TAPCELL_ROW_20_488 VGND VPWR sky130_fd_sc_hd__tapvpwrvgnd_1
X_5669_ _5925_/CLK _5669_/D VGND VGND VPWR VPWR _5669_/Q sky130_fd_sc_hd__dfxtp_2
XFILLER_2_604 VGND VGND VPWR VPWR sky130_fd_sc_hd__decap_3
XFILLER_2_637 VGND VGND VPWR VPWR sky130_fd_sc_hd__decap_3
XFILLER_2_648 VGND VGND VPWR VPWR sky130_fd_sc_hd__decap_3
XFILLER_8_6 VGND VGND VPWR VPWR sky130_fd_sc_hd__decap_3
Xmax_cap191 _4608_/Y VGND VGND VPWR VPWR fanout190/A sky130_fd_sc_hd__clkbuf_2
XFILLER_89_298 VGND VGND VPWR VPWR sky130_fd_sc_hd__fill_1
Xfanout952 input27/X VGND VGND VPWR VPWR _5001_/A1 sky130_fd_sc_hd__clkdlybuf4s25_1
Xfanout941 input29/X VGND VGND VPWR VPWR _4526_/A1 sky130_fd_sc_hd__clkdlybuf4s25_1
Xfanout930 _5039_/A1 VGND VGND VPWR VPWR _4529_/A1 sky130_fd_sc_hd__clkdlybuf4s25_1
XFILLER_77_449 VGND VGND VPWR VPWR sky130_fd_sc_hd__decap_3
Xfanout974 _5029_/A1 VGND VGND VPWR VPWR _4927_/A1 sky130_fd_sc_hd__clkdlybuf4s25_1
Xfanout985 _4992_/A1 VGND VGND VPWR VPWR _4653_/A1 sky130_fd_sc_hd__clkdlybuf4s25_1
Xfanout963 input24/X VGND VGND VPWR VPWR _4762_/A1 sky130_fd_sc_hd__clkdlybuf4s25_1
Xclkbuf_leaf_69_clk clkload3/A VGND VGND VPWR VPWR _5986_/CLK sky130_fd_sc_hd__clkbuf_8
XFILLER_57_151 VGND VGND VPWR VPWR sky130_fd_sc_hd__decap_3
XFILLER_85_460 VGND VGND VPWR VPWR sky130_fd_sc_hd__decap_3
Xfanout996 _5015_/A VGND VGND VPWR VPWR _4437_/A sky130_fd_sc_hd__clkdlybuf4s25_1
Xhold1150 _5857_/Q VGND VGND VPWR VPWR _4821_/B2 sky130_fd_sc_hd__dlygate4sd3_1
XFILLER_57_195 VGND VGND VPWR VPWR sky130_fd_sc_hd__decap_3
XFILLER_72_121 VGND VGND VPWR VPWR sky130_fd_sc_hd__decap_3
Xhold1161 _5568_/Q VGND VGND VPWR VPWR _4514_/B2 sky130_fd_sc_hd__dlygate4sd3_1
Xhold1172 _5771_/Q VGND VGND VPWR VPWR _4731_/B2 sky130_fd_sc_hd__dlygate4sd3_1
Xhold1183 _5649_/Q VGND VGND VPWR VPWR _4600_/B2 sky130_fd_sc_hd__dlygate4sd3_1
Xhold1194 _5429_/Q VGND VGND VPWR VPWR _4363_/B2 sky130_fd_sc_hd__dlygate4sd3_1
XFILLER_33_508 VGND VGND VPWR VPWR sky130_fd_sc_hd__decap_3
XFILLER_45_379 VGND VGND VPWR VPWR sky130_fd_sc_hd__fill_2
XFILLER_72_132 VGND VGND VPWR VPWR sky130_fd_sc_hd__decap_3
XFILLER_26_582 VGND VGND VPWR VPWR sky130_fd_sc_hd__decap_3
XFILLER_72_165 VGND VGND VPWR VPWR sky130_fd_sc_hd__fill_1
XTAP_TAPCELL_ROW_28_588 VGND VPWR sky130_fd_sc_hd__tapvpwrvgnd_1
XPHY_EDGE_ROW_109_Left_225 VGND VGND VPWR VPWR sky130_fd_sc_hd__decap_3
XFILLER_13_254 VGND VGND VPWR VPWR sky130_fd_sc_hd__fill_1
XFILLER_41_596 VGND VGND VPWR VPWR sky130_fd_sc_hd__decap_3
XFILLER_9_236 VGND VGND VPWR VPWR sky130_fd_sc_hd__fill_2
XFILLER_70_85 VGND VGND VPWR VPWR sky130_fd_sc_hd__decap_3
Xclkload17 _5589_/CLK VGND VGND VPWR VPWR clkload17/X sky130_fd_sc_hd__clkbuf_8
Xclkload39 _6033_/CLK VGND VGND VPWR VPWR clkload39/X sky130_fd_sc_hd__clkbuf_4
Xclkload28 _6036_/CLK VGND VGND VPWR VPWR clkload28/X sky130_fd_sc_hd__clkbuf_4
XFILLER_68_438 VGND VGND VPWR VPWR sky130_fd_sc_hd__decap_3
XFILLER_110_568 VGND VGND VPWR VPWR sky130_fd_sc_hd__decap_3
XFILLER_64_611 VGND VGND VPWR VPWR sky130_fd_sc_hd__decap_3
XFILLER_95_60 VGND VGND VPWR VPWR sky130_fd_sc_hd__fill_2
Xclkbuf_leaf_0_clk clkbuf_4_0_0_clk/X VGND VGND VPWR VPWR _5785_/CLK sky130_fd_sc_hd__clkbuf_8
X_3020_ _5262_/Q _5230_/Q _3021_/S VGND VGND VPWR VPWR _3020_/X sky130_fd_sc_hd__mux2_1
XFILLER_63_121 VGND VGND VPWR VPWR sky130_fd_sc_hd__decap_3
XFILLER_17_571 VGND VGND VPWR VPWR sky130_fd_sc_hd__decap_3
XTAP_TAPCELL_ROW_63_1000 VGND VPWR sky130_fd_sc_hd__tapvpwrvgnd_1
X_4971_ _5005_/A1 _4976_/A2 _4978_/B1 _4971_/B2 VGND VGND VPWR VPWR _5999_/D sky130_fd_sc_hd__a22o_2
XTAP_TAPCELL_ROW_63_1011 VGND VPWR sky130_fd_sc_hd__tapvpwrvgnd_1
X_3922_ wire630/X _3918_/X _3920_/X _3922_/B1 _3904_/X VGND VGND VPWR VPWR _3922_/X
+ sky130_fd_sc_hd__a32o_2
X_3853_ _3889_/A _3849_/X _3852_/X _3898_/A1 VGND VGND VPWR VPWR _3853_/X sky130_fd_sc_hd__o211a_2
X_2804_ _2797_/X _2803_/X wire570/X VGND VGND VPWR VPWR _2804_/X sky130_fd_sc_hd__o21a_2
X_3784_ _3784_/A _3784_/B VGND VGND VPWR VPWR _3784_/X sky130_fd_sc_hd__and2_2
X_5523_ _5589_/CLK _5523_/D VGND VGND VPWR VPWR _5523_/Q sky130_fd_sc_hd__dfxtp_2
X_2735_ _2723_/X _2734_/X wire570/A VGND VGND VPWR VPWR _2735_/X sky130_fd_sc_hd__o21a_2
XFILLER_105_307 VGND VGND VPWR VPWR sky130_fd_sc_hd__decap_3
X_5454_ _5838_/CLK _5454_/D VGND VGND VPWR VPWR _5454_/Q sky130_fd_sc_hd__dfxtp_2
X_2666_ _5919_/Q _5887_/Q _5855_/Q _5759_/Q _3088_/S _3086_/S1 VGND VGND VPWR VPWR
+ _2666_/X sky130_fd_sc_hd__mux4_2
X_5385_ _5571_/CLK _5385_/D VGND VGND VPWR VPWR _5385_/Q sky130_fd_sc_hd__dfxtp_2
X_4405_ _4507_/A1 _4426_/A2 _4426_/B1 _4405_/B2 VGND VGND VPWR VPWR _5465_/D sky130_fd_sc_hd__a22o_2
XTAP_TAPCELL_ROW_74_1140 VGND VPWR sky130_fd_sc_hd__tapvpwrvgnd_1
Xfanout204 fanout204/A VGND VGND VPWR VPWR _4566_/B1 sky130_fd_sc_hd__clkdlybuf4s25_1
X_4336_ _4645_/A1 wire462/X wire242/A _4336_/B2 VGND VGND VPWR VPWR _5402_/D sky130_fd_sc_hd__a22o_2
X_2597_ _2585_/X _2596_/X _3119_/B1 VGND VGND VPWR VPWR _2597_/X sky130_fd_sc_hd__o21a_2
XFILLER_115_15 VGND VGND VPWR VPWR sky130_fd_sc_hd__decap_3
Xfanout237 _4368_/Y VGND VGND VPWR VPWR wire238/A sky130_fd_sc_hd__clkdlybuf4s25_1
Xfanout226 fanout232/X VGND VGND VPWR VPWR _4431_/B1 sky130_fd_sc_hd__clkdlybuf4s25_1
Xfanout215 _4471_/Y VGND VGND VPWR VPWR _4496_/B1 sky130_fd_sc_hd__clkdlybuf4s25_1
X_4267_ _4507_/A1 wire475/X wire255/X _4267_/B2 VGND VGND VPWR VPWR _5337_/D sky130_fd_sc_hd__a22o_2
XFILLER_101_579 VGND VGND VPWR VPWR sky130_fd_sc_hd__decap_3
X_6006_ _6038_/CLK _6006_/D VGND VGND VPWR VPWR _6006_/Q sky130_fd_sc_hd__dfxtp_2
X_4198_ _5016_/A1 _4226_/A2 _4226_/B1 _4198_/B2 VGND VGND VPWR VPWR _5272_/D sky130_fd_sc_hd__a22o_2
X_3218_ _3218_/A1 _3216_/X _3217_/X _3218_/B2 VGND VGND VPWR VPWR _3218_/X sky130_fd_sc_hd__o22a_2
X_3149_ _5812_/Q _5748_/Q _3150_/S VGND VGND VPWR VPWR _3149_/X sky130_fd_sc_hd__mux2_1
XFILLER_91_18 VGND VGND VPWR VPWR sky130_fd_sc_hd__decap_3
XTAP_TAPCELL_ROW_25_547 VGND VPWR sky130_fd_sc_hd__tapvpwrvgnd_1
XFILLER_23_552 VGND VGND VPWR VPWR sky130_fd_sc_hd__decap_3
XTAP_TAPCELL_ROW_53_889 VGND VPWR sky130_fd_sc_hd__tapvpwrvgnd_1
XFILLER_23_596 VGND VGND VPWR VPWR sky130_fd_sc_hd__fill_2
XFILLER_109_613 VGND VGND VPWR VPWR sky130_fd_sc_hd__decap_3
XFILLER_108_134 VGND VGND VPWR VPWR sky130_fd_sc_hd__decap_3
XFILLER_109_657 VGND VGND VPWR VPWR sky130_fd_sc_hd__decap_3
XFILLER_40_22 VGND VGND VPWR VPWR sky130_fd_sc_hd__decap_3
XFILLER_109_679 VGND VGND VPWR VPWR sky130_fd_sc_hd__decap_3
XFILLER_108_178 VGND VGND VPWR VPWR sky130_fd_sc_hd__decap_3
XFILLER_40_88 VGND VGND VPWR VPWR sky130_fd_sc_hd__fill_1
XFILLER_2_445 VGND VGND VPWR VPWR sky130_fd_sc_hd__decap_3
XFILLER_6_3 VGND VGND VPWR VPWR sky130_fd_sc_hd__decap_3
XFILLER_77_246 VGND VGND VPWR VPWR sky130_fd_sc_hd__fill_1
XFILLER_1_27 VGND VGND VPWR VPWR sky130_fd_sc_hd__decap_3
Xfanout793 _3026_/S VGND VGND VPWR VPWR _3015_/S sky130_fd_sc_hd__clkbuf_2
Xfanout771 input7/X VGND VGND VPWR VPWR wire772/A sky130_fd_sc_hd__clkdlybuf4s25_1
XTAP_TAPCELL_ROW_88_1309 VGND VPWR sky130_fd_sc_hd__tapvpwrvgnd_1
XFILLER_105_81 VGND VGND VPWR VPWR sky130_fd_sc_hd__decap_3
XFILLER_92_249 VGND VGND VPWR VPWR sky130_fd_sc_hd__decap_3
XFILLER_45_132 VGND VGND VPWR VPWR sky130_fd_sc_hd__decap_3
XFILLER_14_530 VGND VGND VPWR VPWR sky130_fd_sc_hd__fill_2
XFILLER_61_669 VGND VGND VPWR VPWR sky130_fd_sc_hd__decap_3
XFILLER_41_371 VGND VGND VPWR VPWR sky130_fd_sc_hd__fill_1
XTAP_TAPCELL_ROW_99_1438 VGND VPWR sky130_fd_sc_hd__tapvpwrvgnd_1
XFILLER_60_6 VGND VGND VPWR VPWR sky130_fd_sc_hd__fill_1
X_2520_ _5240_/Q _5208_/Q _2789_/S VGND VGND VPWR VPWR _2520_/X sky130_fd_sc_hd__mux2_1
XFILLER_115_638 VGND VGND VPWR VPWR sky130_fd_sc_hd__decap_3
XFILLER_39_3 VGND VGND VPWR VPWR sky130_fd_sc_hd__fill_1
XFILLER_96_511 VGND VGND VPWR VPWR sky130_fd_sc_hd__fill_2
X_5170_ _5805_/CLK _5170_/D VGND VGND VPWR VPWR _5170_/Q sky130_fd_sc_hd__dfxtp_2
XFILLER_96_544 VGND VGND VPWR VPWR sky130_fd_sc_hd__decap_3
Xhold1908 _5095_/Q VGND VGND VPWR VPWR _4004_/B2 sky130_fd_sc_hd__dlygate4sd3_1
X_4121_ _5008_/A1 wire518/X _4121_/B1 _4121_/B2 VGND VGND VPWR VPWR _5202_/D sky130_fd_sc_hd__a22o_2
Xhold1919 _5541_/Q VGND VGND VPWR VPWR _4485_/B2 sky130_fd_sc_hd__dlygate4sd3_1
X_4052_ _5010_/A1 _4052_/A2 _4052_/B1 _4052_/B2 VGND VGND VPWR VPWR _5140_/D sky130_fd_sc_hd__a22o_2
Xinput4 rd[3] VGND VGND VPWR VPWR input4/X sky130_fd_sc_hd__clkdlybuf4s25_1
X_3003_ _5837_/Q _5453_/Q _3003_/S VGND VGND VPWR VPWR _3003_/X sky130_fd_sc_hd__mux2_1
XTAP_TAPCELL_ROW_108_1545 VGND VPWR sky130_fd_sc_hd__tapvpwrvgnd_1
XFILLER_52_603 VGND VGND VPWR VPWR sky130_fd_sc_hd__fill_1
XFILLER_64_474 VGND VGND VPWR VPWR sky130_fd_sc_hd__fill_2
XFILLER_91_293 VGND VGND VPWR VPWR sky130_fd_sc_hd__decap_3
X_4954_ _4988_/A1 _4974_/A2 _4974_/B1 _4954_/B2 VGND VGND VPWR VPWR _5982_/D sky130_fd_sc_hd__a22o_2
X_3905_ _5142_/Q _5110_/Q _6038_/Q _6006_/Q _3508_/S _3905_/S1 VGND VGND VPWR VPWR
+ _3906_/B sky130_fd_sc_hd__mux4_2
XFILLER_20_511 VGND VGND VPWR VPWR sky130_fd_sc_hd__decap_3
XTAP_TAPCELL_ROW_22_517 VGND VPWR sky130_fd_sc_hd__tapvpwrvgnd_1
XTAP_TAPCELL_ROW_50_848 VGND VPWR sky130_fd_sc_hd__tapvpwrvgnd_1
X_4885_ _4885_/A1 _4902_/A2 wire139/A _4885_/B2 VGND VGND VPWR VPWR _5917_/D sky130_fd_sc_hd__a22o_2
XFILLER_20_566 VGND VGND VPWR VPWR sky130_fd_sc_hd__decap_3
X_3836_ _5843_/Q _5459_/Q _6067_/Q _5971_/Q _3622_/S _3893_/S1 VGND VGND VPWR VPWR
+ _3837_/B sky130_fd_sc_hd__mux4_2
X_3767_ _5839_/Q _5455_/Q _3767_/S VGND VGND VPWR VPWR _3767_/X sky130_fd_sc_hd__mux2_1
X_5506_ _5879_/CLK _5506_/D VGND VGND VPWR VPWR _5506_/Q sky130_fd_sc_hd__dfxtp_2
X_2718_ _5921_/Q _5889_/Q _5857_/Q _5761_/Q _2924_/S _2973_/S1 VGND VGND VPWR VPWR
+ _2719_/B sky130_fd_sc_hd__mux4_2
X_3698_ _5708_/Q _5676_/Q _5644_/Q _5612_/Q _3683_/S _3698_/S1 VGND VGND VPWR VPWR
+ _3698_/X sky130_fd_sc_hd__mux4_2
XFILLER_105_148 VGND VGND VPWR VPWR sky130_fd_sc_hd__fill_1
X_5437_ _6045_/CLK _5437_/D VGND VGND VPWR VPWR _5437_/Q sky130_fd_sc_hd__dfxtp_2
X_2649_ _2649_/A _2649_/B VGND VGND VPWR VPWR _2649_/X sky130_fd_sc_hd__or2_2
XFILLER_114_660 VGND VGND VPWR VPWR sky130_fd_sc_hd__decap_3
XFILLER_86_29 VGND VGND VPWR VPWR sky130_fd_sc_hd__decap_3
XFILLER_87_500 VGND VGND VPWR VPWR sky130_fd_sc_hd__decap_3
XFILLER_87_511 VGND VGND VPWR VPWR sky130_fd_sc_hd__decap_3
XFILLER_99_371 VGND VGND VPWR VPWR sky130_fd_sc_hd__decap_3
X_5368_ _5400_/CLK _5368_/D VGND VGND VPWR VPWR _5368_/Q sky130_fd_sc_hd__dfxtp_2
XFILLER_87_555 VGND VGND VPWR VPWR sky130_fd_sc_hd__decap_3
XFILLER_99_393 VGND VGND VPWR VPWR sky130_fd_sc_hd__decap_3
X_5299_ _5500_/CLK _5299_/D VGND VGND VPWR VPWR _5299_/Q sky130_fd_sc_hd__dfxtp_2
X_4319_ _4525_/A1 _4327_/A2 wire248/X _4319_/B2 VGND VGND VPWR VPWR _5387_/D sky130_fd_sc_hd__a22o_2
XFILLER_101_343 VGND VGND VPWR VPWR sky130_fd_sc_hd__fill_1
Xwire1127 _3397_/S VGND VGND VPWR VPWR _3802_/S sky130_fd_sc_hd__clkbuf_4
XFILLER_28_633 VGND VGND VPWR VPWR sky130_fd_sc_hd__decap_3
XTAP_TAPCELL_ROW_58_948 VGND VPWR sky130_fd_sc_hd__tapvpwrvgnd_1
XFILLER_28_655 VGND VGND VPWR VPWR sky130_fd_sc_hd__decap_3
XFILLER_74_249 VGND VGND VPWR VPWR sky130_fd_sc_hd__decap_3
XFILLER_28_677 VGND VGND VPWR VPWR sky130_fd_sc_hd__decap_3
XFILLER_42_102 VGND VGND VPWR VPWR sky130_fd_sc_hd__decap_3
XFILLER_43_625 VGND VGND VPWR VPWR sky130_fd_sc_hd__decap_3
XTAP_TAPCELL_ROW_2_275 VGND VPWR sky130_fd_sc_hd__tapvpwrvgnd_1
XFILLER_15_349 VGND VGND VPWR VPWR sky130_fd_sc_hd__decap_3
XFILLER_35_44 VGND VGND VPWR VPWR sky130_fd_sc_hd__decap_3
XFILLER_35_55 VGND VGND VPWR VPWR sky130_fd_sc_hd__fill_1
XFILLER_43_669 VGND VGND VPWR VPWR sky130_fd_sc_hd__decap_3
XFILLER_35_77 VGND VGND VPWR VPWR sky130_fd_sc_hd__decap_3
XFILLER_42_168 VGND VGND VPWR VPWR sky130_fd_sc_hd__fill_1
XFILLER_11_500 VGND VGND VPWR VPWR sky130_fd_sc_hd__decap_3
XFILLER_7_515 VGND VGND VPWR VPWR sky130_fd_sc_hd__fill_1
XFILLER_7_559 VGND VGND VPWR VPWR sky130_fd_sc_hd__fill_1
Xwire479 wire479/A VGND VGND VPWR VPWR _4265_/B sky130_fd_sc_hd__clkbuf_4
XFILLER_109_498 VGND VGND VPWR VPWR sky130_fd_sc_hd__decap_3
XTAP_TAPCELL_ROW_94_1379 VGND VPWR sky130_fd_sc_hd__tapvpwrvgnd_1
XFILLER_105_671 VGND VGND VPWR VPWR sky130_fd_sc_hd__fill_1
XFILLER_105_682 VGND VGND VPWR VPWR sky130_fd_sc_hd__decap_3
XFILLER_112_619 VGND VGND VPWR VPWR sky130_fd_sc_hd__decap_3
XFILLER_78_533 VGND VGND VPWR VPWR sky130_fd_sc_hd__decap_3
XFILLER_65_205 VGND VGND VPWR VPWR sky130_fd_sc_hd__fill_2
Xfanout590 _3916_/A1 VGND VGND VPWR VPWR wire591/A sky130_fd_sc_hd__clkdlybuf4s25_1
XFILLER_73_271 VGND VGND VPWR VPWR sky130_fd_sc_hd__fill_1
XFILLER_33_124 VGND VGND VPWR VPWR sky130_fd_sc_hd__decap_3
XFILLER_33_146 VGND VGND VPWR VPWR sky130_fd_sc_hd__decap_3
XFILLER_33_179 VGND VGND VPWR VPWR sky130_fd_sc_hd__decap_3
XTAP_TAPCELL_ROW_103_1486 VGND VPWR sky130_fd_sc_hd__tapvpwrvgnd_1
X_4670_ _4773_/A1 wire400/X wire179/A _4670_/B2 VGND VGND VPWR VPWR _5715_/D sky130_fd_sc_hd__a22o_2
X_3621_ _5257_/Q _5225_/Q _3622_/S VGND VGND VPWR VPWR _3621_/X sky130_fd_sc_hd__mux2_1
X_3552_ _5510_/Q _5478_/Q _3558_/S VGND VGND VPWR VPWR _3552_/X sky130_fd_sc_hd__mux2_1
X_2503_ _2497_/B _2503_/B VGND VGND VPWR VPWR _2503_/Y sky130_fd_sc_hd__nand2b_2
X_3483_ _3483_/A _3483_/B _3471_/B1 VGND VGND VPWR VPWR _3484_/C sky130_fd_sc_hd__or3b_2
X_5222_ _6061_/CLK _5222_/D VGND VGND VPWR VPWR _5222_/Q sky130_fd_sc_hd__dfxtp_2
X_5153_ _6026_/CLK _5153_/D VGND VGND VPWR VPWR _5153_/Q sky130_fd_sc_hd__dfxtp_2
XFILLER_111_641 VGND VGND VPWR VPWR sky130_fd_sc_hd__decap_3
XFILLER_96_363 VGND VGND VPWR VPWR sky130_fd_sc_hd__fill_1
Xhold1705 _5780_/Q VGND VGND VPWR VPWR _4740_/B2 sky130_fd_sc_hd__dlygate4sd3_1
Xhold1716 _5225_/Q VGND VGND VPWR VPWR _4146_/B2 sky130_fd_sc_hd__dlygate4sd3_1
X_4104_ _4991_/A1 wire516/X wire298/X _4104_/B2 VGND VGND VPWR VPWR _5185_/D sky130_fd_sc_hd__a22o_2
XFILLER_111_685 VGND VGND VPWR VPWR sky130_fd_sc_hd__decap_3
XFILLER_84_536 VGND VGND VPWR VPWR sky130_fd_sc_hd__decap_3
Xhold1727 _5245_/Q VGND VGND VPWR VPWR _4168_/B2 sky130_fd_sc_hd__dlygate4sd3_1
Xhold1738 _5773_/Q VGND VGND VPWR VPWR _4733_/B2 sky130_fd_sc_hd__dlygate4sd3_1
Xhold1749 _5105_/Q VGND VGND VPWR VPWR _4014_/B2 sky130_fd_sc_hd__dlygate4sd3_1
X_5084_ _6035_/CLK _5084_/D VGND VGND VPWR VPWR _5084_/Q sky130_fd_sc_hd__dfxtp_2
XFILLER_112_16 VGND VGND VPWR VPWR sky130_fd_sc_hd__decap_3
XFILLER_84_558 VGND VGND VPWR VPWR sky130_fd_sc_hd__fill_2
XTAP_TAPCELL_ROW_55_907 VGND VPWR sky130_fd_sc_hd__tapvpwrvgnd_1
X_4035_ _4517_/A1 _4053_/A2 _4040_/B1 _4035_/B2 VGND VGND VPWR VPWR _5123_/D sky130_fd_sc_hd__a22o_2
XFILLER_112_38 VGND VGND VPWR VPWR sky130_fd_sc_hd__decap_3
XFILLER_24_102 VGND VGND VPWR VPWR sky130_fd_sc_hd__decap_3
XFILLER_37_485 VGND VGND VPWR VPWR sky130_fd_sc_hd__fill_1
XTAP_TAPCELL_ROW_69_1072 VGND VPWR sky130_fd_sc_hd__tapvpwrvgnd_1
XFILLER_64_282 VGND VGND VPWR VPWR sky130_fd_sc_hd__fill_1
XTAP_TAPCELL_ROW_69_1083 VGND VPWR sky130_fd_sc_hd__tapvpwrvgnd_1
XFILLER_25_669 VGND VGND VPWR VPWR sky130_fd_sc_hd__decap_3
XTAP_TAPCELL_ROW_35_664 VGND VPWR sky130_fd_sc_hd__tapvpwrvgnd_1
X_5986_ _5986_/CLK _5986_/D VGND VGND VPWR VPWR _5986_/Q sky130_fd_sc_hd__dfxtp_2
XTAP_TAPCELL_ROW_35_675 VGND VPWR sky130_fd_sc_hd__tapvpwrvgnd_1
X_4937_ _5039_/A1 wire353/X wire136/X _4937_/B2 VGND VGND VPWR VPWR _5967_/D sky130_fd_sc_hd__a22o_2
XANTENNA_20 fanout397/A VGND VGND VPWR VPWR sky130_fd_sc_hd__diode_2
XANTENNA_31 _3878_/S1 VGND VGND VPWR VPWR sky130_fd_sc_hd__diode_2
XFILLER_20_330 VGND VGND VPWR VPWR sky130_fd_sc_hd__decap_3
X_4868_ _5038_/A1 _4868_/A2 wire146/X _4868_/B2 VGND VGND VPWR VPWR _5902_/D sky130_fd_sc_hd__a22o_2
XANTENNA_42 fanout375/A VGND VGND VPWR VPWR sky130_fd_sc_hd__diode_2
X_3819_ _3831_/B2 _3817_/X _3818_/X _3831_/A1 _3816_/X VGND VGND VPWR VPWR _3819_/X
+ sky130_fd_sc_hd__o221a_2
X_4799_ _4807_/A_N _4799_/B VGND VGND VPWR VPWR _5837_/D sky130_fd_sc_hd__and2b_2
XFILLER_106_424 VGND VGND VPWR VPWR sky130_fd_sc_hd__decap_3
XFILLER_108_6 VGND VGND VPWR VPWR sky130_fd_sc_hd__decap_3
XFILLER_97_39 VGND VGND VPWR VPWR sky130_fd_sc_hd__decap_3
XTAP_TAPCELL_ROW_7_334 VGND VPWR sky130_fd_sc_hd__tapvpwrvgnd_1
XFILLER_102_674 VGND VGND VPWR VPWR sky130_fd_sc_hd__decap_3
XFILLER_75_503 VGND VGND VPWR VPWR sky130_fd_sc_hd__fill_1
XPHY_EDGE_ROW_102_Right_102 VGND VGND VPWR VPWR sky130_fd_sc_hd__decap_3
XFILLER_101_151 VGND VGND VPWR VPWR sky130_fd_sc_hd__fill_1
XFILLER_75_569 VGND VGND VPWR VPWR sky130_fd_sc_hd__decap_3
XFILLER_15_102 VGND VGND VPWR VPWR sky130_fd_sc_hd__fill_2
XFILLER_15_124 VGND VGND VPWR VPWR sky130_fd_sc_hd__decap_3
XFILLER_83_591 VGND VGND VPWR VPWR sky130_fd_sc_hd__decap_3
XFILLER_30_138 VGND VGND VPWR VPWR sky130_fd_sc_hd__fill_2
XFILLER_30_149 VGND VGND VPWR VPWR sky130_fd_sc_hd__decap_3
XFILLER_7_15 VGND VGND VPWR VPWR sky130_fd_sc_hd__decap_3
XFILLER_7_301 VGND VGND VPWR VPWR sky130_fd_sc_hd__decap_3
XFILLER_7_48 VGND VGND VPWR VPWR sky130_fd_sc_hd__decap_3
XFILLER_109_251 VGND VGND VPWR VPWR sky130_fd_sc_hd__decap_3
Xwire298 wire298/A VGND VGND VPWR VPWR wire298/X sky130_fd_sc_hd__buf_4
XFILLER_98_639 VGND VGND VPWR VPWR sky130_fd_sc_hd__decap_3
XFILLER_87_50 VGND VGND VPWR VPWR sky130_fd_sc_hd__decap_3
XFILLER_97_127 VGND VGND VPWR VPWR sky130_fd_sc_hd__decap_3
Xload_slew259 _4284_/B1 VGND VGND VPWR VPWR _4294_/B1 sky130_fd_sc_hd__buf_4
XFILLER_38_238 VGND VGND VPWR VPWR sky130_fd_sc_hd__decap_3
XFILLER_66_547 VGND VGND VPWR VPWR sky130_fd_sc_hd__decap_3
XFILLER_53_208 VGND VGND VPWR VPWR sky130_fd_sc_hd__fill_1
XTAP_TAPCELL_ROW_105_1504 VGND VPWR sky130_fd_sc_hd__tapvpwrvgnd_1
XFILLER_46_282 VGND VGND VPWR VPWR sky130_fd_sc_hd__fill_2
XTAP_TAPCELL_ROW_105_1515 VGND VPWR sky130_fd_sc_hd__tapvpwrvgnd_1
X_5840_ _6040_/CLK _5840_/D VGND VGND VPWR VPWR _5840_/Q sky130_fd_sc_hd__dfxtp_2
XFILLER_22_639 VGND VGND VPWR VPWR sky130_fd_sc_hd__decap_3
XFILLER_34_488 VGND VGND VPWR VPWR sky130_fd_sc_hd__fill_2
X_5771_ _5867_/CLK _5771_/D VGND VGND VPWR VPWR _5771_/Q sky130_fd_sc_hd__dfxtp_2
X_2983_ _3228_/B2 _2980_/X _2982_/X VGND VGND VPWR VPWR _2983_/X sky130_fd_sc_hd__a21o_2
XFILLER_21_149 VGND VGND VPWR VPWR sky130_fd_sc_hd__decap_3
XTAP_TAPCELL_ROW_32_634 VGND VPWR sky130_fd_sc_hd__tapvpwrvgnd_1
XTAP_TAPCELL_ROW_60_965 VGND VPWR sky130_fd_sc_hd__tapvpwrvgnd_1
X_4722_ _4822_/A1 _4741_/A2 _4741_/B1 _4722_/B2 VGND VGND VPWR VPWR _5762_/D sky130_fd_sc_hd__a22o_2
Xinput40 wd[30] VGND VGND VPWR VPWR input40/X sky130_fd_sc_hd__clkdlybuf4s25_1
X_4653_ _4653_/A1 _4674_/A2 _4674_/B1 _4653_/B2 VGND VGND VPWR VPWR _5698_/D sky130_fd_sc_hd__a22o_2
XTAP_TAPCELL_ROW_12_391 VGND VPWR sky130_fd_sc_hd__tapvpwrvgnd_1
X_4584_ _4755_/A1 _4595_/A2 _4600_/B1 _4584_/B2 VGND VGND VPWR VPWR _5633_/D sky130_fd_sc_hd__a22o_2
X_3604_ _5576_/Q _5544_/Q _3880_/S VGND VGND VPWR VPWR _3604_/X sky130_fd_sc_hd__mux2_1
X_3535_ _5797_/Q _5733_/Q _3810_/S VGND VGND VPWR VPWR _3535_/X sky130_fd_sc_hd__mux2_1
XFILLER_107_27 VGND VGND VPWR VPWR sky130_fd_sc_hd__decap_3
X_3466_ _5410_/Q _5058_/Q _5794_/Q _5730_/Q _3469_/S0 _3828_/S1 VGND VGND VPWR VPWR
+ _3466_/X sky130_fd_sc_hd__mux4_2
XFILLER_103_449 VGND VGND VPWR VPWR sky130_fd_sc_hd__fill_2
X_5205_ _5914_/CLK _5205_/D VGND VGND VPWR VPWR _5205_/Q sky130_fd_sc_hd__dfxtp_2
X_3397_ _5503_/Q _5471_/Q _3397_/S VGND VGND VPWR VPWR _3397_/X sky130_fd_sc_hd__mux2_1
XFILLER_57_525 VGND VGND VPWR VPWR sky130_fd_sc_hd__decap_3
Xhold1502 _6035_/Q VGND VGND VPWR VPWR _5009_/B2 sky130_fd_sc_hd__dlygate4sd3_1
Xhold1513 _5423_/Q VGND VGND VPWR VPWR _4357_/B2 sky130_fd_sc_hd__dlygate4sd3_1
Xhold1524 _5482_/Q VGND VGND VPWR VPWR _4422_/B2 sky130_fd_sc_hd__dlygate4sd3_1
Xhold1535 _5603_/Q VGND VGND VPWR VPWR _4552_/B2 sky130_fd_sc_hd__dlygate4sd3_1
Xload_slew782 _2896_/S VGND VGND VPWR VPWR _2604_/S sky130_fd_sc_hd__clkbuf_4
X_5136_ _6000_/CLK _5136_/D VGND VGND VPWR VPWR _5136_/Q sky130_fd_sc_hd__dfxtp_2
Xhold1546 _6036_/Q VGND VGND VPWR VPWR _5010_/B2 sky130_fd_sc_hd__dlygate4sd3_1
Xhold1557 _5875_/Q VGND VGND VPWR VPWR _4839_/B2 sky130_fd_sc_hd__dlygate4sd3_1
Xhold1568 _5244_/Q VGND VGND VPWR VPWR _4167_/B2 sky130_fd_sc_hd__dlygate4sd3_1
X_5067_ _6059_/CLK _5067_/D VGND VGND VPWR VPWR _5067_/Q sky130_fd_sc_hd__dfxtp_2
Xhold1579 _5434_/Q VGND VGND VPWR VPWR _4371_/B2 sky130_fd_sc_hd__dlygate4sd3_1
X_4018_ _5045_/A1 _4018_/A2 _4018_/B1 _4018_/B2 VGND VGND VPWR VPWR _5109_/D sky130_fd_sc_hd__a22o_2
XFILLER_16_24 VGND VGND VPWR VPWR sky130_fd_sc_hd__decap_3
XFILLER_25_433 VGND VGND VPWR VPWR sky130_fd_sc_hd__fill_2
XFILLER_65_591 VGND VGND VPWR VPWR sky130_fd_sc_hd__decap_3
XFILLER_16_57 VGND VGND VPWR VPWR sky130_fd_sc_hd__decap_3
XTAP_TAPCELL_ROW_80_1209 VGND VPWR sky130_fd_sc_hd__tapvpwrvgnd_1
XFILLER_13_639 VGND VGND VPWR VPWR sky130_fd_sc_hd__decap_3
XFILLER_25_488 VGND VGND VPWR VPWR sky130_fd_sc_hd__fill_2
XFILLER_52_263 VGND VGND VPWR VPWR sky130_fd_sc_hd__decap_3
XFILLER_80_572 VGND VGND VPWR VPWR sky130_fd_sc_hd__fill_1
X_5969_ _6065_/CLK _5969_/D VGND VGND VPWR VPWR _5969_/Q sky130_fd_sc_hd__dfxtp_2
XFILLER_12_138 VGND VGND VPWR VPWR sky130_fd_sc_hd__fill_2
XFILLER_40_447 VGND VGND VPWR VPWR sky130_fd_sc_hd__decap_3
XFILLER_106_3 VGND VGND VPWR VPWR sky130_fd_sc_hd__decap_3
XTAP_TAPCELL_ROW_91_1338 VGND VPWR sky130_fd_sc_hd__tapvpwrvgnd_1
XFILLER_79_116 VGND VGND VPWR VPWR sky130_fd_sc_hd__decap_3
XFILLER_79_149 VGND VGND VPWR VPWR sky130_fd_sc_hd__decap_3
XFILLER_0_576 VGND VGND VPWR VPWR sky130_fd_sc_hd__decap_3
XFILLER_0_587 VGND VGND VPWR VPWR sky130_fd_sc_hd__fill_1
XFILLER_0_598 VGND VGND VPWR VPWR sky130_fd_sc_hd__decap_3
XFILLER_57_86 VGND VGND VPWR VPWR sky130_fd_sc_hd__decap_3
XFILLER_75_355 VGND VGND VPWR VPWR sky130_fd_sc_hd__fill_1
XFILLER_113_81 VGND VGND VPWR VPWR sky130_fd_sc_hd__decap_3
XFILLER_56_580 VGND VGND VPWR VPWR sky130_fd_sc_hd__decap_3
XFILLER_63_539 VGND VGND VPWR VPWR sky130_fd_sc_hd__fill_1
XFILLER_71_561 VGND VGND VPWR VPWR sky130_fd_sc_hd__fill_1
XFILLER_16_499 VGND VGND VPWR VPWR sky130_fd_sc_hd__fill_2
XFILLER_31_436 VGND VGND VPWR VPWR sky130_fd_sc_hd__decap_3
XFILLER_92_9 VGND VGND VPWR VPWR sky130_fd_sc_hd__decap_3
XFILLER_12_672 VGND VGND VPWR VPWR sky130_fd_sc_hd__decap_3
XTAP_TAPCELL_ROW_100_1445 VGND VPWR sky130_fd_sc_hd__tapvpwrvgnd_1
XFILLER_11_160 VGND VGND VPWR VPWR sky130_fd_sc_hd__fill_1
XFILLER_8_632 VGND VGND VPWR VPWR sky130_fd_sc_hd__decap_3
XFILLER_7_142 VGND VGND VPWR VPWR sky130_fd_sc_hd__fill_1
X_3320_ _3713_/B2 _3317_/X _3319_/X VGND VGND VPWR VPWR _3320_/X sky130_fd_sc_hd__o21a_2
X_3251_ _5400_/Q _5048_/Q _3863_/S VGND VGND VPWR VPWR _3251_/X sky130_fd_sc_hd__mux2_1
XFILLER_39_514 VGND VGND VPWR VPWR sky130_fd_sc_hd__decap_3
XFILLER_78_171 VGND VGND VPWR VPWR sky130_fd_sc_hd__decap_3
XTAP_TAPCELL_ROW_111_1585 VGND VPWR sky130_fd_sc_hd__tapvpwrvgnd_1
X_3182_ _5813_/Q _5749_/Q _3182_/S VGND VGND VPWR VPWR _3182_/X sky130_fd_sc_hd__mux2_1
XFILLER_39_558 VGND VGND VPWR VPWR sky130_fd_sc_hd__fill_2
XFILLER_26_219 VGND VGND VPWR VPWR sky130_fd_sc_hd__decap_3
XFILLER_54_528 VGND VGND VPWR VPWR sky130_fd_sc_hd__decap_3
XFILLER_66_388 VGND VGND VPWR VPWR sky130_fd_sc_hd__decap_3
XFILLER_19_271 VGND VGND VPWR VPWR sky130_fd_sc_hd__fill_1
XTAP_TAPCELL_ROW_66_1042 VGND VPWR sky130_fd_sc_hd__tapvpwrvgnd_1
XTAP_TAPCELL_ROW_17_450 VGND VPWR sky130_fd_sc_hd__tapvpwrvgnd_1
X_5823_ _6060_/CLK _5823_/D VGND VGND VPWR VPWR _5823_/Q sky130_fd_sc_hd__dfxtp_2
XTAP_TAPCELL_ROW_45_792 VGND VPWR sky130_fd_sc_hd__tapvpwrvgnd_1
X_5754_ _5914_/CLK _5754_/D VGND VGND VPWR VPWR _5754_/Q sky130_fd_sc_hd__dfxtp_2
X_2966_ _2497_/B _2963_/X _2965_/X _3229_/A1 VGND VGND VPWR VPWR _2966_/X sky130_fd_sc_hd__a22o_2
X_5685_ _5813_/CLK _5685_/D VGND VGND VPWR VPWR _5685_/Q sky130_fd_sc_hd__dfxtp_2
X_4705_ _4908_/A1 _4707_/A2 _4707_/B1 _4705_/B2 VGND VGND VPWR VPWR _5748_/D sky130_fd_sc_hd__a22o_2
X_2897_ _5193_/Q _5161_/Q _2897_/S VGND VGND VPWR VPWR _2897_/X sky130_fd_sc_hd__mux2_1
XFILLER_108_519 VGND VGND VPWR VPWR sky130_fd_sc_hd__decap_3
X_4636_ _4773_/A1 wire407/X wire186/A _4636_/B2 VGND VGND VPWR VPWR _5683_/D sky130_fd_sc_hd__a22o_2
XTAP_TAPCELL_ROW_77_1171 VGND VPWR sky130_fd_sc_hd__tapvpwrvgnd_1
X_4567_ _4772_/A1 _4572_/A2 _4572_/B1 _4567_/B2 VGND VGND VPWR VPWR _5618_/D sky130_fd_sc_hd__a22o_2
Xmax_cap384 _4744_/Y VGND VGND VPWR VPWR fanout383/A sky130_fd_sc_hd__buf_2
X_4498_ _4738_/A1 _4498_/A2 _4498_/B1 _4498_/B2 VGND VGND VPWR VPWR _5554_/D sky130_fd_sc_hd__a22o_2
X_3518_ _3867_/A _3518_/B VGND VGND VPWR VPWR _3518_/X sky130_fd_sc_hd__or2_2
Xhold2000 _5477_/Q VGND VGND VPWR VPWR _4417_/B2 sky130_fd_sc_hd__dlygate4sd3_1
Xhold2011 _5531_/Q VGND VGND VPWR VPWR _4475_/B2 sky130_fd_sc_hd__dlygate4sd3_1
X_3449_ _5505_/Q _5473_/Q _3700_/S VGND VGND VPWR VPWR _3449_/X sky130_fd_sc_hd__mux2_1
Xhold2022 _5563_/Q VGND VGND VPWR VPWR _4509_/B2 sky130_fd_sc_hd__dlygate4sd3_1
Xhold2033 _5232_/Q VGND VGND VPWR VPWR _4153_/B2 sky130_fd_sc_hd__dlygate4sd3_1
Xhold2044 _5662_/Q VGND VGND VPWR VPWR _4615_/B2 sky130_fd_sc_hd__dlygate4sd3_1
XFILLER_85_631 VGND VGND VPWR VPWR sky130_fd_sc_hd__decap_3
XFILLER_94_29 VGND VGND VPWR VPWR sky130_fd_sc_hd__decap_3
XFILLER_97_491 VGND VGND VPWR VPWR sky130_fd_sc_hd__decap_3
Xhold1310 _5181_/Q VGND VGND VPWR VPWR _4100_/B2 sky130_fd_sc_hd__dlygate4sd3_1
Xhold1321 _5276_/Q VGND VGND VPWR VPWR _4202_/B2 sky130_fd_sc_hd__dlygate4sd3_1
Xhold1332 _5248_/Q VGND VGND VPWR VPWR _4171_/B2 sky130_fd_sc_hd__dlygate4sd3_1
Xhold1343 _5627_/Q VGND VGND VPWR VPWR _4578_/B2 sky130_fd_sc_hd__dlygate4sd3_1
Xhold2055 _5233_/Q VGND VGND VPWR VPWR _4154_/B2 sky130_fd_sc_hd__dlygate4sd3_1
Xhold2066 _5674_/Q VGND VGND VPWR VPWR _4627_/B2 sky130_fd_sc_hd__dlygate4sd3_1
Xhold2077 _5975_/Q VGND VGND VPWR VPWR _4945_/B2 sky130_fd_sc_hd__dlygate4sd3_1
Xhold2088 _5208_/Q VGND VGND VPWR VPWR _4129_/B2 sky130_fd_sc_hd__dlygate4sd3_1
X_5119_ _5804_/CLK _5119_/D VGND VGND VPWR VPWR _5119_/Q sky130_fd_sc_hd__dfxtp_2
XFILLER_27_12 VGND VGND VPWR VPWR sky130_fd_sc_hd__decap_3
XFILLER_45_528 VGND VGND VPWR VPWR sky130_fd_sc_hd__fill_2
Xhold1354 _5575_/Q VGND VGND VPWR VPWR _4521_/B2 sky130_fd_sc_hd__dlygate4sd3_1
Xhold1365 _5421_/Q VGND VGND VPWR VPWR _4355_/B2 sky130_fd_sc_hd__dlygate4sd3_1
Xhold1376 _5882_/Q VGND VGND VPWR VPWR _4848_/B2 sky130_fd_sc_hd__dlygate4sd3_1
Xhold2099 _5758_/Q VGND VGND VPWR VPWR _4718_/B2 sky130_fd_sc_hd__dlygate4sd3_1
Xhold1387 _5338_/Q VGND VGND VPWR VPWR _4268_/B2 sky130_fd_sc_hd__dlygate4sd3_1
Xhold1398 _5801_/Q VGND VGND VPWR VPWR _4763_/B2 sky130_fd_sc_hd__dlygate4sd3_1
XFILLER_25_241 VGND VGND VPWR VPWR sky130_fd_sc_hd__decap_3
XFILLER_25_263 VGND VGND VPWR VPWR sky130_fd_sc_hd__fill_1
XFILLER_40_200 VGND VGND VPWR VPWR sky130_fd_sc_hd__fill_1
XFILLER_13_447 VGND VGND VPWR VPWR sky130_fd_sc_hd__fill_1
XFILLER_40_233 VGND VGND VPWR VPWR sky130_fd_sc_hd__fill_2
XFILLER_43_55 VGND VGND VPWR VPWR sky130_fd_sc_hd__fill_1
XFILLER_40_277 VGND VGND VPWR VPWR sky130_fd_sc_hd__fill_1
XFILLER_9_429 VGND VGND VPWR VPWR sky130_fd_sc_hd__decap_3
XFILLER_5_613 VGND VGND VPWR VPWR sky130_fd_sc_hd__decap_3
XFILLER_5_635 VGND VGND VPWR VPWR sky130_fd_sc_hd__decap_3
XFILLER_5_668 VGND VGND VPWR VPWR sky130_fd_sc_hd__decap_3
XFILLER_5_679 VGND VGND VPWR VPWR sky130_fd_sc_hd__decap_3
XFILLER_4_27 VGND VGND VPWR VPWR sky130_fd_sc_hd__fill_1
XFILLER_4_38 VGND VGND VPWR VPWR sky130_fd_sc_hd__decap_3
XFILLER_76_642 VGND VGND VPWR VPWR sky130_fd_sc_hd__fill_2
XFILLER_91_612 VGND VGND VPWR VPWR sky130_fd_sc_hd__decap_3
XFILLER_48_388 VGND VGND VPWR VPWR sky130_fd_sc_hd__decap_3
XFILLER_44_550 VGND VGND VPWR VPWR sky130_fd_sc_hd__decap_3
XFILLER_90_133 VGND VGND VPWR VPWR sky130_fd_sc_hd__decap_3
XFILLER_16_274 VGND VGND VPWR VPWR sky130_fd_sc_hd__fill_2
XFILLER_71_391 VGND VGND VPWR VPWR sky130_fd_sc_hd__fill_1
XFILLER_90_6 VGND VGND VPWR VPWR sky130_fd_sc_hd__decap_3
XTAP_TAPCELL_ROW_14_420 VGND VPWR sky130_fd_sc_hd__tapvpwrvgnd_1
XFILLER_31_255 VGND VGND VPWR VPWR sky130_fd_sc_hd__fill_2
XTAP_TAPCELL_ROW_42_751 VGND VPWR sky130_fd_sc_hd__tapvpwrvgnd_1
X_2820_ _5381_/Q _5349_/Q _5317_/Q _5285_/Q _3193_/S _2979_/S1 VGND VGND VPWR VPWR
+ _2820_/X sky130_fd_sc_hd__mux4_2
X_2751_ wire559/X _2747_/X _2750_/X _2745_/X VGND VGND VPWR VPWR _2751_/X sky130_fd_sc_hd__a31o_2
X_5470_ _5502_/CLK _5470_/D VGND VGND VPWR VPWR _5470_/Q sky130_fd_sc_hd__dfxtp_2
X_2682_ _5375_/Q _5343_/Q _5311_/Q _5279_/Q _3083_/S _3091_/S1 VGND VGND VPWR VPWR
+ _2682_/X sky130_fd_sc_hd__mux4_2
XFILLER_69_3 VGND VGND VPWR VPWR sky130_fd_sc_hd__fill_2
X_4421_ _4660_/A1 _4426_/A2 _4426_/B1 _4421_/B2 VGND VGND VPWR VPWR _5481_/D sky130_fd_sc_hd__a22o_2
XTAP_TAPCELL_ROW_113_1603 VGND VPWR sky130_fd_sc_hd__tapvpwrvgnd_1
XFILLER_113_533 VGND VGND VPWR VPWR sky130_fd_sc_hd__fill_1
X_4352_ _4695_/A1 _4365_/A2 _4365_/B1 _4352_/B2 VGND VGND VPWR VPWR _5418_/D sky130_fd_sc_hd__a22o_2
Xfanout408 _4607_/Y VGND VGND VPWR VPWR _4639_/A2 sky130_fd_sc_hd__clkdlybuf4s25_1
X_4283_ _4660_/A1 wire475/X wire255/X _4283_/B2 VGND VGND VPWR VPWR _5353_/D sky130_fd_sc_hd__a22o_2
X_3303_ wire628/X _3294_/X _3297_/X _3302_/X VGND VGND VPWR VPWR _3303_/X sky130_fd_sc_hd__a31o_2
XFILLER_113_599 VGND VGND VPWR VPWR sky130_fd_sc_hd__decap_3
XFILLER_98_288 VGND VGND VPWR VPWR sky130_fd_sc_hd__decap_3
X_6022_ _6066_/CLK _6022_/D VGND VGND VPWR VPWR _6022_/Q sky130_fd_sc_hd__dfxtp_2
X_3234_ _3239_/B _3234_/B VGND VGND VPWR VPWR _3234_/X sky130_fd_sc_hd__or2_4
XFILLER_100_238 VGND VGND VPWR VPWR sky130_fd_sc_hd__decap_3
XFILLER_79_491 VGND VGND VPWR VPWR sky130_fd_sc_hd__decap_3
XFILLER_27_517 VGND VGND VPWR VPWR sky130_fd_sc_hd__decap_3
XFILLER_66_141 VGND VGND VPWR VPWR sky130_fd_sc_hd__fill_2
X_3165_ _5525_/Q _5493_/Q _3166_/S VGND VGND VPWR VPWR _3165_/X sky130_fd_sc_hd__mux2_1
XFILLER_82_634 VGND VGND VPWR VPWR sky130_fd_sc_hd__fill_2
XFILLER_82_645 VGND VGND VPWR VPWR sky130_fd_sc_hd__decap_3
X_3096_ _3085_/X _3090_/X _3095_/X _3231_/B1 VGND VGND VPWR VPWR _3096_/X sky130_fd_sc_hd__o31a_2
XFILLER_35_561 VGND VGND VPWR VPWR sky130_fd_sc_hd__decap_3
XFILLER_50_542 VGND VGND VPWR VPWR sky130_fd_sc_hd__decap_3
XFILLER_62_380 VGND VGND VPWR VPWR sky130_fd_sc_hd__decap_3
XFILLER_62_391 VGND VGND VPWR VPWR sky130_fd_sc_hd__fill_2
XFILLER_10_406 VGND VGND VPWR VPWR sky130_fd_sc_hd__decap_3
XFILLER_50_553 VGND VGND VPWR VPWR sky130_fd_sc_hd__decap_3
XFILLER_50_575 VGND VGND VPWR VPWR sky130_fd_sc_hd__decap_3
X_5806_ _6062_/CLK _5806_/D VGND VGND VPWR VPWR _5806_/Q sky130_fd_sc_hd__dfxtp_2
X_3998_ _4515_/A1 wire540/X _4020_/B1 _3998_/B2 VGND VGND VPWR VPWR _5089_/D sky130_fd_sc_hd__a22o_2
XTAP_TAPCELL_ROW_79_1200 VGND VPWR sky130_fd_sc_hd__tapvpwrvgnd_1
X_5737_ _5785_/CLK _5737_/D VGND VGND VPWR VPWR _5737_/Q sky130_fd_sc_hd__dfxtp_2
X_2949_ _2499_/A _2947_/X _2948_/X _2949_/B2 VGND VGND VPWR VPWR _2949_/X sky130_fd_sc_hd__o22a_2
XFILLER_89_18 VGND VGND VPWR VPWR sky130_fd_sc_hd__fill_1
XTAP_TAPCELL_ROW_20_489 VGND VPWR sky130_fd_sc_hd__tapvpwrvgnd_1
X_5668_ _6052_/CLK _5668_/D VGND VGND VPWR VPWR _5668_/Q sky130_fd_sc_hd__dfxtp_2
X_5599_ _5825_/CLK _5599_/D VGND VGND VPWR VPWR _5599_/Q sky130_fd_sc_hd__dfxtp_2
X_4619_ _4653_/A1 _4640_/A2 _4640_/B1 _4619_/B2 VGND VGND VPWR VPWR _5666_/D sky130_fd_sc_hd__a22o_2
XFILLER_2_616 VGND VGND VPWR VPWR sky130_fd_sc_hd__decap_3
XFILLER_89_222 VGND VGND VPWR VPWR sky130_fd_sc_hd__fill_2
XFILLER_104_533 VGND VGND VPWR VPWR sky130_fd_sc_hd__fill_1
XFILLER_89_255 VGND VGND VPWR VPWR sky130_fd_sc_hd__fill_1
Xfanout942 input29/X VGND VGND VPWR VPWR _5002_/A1 sky130_fd_sc_hd__clkdlybuf4s25_1
Xfanout931 _5039_/A1 VGND VGND VPWR VPWR _4903_/A1 sky130_fd_sc_hd__clkdlybuf4s25_1
Xfanout920 _4601_/A1 VGND VGND VPWR VPWR _4772_/A1 sky130_fd_sc_hd__clkdlybuf4s25_1
Xfanout975 input21/X VGND VGND VPWR VPWR _5029_/A1 sky130_fd_sc_hd__clkdlybuf4s25_1
Xfanout986 _5026_/A1 VGND VGND VPWR VPWR _4992_/A1 sky130_fd_sc_hd__clkdlybuf4s25_1
Xfanout964 input23/X VGND VGND VPWR VPWR _4727_/A1 sky130_fd_sc_hd__clkdlybuf4s25_1
Xfanout953 _5034_/A1 VGND VGND VPWR VPWR _4830_/A1 sky130_fd_sc_hd__clkdlybuf4s25_1
XFILLER_57_130 VGND VGND VPWR VPWR sky130_fd_sc_hd__decap_3
XFILLER_58_653 VGND VGND VPWR VPWR sky130_fd_sc_hd__fill_2
XFILLER_73_601 VGND VGND VPWR VPWR sky130_fd_sc_hd__decap_3
Xhold1140 _5851_/Q VGND VGND VPWR VPWR _4815_/B2 sky130_fd_sc_hd__dlygate4sd3_1
Xhold1151 _5814_/Q VGND VGND VPWR VPWR _4776_/B2 sky130_fd_sc_hd__dlygate4sd3_1
XFILLER_73_623 VGND VGND VPWR VPWR sky130_fd_sc_hd__decap_3
XFILLER_85_494 VGND VGND VPWR VPWR sky130_fd_sc_hd__decap_3
Xhold1162 _6060_/Q VGND VGND VPWR VPWR _5036_/B2 sky130_fd_sc_hd__dlygate4sd3_1
Xhold1173 _5247_/Q VGND VGND VPWR VPWR _4170_/B2 sky130_fd_sc_hd__dlygate4sd3_1
Xhold1184 _5190_/Q VGND VGND VPWR VPWR _4109_/B2 sky130_fd_sc_hd__dlygate4sd3_1
XFILLER_72_144 VGND VGND VPWR VPWR sky130_fd_sc_hd__decap_3
Xhold1195 _5642_/Q VGND VGND VPWR VPWR _4593_/B2 sky130_fd_sc_hd__dlygate4sd3_1
XFILLER_60_317 VGND VGND VPWR VPWR sky130_fd_sc_hd__fill_1
XTAP_TAPCELL_ROW_28_589 VGND VPWR sky130_fd_sc_hd__tapvpwrvgnd_1
XFILLER_110_71 VGND VGND VPWR VPWR sky130_fd_sc_hd__decap_3
XFILLER_41_564 VGND VGND VPWR VPWR sky130_fd_sc_hd__decap_3
XFILLER_9_204 VGND VGND VPWR VPWR sky130_fd_sc_hd__decap_3
XFILLER_13_277 VGND VGND VPWR VPWR sky130_fd_sc_hd__decap_3
XFILLER_70_53 VGND VGND VPWR VPWR sky130_fd_sc_hd__fill_1
Xclkload29 _6059_/CLK VGND VGND VPWR VPWR clkload29/X sky130_fd_sc_hd__clkbuf_4
Xclkload18 _5500_/CLK VGND VGND VPWR VPWR clkload18/X sky130_fd_sc_hd__clkbuf_8
XFILLER_79_51 VGND VGND VPWR VPWR sky130_fd_sc_hd__decap_3
XFILLER_107_393 VGND VGND VPWR VPWR sky130_fd_sc_hd__decap_3
XFILLER_1_671 VGND VGND VPWR VPWR sky130_fd_sc_hd__fill_1
XFILLER_1_682 VGND VGND VPWR VPWR sky130_fd_sc_hd__decap_3
XFILLER_49_631 VGND VGND VPWR VPWR sky130_fd_sc_hd__decap_3
XFILLER_48_152 VGND VGND VPWR VPWR sky130_fd_sc_hd__decap_3
XFILLER_48_185 VGND VGND VPWR VPWR sky130_fd_sc_hd__decap_3
XFILLER_64_645 VGND VGND VPWR VPWR sky130_fd_sc_hd__decap_3
XFILLER_76_494 VGND VGND VPWR VPWR sky130_fd_sc_hd__fill_2
XTAP_TAPCELL_ROW_47_810 VGND VPWR sky130_fd_sc_hd__tapvpwrvgnd_1
XFILLER_63_133 VGND VGND VPWR VPWR sky130_fd_sc_hd__fill_1
XFILLER_17_561 VGND VGND VPWR VPWR sky130_fd_sc_hd__fill_1
XTAP_TAPCELL_ROW_63_1001 VGND VPWR sky130_fd_sc_hd__tapvpwrvgnd_1
X_4970_ _5004_/A1 _4947_/B _4976_/B1 _4970_/B2 VGND VGND VPWR VPWR _5998_/D sky130_fd_sc_hd__a22o_2
X_3921_ _3912_/X _3914_/X _3916_/X _3910_/X VGND VGND VPWR VPWR _3921_/X sky130_fd_sc_hd__a31o_2
XFILLER_32_553 VGND VGND VPWR VPWR sky130_fd_sc_hd__decap_3
X_3852_ _3347_/A _3850_/X _3851_/X _3632_/A VGND VGND VPWR VPWR _3852_/X sky130_fd_sc_hd__o22a_2
XFILLER_32_586 VGND VGND VPWR VPWR sky130_fd_sc_hd__fill_2
X_2803_ _3206_/C1 _2786_/X _2802_/X _3185_/A1 VGND VGND VPWR VPWR _2803_/X sky130_fd_sc_hd__a22o_2
X_5522_ _5659_/CLK _5522_/D VGND VGND VPWR VPWR _5522_/Q sky130_fd_sc_hd__dfxtp_2
X_3783_ _5840_/Q _5456_/Q _3785_/S VGND VGND VPWR VPWR _3784_/B sky130_fd_sc_hd__mux2_1
X_2734_ wire559/X _2730_/X _2733_/X _2728_/X VGND VGND VPWR VPWR _2734_/X sky130_fd_sc_hd__a31o_2
X_5453_ _6061_/CLK _5453_/D VGND VGND VPWR VPWR _5453_/Q sky130_fd_sc_hd__dfxtp_2
X_2665_ _2658_/X _2664_/X _3119_/B1 VGND VGND VPWR VPWR _2665_/X sky130_fd_sc_hd__o21a_2
XFILLER_105_319 VGND VGND VPWR VPWR sky130_fd_sc_hd__fill_1
X_5384_ _6056_/CLK _5384_/D VGND VGND VPWR VPWR _5384_/Q sky130_fd_sc_hd__dfxtp_2
X_4404_ _4506_/A1 _4403_/B _4434_/B1 _4404_/B2 VGND VGND VPWR VPWR _5464_/D sky130_fd_sc_hd__a22o_2
X_2596_ _3118_/B2 _2587_/X _2590_/X _2595_/X VGND VGND VPWR VPWR _2596_/X sky130_fd_sc_hd__a31o_2
XFILLER_99_542 VGND VGND VPWR VPWR sky130_fd_sc_hd__decap_3
XTAP_TAPCELL_ROW_74_1141 VGND VPWR sky130_fd_sc_hd__tapvpwrvgnd_1
X_4335_ _5017_/A1 wire462/X wire242/X _4335_/B2 VGND VGND VPWR VPWR _5401_/D sky130_fd_sc_hd__a22o_2
XFILLER_115_27 VGND VGND VPWR VPWR sky130_fd_sc_hd__fill_1
XFILLER_115_38 VGND VGND VPWR VPWR sky130_fd_sc_hd__decap_3
Xfanout249 _4331_/B1 VGND VGND VPWR VPWR _4321_/B1 sky130_fd_sc_hd__clkdlybuf4s25_1
X_4266_ _5016_/A1 wire479/A _4294_/B1 _4266_/B2 VGND VGND VPWR VPWR _5336_/D sky130_fd_sc_hd__a22o_2
X_6005_ _6037_/CLK _6005_/D VGND VGND VPWR VPWR _6005_/Q sky130_fd_sc_hd__dfxtp_2
X_4197_ _4879_/A _4197_/B VGND VGND VPWR VPWR _4197_/Y sky130_fd_sc_hd__nor2_2
X_3217_ _5815_/Q _5751_/Q _3217_/S VGND VGND VPWR VPWR _3217_/X sky130_fd_sc_hd__mux2_1
X_3148_ _5716_/Q _5684_/Q _5652_/Q _5620_/Q _3150_/S _3153_/S1 VGND VGND VPWR VPWR
+ _3148_/X sky130_fd_sc_hd__mux4_2
XFILLER_82_475 VGND VGND VPWR VPWR sky130_fd_sc_hd__fill_1
X_3079_ _3081_/A _3075_/X _3078_/X _3224_/A1 VGND VGND VPWR VPWR _3079_/X sky130_fd_sc_hd__o211a_2
XFILLER_23_542 VGND VGND VPWR VPWR sky130_fd_sc_hd__fill_2
XFILLER_70_648 VGND VGND VPWR VPWR sky130_fd_sc_hd__decap_3
XTAP_TAPCELL_ROW_25_548 VGND VPWR sky130_fd_sc_hd__tapvpwrvgnd_1
XTAP_TAPCELL_ROW_85_1270 VGND VPWR sky130_fd_sc_hd__tapvpwrvgnd_1
XFILLER_23_575 VGND VGND VPWR VPWR sky130_fd_sc_hd__decap_3
XFILLER_50_361 VGND VGND VPWR VPWR sky130_fd_sc_hd__decap_3
XFILLER_10_203 VGND VGND VPWR VPWR sky130_fd_sc_hd__decap_3
Xwire628 wire628/A VGND VGND VPWR VPWR wire628/X sky130_fd_sc_hd__clkbuf_4
XFILLER_109_669 VGND VGND VPWR VPWR sky130_fd_sc_hd__decap_3
XFILLER_104_363 VGND VGND VPWR VPWR sky130_fd_sc_hd__fill_1
XFILLER_49_98 VGND VGND VPWR VPWR sky130_fd_sc_hd__decap_3
XFILLER_77_225 VGND VGND VPWR VPWR sky130_fd_sc_hd__fill_1
XFILLER_105_60 VGND VGND VPWR VPWR sky130_fd_sc_hd__decap_3
XFILLER_92_206 VGND VGND VPWR VPWR sky130_fd_sc_hd__decap_3
Xfanout783 _2913_/S VGND VGND VPWR VPWR _2529_/S sky130_fd_sc_hd__dlymetal6s2s_1
Xfanout761 fanout765/X VGND VGND VPWR VPWR _3102_/S1 sky130_fd_sc_hd__clkdlybuf4s25_1
XFILLER_100_580 VGND VGND VPWR VPWR sky130_fd_sc_hd__decap_3
XFILLER_105_93 VGND VGND VPWR VPWR sky130_fd_sc_hd__fill_2
XFILLER_18_303 VGND VGND VPWR VPWR sky130_fd_sc_hd__decap_3
XFILLER_1_39 VGND VGND VPWR VPWR sky130_fd_sc_hd__decap_3
XFILLER_65_42 VGND VGND VPWR VPWR sky130_fd_sc_hd__decap_3
XFILLER_33_317 VGND VGND VPWR VPWR sky130_fd_sc_hd__fill_2
XFILLER_61_637 VGND VGND VPWR VPWR sky130_fd_sc_hd__decap_3
XFILLER_60_114 VGND VGND VPWR VPWR sky130_fd_sc_hd__fill_2
XFILLER_14_542 VGND VGND VPWR VPWR sky130_fd_sc_hd__fill_2
XFILLER_14_586 VGND VGND VPWR VPWR sky130_fd_sc_hd__fill_2
XTAP_TAPCELL_ROW_99_1439 VGND VPWR sky130_fd_sc_hd__tapvpwrvgnd_1
XFILLER_115_617 VGND VGND VPWR VPWR sky130_fd_sc_hd__decap_3
XFILLER_114_138 VGND VGND VPWR VPWR sky130_fd_sc_hd__fill_2
Xhold1909 _5548_/Q VGND VGND VPWR VPWR _4492_/B2 sky130_fd_sc_hd__dlygate4sd3_1
X_4120_ _5007_/A1 _4120_/A2 _4120_/B1 _4120_/B2 VGND VGND VPWR VPWR _5201_/D sky130_fd_sc_hd__a22o_2
XFILLER_96_589 VGND VGND VPWR VPWR sky130_fd_sc_hd__decap_3
X_4051_ _5009_/A1 _4053_/A2 _4053_/B1 _4051_/B2 VGND VGND VPWR VPWR _5139_/D sky130_fd_sc_hd__a22o_2
Xinput5 rd[4] VGND VGND VPWR VPWR input5/X sky130_fd_sc_hd__clkdlybuf4s25_1
X_3002_ _6061_/Q _5965_/Q _3003_/S VGND VGND VPWR VPWR _3002_/X sky130_fd_sc_hd__mux2_1
XFILLER_36_144 VGND VGND VPWR VPWR sky130_fd_sc_hd__fill_2
XFILLER_37_645 VGND VGND VPWR VPWR sky130_fd_sc_hd__decap_3
XTAP_TAPCELL_ROW_108_1546 VGND VPWR sky130_fd_sc_hd__tapvpwrvgnd_1
XFILLER_101_18 VGND VGND VPWR VPWR sky130_fd_sc_hd__fill_2
X_4953_ _4987_/A1 _4974_/A2 _4974_/B1 _4953_/B2 VGND VGND VPWR VPWR _5981_/D sky130_fd_sc_hd__a22o_2
XFILLER_32_350 VGND VGND VPWR VPWR sky130_fd_sc_hd__decap_3
X_3904_ _3233_/Y _3901_/X _3903_/X VGND VGND VPWR VPWR _3904_/X sky130_fd_sc_hd__a21o_2
XTAP_TAPCELL_ROW_22_518 VGND VPWR sky130_fd_sc_hd__tapvpwrvgnd_1
XTAP_TAPCELL_ROW_50_849 VGND VPWR sky130_fd_sc_hd__tapvpwrvgnd_1
X_4884_ _5020_/A1 _4907_/A2 wire139/X _4884_/B2 VGND VGND VPWR VPWR _5916_/D sky130_fd_sc_hd__a22o_2
XFILLER_32_394 VGND VGND VPWR VPWR sky130_fd_sc_hd__decap_3
X_3835_ _5939_/Q _5907_/Q _5875_/Q _5779_/Q _3622_/S _3893_/S1 VGND VGND VPWR VPWR
+ _3835_/X sky130_fd_sc_hd__mux4_2
X_3766_ _6063_/Q _5967_/Q _3767_/S VGND VGND VPWR VPWR _3766_/X sky130_fd_sc_hd__mux2_1
X_5505_ _6058_/CLK _5505_/D VGND VGND VPWR VPWR _5505_/Q sky130_fd_sc_hd__dfxtp_2
X_2717_ _2730_/A _2713_/X _2716_/X _3106_/C1 VGND VGND VPWR VPWR _2717_/X sky130_fd_sc_hd__o211a_2
XFILLER_10_15 VGND VGND VPWR VPWR sky130_fd_sc_hd__decap_3
X_5436_ _6044_/CLK _5436_/D VGND VGND VPWR VPWR _5436_/Q sky130_fd_sc_hd__dfxtp_2
X_3697_ _3248_/X _3687_/X _3690_/X _3696_/X VGND VGND VPWR VPWR _3697_/X sky130_fd_sc_hd__a31o_2
X_2648_ _5694_/Q _5662_/Q _5630_/Q _5598_/Q _3114_/S _3107_/S1 VGND VGND VPWR VPWR
+ _2649_/B sky130_fd_sc_hd__mux4_2
XFILLER_114_672 VGND VGND VPWR VPWR sky130_fd_sc_hd__decap_3
X_5367_ _5704_/CLK _5367_/D VGND VGND VPWR VPWR _5367_/Q sky130_fd_sc_hd__dfxtp_2
X_2579_ wire643/X _2577_/X _2578_/X _2990_/A1 VGND VGND VPWR VPWR _2579_/X sky130_fd_sc_hd__o22a_2
XFILLER_87_534 VGND VGND VPWR VPWR sky130_fd_sc_hd__decap_3
XFILLER_99_383 VGND VGND VPWR VPWR sky130_fd_sc_hd__decap_3
X_5298_ _5502_/CLK _5298_/D VGND VGND VPWR VPWR _5298_/Q sky130_fd_sc_hd__dfxtp_2
X_4318_ _4830_/A1 _4331_/A2 _4318_/B1 _4318_/B2 VGND VGND VPWR VPWR _5386_/D sky130_fd_sc_hd__a22o_2
XFILLER_101_366 VGND VGND VPWR VPWR sky130_fd_sc_hd__decap_3
X_4249_ _4660_/A1 wire482/X wire262/X _4249_/B2 VGND VGND VPWR VPWR _5321_/D sky130_fd_sc_hd__a22o_2
XFILLER_28_601 VGND VGND VPWR VPWR sky130_fd_sc_hd__decap_3
XTAP_TAPCELL_ROW_58_949 VGND VPWR sky130_fd_sc_hd__tapvpwrvgnd_1
XFILLER_28_645 VGND VGND VPWR VPWR sky130_fd_sc_hd__fill_2
XFILLER_28_667 VGND VGND VPWR VPWR sky130_fd_sc_hd__fill_2
XFILLER_55_420 VGND VGND VPWR VPWR sky130_fd_sc_hd__fill_2
XTAP_TAPCELL_ROW_2_276 VGND VPWR sky130_fd_sc_hd__tapvpwrvgnd_1
XFILLER_70_445 VGND VGND VPWR VPWR sky130_fd_sc_hd__decap_3
XFILLER_23_350 VGND VGND VPWR VPWR sky130_fd_sc_hd__decap_3
XFILLER_30_309 VGND VGND VPWR VPWR sky130_fd_sc_hd__decap_3
XFILLER_42_158 VGND VGND VPWR VPWR sky130_fd_sc_hd__fill_1
XFILLER_51_670 VGND VGND VPWR VPWR sky130_fd_sc_hd__fill_2
Xwire414 wire414/A VGND VGND VPWR VPWR wire414/X sky130_fd_sc_hd__buf_4
XFILLER_11_578 VGND VGND VPWR VPWR sky130_fd_sc_hd__decap_3
XFILLER_51_55 VGND VGND VPWR VPWR sky130_fd_sc_hd__fill_1
XFILLER_105_650 VGND VGND VPWR VPWR sky130_fd_sc_hd__decap_3
Xload_slew419 _4574_/B VGND VGND VPWR VPWR _4595_/A2 sky130_fd_sc_hd__buf_4
XFILLER_104_171 VGND VGND VPWR VPWR sky130_fd_sc_hd__decap_3
XFILLER_111_119 VGND VGND VPWR VPWR sky130_fd_sc_hd__fill_1
XFILLER_38_409 VGND VGND VPWR VPWR sky130_fd_sc_hd__decap_3
XFILLER_78_589 VGND VGND VPWR VPWR sky130_fd_sc_hd__decap_3
Xfanout580 _3248_/X VGND VGND VPWR VPWR _3922_/B1 sky130_fd_sc_hd__clkbuf_4
XFILLER_18_177 VGND VGND VPWR VPWR sky130_fd_sc_hd__decap_3
XFILLER_46_475 VGND VGND VPWR VPWR sky130_fd_sc_hd__fill_1
XFILLER_34_637 VGND VGND VPWR VPWR sky130_fd_sc_hd__decap_3
XFILLER_46_497 VGND VGND VPWR VPWR sky130_fd_sc_hd__decap_3
XFILLER_61_423 VGND VGND VPWR VPWR sky130_fd_sc_hd__fill_1
XFILLER_92_51 VGND VGND VPWR VPWR sky130_fd_sc_hd__decap_3
XFILLER_14_350 VGND VGND VPWR VPWR sky130_fd_sc_hd__decap_3
XFILLER_33_158 VGND VGND VPWR VPWR sky130_fd_sc_hd__decap_3
XFILLER_33_169 VGND VGND VPWR VPWR sky130_fd_sc_hd__fill_2
XTAP_TAPCELL_ROW_103_1487 VGND VPWR sky130_fd_sc_hd__tapvpwrvgnd_1
XFILLER_14_394 VGND VGND VPWR VPWR sky130_fd_sc_hd__fill_2
X_3620_ _5129_/Q _5097_/Q _6025_/Q _5993_/Q _3616_/S _3627_/S1 VGND VGND VPWR VPWR
+ _3620_/X sky130_fd_sc_hd__mux4_2
X_3551_ _5382_/Q _5350_/Q _5318_/Q _5286_/Q _3317_/S _3566_/S1 VGND VGND VPWR VPWR
+ _3551_/X sky130_fd_sc_hd__mux4_2
XFILLER_6_560 VGND VGND VPWR VPWR sky130_fd_sc_hd__decap_3
X_2502_ _2497_/B _2503_/B VGND VGND VPWR VPWR _2502_/X sky130_fd_sc_hd__and2b_2
XFILLER_51_3 VGND VGND VPWR VPWR sky130_fd_sc_hd__decap_3
X_3482_ _3235_/B _3479_/X _3481_/X _2495_/Y VGND VGND VPWR VPWR _3483_/B sky130_fd_sc_hd__o211a_2
XFILLER_102_108 VGND VGND VPWR VPWR sky130_fd_sc_hd__decap_3
XFILLER_88_309 VGND VGND VPWR VPWR sky130_fd_sc_hd__decap_3
XTAP_TAPCELL_ROW_71_1100 VGND VPWR sky130_fd_sc_hd__tapvpwrvgnd_1
X_5221_ _5832_/CLK _5221_/D VGND VGND VPWR VPWR _5221_/Q sky130_fd_sc_hd__dfxtp_2
XFILLER_111_620 VGND VGND VPWR VPWR sky130_fd_sc_hd__decap_3
X_5152_ _6030_/CLK _5152_/D VGND VGND VPWR VPWR _5152_/Q sky130_fd_sc_hd__dfxtp_2
XFILLER_111_653 VGND VGND VPWR VPWR sky130_fd_sc_hd__decap_3
XFILLER_96_331 VGND VGND VPWR VPWR sky130_fd_sc_hd__decap_3
Xhold1706 _5336_/Q VGND VGND VPWR VPWR _4266_/B2 sky130_fd_sc_hd__dlygate4sd3_1
Xhold1717 _5854_/Q VGND VGND VPWR VPWR _4818_/B2 sky130_fd_sc_hd__dlygate4sd3_1
X_4103_ _4990_/A1 _4094_/B _4123_/B1 _4103_/B2 VGND VGND VPWR VPWR _5184_/D sky130_fd_sc_hd__a22o_2
XFILLER_2_71 VGND VGND VPWR VPWR sky130_fd_sc_hd__decap_3
XFILLER_56_206 VGND VGND VPWR VPWR sky130_fd_sc_hd__decap_3
Xhold1728 _5471_/Q VGND VGND VPWR VPWR _4411_/B2 sky130_fd_sc_hd__dlygate4sd3_1
Xhold1739 _5133_/Q VGND VGND VPWR VPWR _4045_/B2 sky130_fd_sc_hd__dlygate4sd3_1
Xload_slew997 _4437_/A VGND VGND VPWR VPWR _4745_/A sky130_fd_sc_hd__buf_4
X_5083_ _6042_/CLK _5083_/D VGND VGND VPWR VPWR _5083_/Q sky130_fd_sc_hd__dfxtp_2
XFILLER_37_442 VGND VGND VPWR VPWR sky130_fd_sc_hd__decap_3
XTAP_TAPCELL_ROW_55_908 VGND VPWR sky130_fd_sc_hd__tapvpwrvgnd_1
X_4034_ _4653_/A1 wire533/X _4055_/B1 _4034_/B2 VGND VGND VPWR VPWR _5122_/D sky130_fd_sc_hd__a22o_2
XFILLER_92_570 VGND VGND VPWR VPWR sky130_fd_sc_hd__decap_3
XFILLER_24_114 VGND VGND VPWR VPWR sky130_fd_sc_hd__fill_1
XFILLER_92_592 VGND VGND VPWR VPWR sky130_fd_sc_hd__fill_1
XTAP_TAPCELL_ROW_69_1073 VGND VPWR sky130_fd_sc_hd__tapvpwrvgnd_1
XFILLER_12_309 VGND VGND VPWR VPWR sky130_fd_sc_hd__decap_3
XFILLER_24_147 VGND VGND VPWR VPWR sky130_fd_sc_hd__fill_1
XTAP_TAPCELL_ROW_35_665 VGND VPWR sky130_fd_sc_hd__tapvpwrvgnd_1
X_5985_ _6017_/CLK _5985_/D VGND VGND VPWR VPWR _5985_/Q sky130_fd_sc_hd__dfxtp_2
XFILLER_52_489 VGND VGND VPWR VPWR sky130_fd_sc_hd__decap_3
X_4936_ _5038_/A1 _4936_/A2 wire133/X _4936_/B2 VGND VGND VPWR VPWR _5966_/D sky130_fd_sc_hd__a22o_2
XANTENNA_10 _4946_/Y VGND VGND VPWR VPWR sky130_fd_sc_hd__diode_2
XANTENNA_21 fanout458/A VGND VGND VPWR VPWR sky130_fd_sc_hd__diode_2
XANTENNA_32 _3878_/S1 VGND VGND VPWR VPWR sky130_fd_sc_hd__diode_2
X_4867_ _5037_/A1 _4875_/A2 _4875_/B1 _4867_/B2 VGND VGND VPWR VPWR _5901_/D sky130_fd_sc_hd__a22o_2
XANTENNA_43 fanout375/A VGND VGND VPWR VPWR sky130_fd_sc_hd__diode_2
X_3818_ _5266_/Q _5234_/Q _3818_/S VGND VGND VPWR VPWR _3818_/X sky130_fd_sc_hd__mux2_1
X_4798_ wire1003/X _4798_/B VGND VGND VPWR VPWR _5836_/D sky130_fd_sc_hd__and2b_2
XFILLER_21_69 VGND VGND VPWR VPWR sky130_fd_sc_hd__decap_3
X_3749_ _5391_/Q _5359_/Q _5327_/Q _5295_/Q _3873_/S _3917_/S1 VGND VGND VPWR VPWR
+ _3749_/X sky130_fd_sc_hd__mux4_2
XFILLER_106_436 VGND VGND VPWR VPWR sky130_fd_sc_hd__decap_3
XFILLER_97_18 VGND VGND VPWR VPWR sky130_fd_sc_hd__decap_3
X_5419_ _6059_/CLK _5419_/D VGND VGND VPWR VPWR _5419_/Q sky130_fd_sc_hd__dfxtp_2
XTAP_TAPCELL_ROW_7_335 VGND VPWR sky130_fd_sc_hd__tapvpwrvgnd_1
XFILLER_101_141 VGND VGND VPWR VPWR sky130_fd_sc_hd__fill_2
XFILLER_87_364 VGND VGND VPWR VPWR sky130_fd_sc_hd__fill_2
XFILLER_101_174 VGND VGND VPWR VPWR sky130_fd_sc_hd__fill_1
XFILLER_102_686 VGND VGND VPWR VPWR sky130_fd_sc_hd__fill_2
XFILLER_47_228 VGND VGND VPWR VPWR sky130_fd_sc_hd__decap_3
XFILLER_16_604 VGND VGND VPWR VPWR sky130_fd_sc_hd__fill_2
XFILLER_62_209 VGND VGND VPWR VPWR sky130_fd_sc_hd__decap_3
XFILLER_16_626 VGND VGND VPWR VPWR sky130_fd_sc_hd__decap_3
XFILLER_16_637 VGND VGND VPWR VPWR sky130_fd_sc_hd__decap_3
XFILLER_16_648 VGND VGND VPWR VPWR sky130_fd_sc_hd__fill_2
XFILLER_28_497 VGND VGND VPWR VPWR sky130_fd_sc_hd__fill_2
XFILLER_46_88 VGND VGND VPWR VPWR sky130_fd_sc_hd__decap_3
XFILLER_70_220 VGND VGND VPWR VPWR sky130_fd_sc_hd__decap_3
XFILLER_15_169 VGND VGND VPWR VPWR sky130_fd_sc_hd__fill_1
XFILLER_24_670 VGND VGND VPWR VPWR sky130_fd_sc_hd__decap_3
XFILLER_62_54 VGND VGND VPWR VPWR sky130_fd_sc_hd__decap_3
XFILLER_23_180 VGND VGND VPWR VPWR sky130_fd_sc_hd__decap_3
XFILLER_7_27 VGND VGND VPWR VPWR sky130_fd_sc_hd__decap_3
XFILLER_7_324 VGND VGND VPWR VPWR sky130_fd_sc_hd__decap_3
Xwire255 wire255/A VGND VGND VPWR VPWR wire255/X sky130_fd_sc_hd__clkbuf_4
XFILLER_109_263 VGND VGND VPWR VPWR sky130_fd_sc_hd__decap_3
XFILLER_7_368 VGND VGND VPWR VPWR sky130_fd_sc_hd__fill_1
Xload_slew227 _4431_/B1 VGND VGND VPWR VPWR _4426_/B1 sky130_fd_sc_hd__buf_2
Xload_slew216 _4496_/B1 VGND VGND VPWR VPWR _4502_/B1 sky130_fd_sc_hd__buf_4
Xclkbuf_4_9_0_clk clkbuf_0_clk/X VGND VGND VPWR VPWR clkload4/A sky130_fd_sc_hd__clkbuf_8
XFILLER_66_504 VGND VGND VPWR VPWR sky130_fd_sc_hd__decap_3
XFILLER_16_6 VGND VGND VPWR VPWR sky130_fd_sc_hd__decap_3
XFILLER_93_345 VGND VGND VPWR VPWR sky130_fd_sc_hd__decap_3
XTAP_TAPCELL_ROW_105_1505 VGND VPWR sky130_fd_sc_hd__tapvpwrvgnd_1
XFILLER_46_272 VGND VGND VPWR VPWR sky130_fd_sc_hd__fill_2
XFILLER_21_106 VGND VGND VPWR VPWR sky130_fd_sc_hd__decap_3
XFILLER_61_275 VGND VGND VPWR VPWR sky130_fd_sc_hd__decap_3
XFILLER_99_3 VGND VGND VPWR VPWR sky130_fd_sc_hd__decap_3
X_5770_ _5866_/CLK _5770_/D VGND VGND VPWR VPWR _5770_/Q sky130_fd_sc_hd__dfxtp_2
X_2982_ _2497_/B _2979_/X _2981_/X _3229_/A1 VGND VGND VPWR VPWR _2982_/X sky130_fd_sc_hd__a22o_2
XTAP_TAPCELL_ROW_32_635 VGND VPWR sky130_fd_sc_hd__tapvpwrvgnd_1
XTAP_TAPCELL_ROW_60_966 VGND VPWR sky130_fd_sc_hd__tapvpwrvgnd_1
X_4721_ _5025_/A1 wire389/X _4727_/B1 _4721_/B2 VGND VGND VPWR VPWR _5761_/D sky130_fd_sc_hd__a22o_2
XFILLER_30_673 VGND VGND VPWR VPWR sky130_fd_sc_hd__decap_3
X_4652_ _4755_/A1 _4668_/A2 _4668_/B1 _4652_/B2 VGND VGND VPWR VPWR _5697_/D sky130_fd_sc_hd__a22o_2
Xinput30 wd[21] VGND VGND VPWR VPWR input30/X sky130_fd_sc_hd__clkdlybuf4s25_1
X_3603_ _5384_/Q _5352_/Q _5320_/Q _5288_/Q _3427_/S _3839_/S1 VGND VGND VPWR VPWR
+ _3603_/X sky130_fd_sc_hd__mux4_2
XTAP_TAPCELL_ROW_12_392 VGND VPWR sky130_fd_sc_hd__tapvpwrvgnd_1
Xinput41 wd[31] VGND VGND VPWR VPWR input41/X sky130_fd_sc_hd__clkdlybuf4s25_1
X_4583_ _5024_/A1 wire414/X wire193/X _4583_/B2 VGND VGND VPWR VPWR _5632_/D sky130_fd_sc_hd__a22o_2
X_3534_ _5701_/Q _5669_/Q _5637_/Q _5605_/Q _3913_/S _3917_/S1 VGND VGND VPWR VPWR
+ _3534_/X sky130_fd_sc_hd__mux4_2
XFILLER_107_39 VGND VGND VPWR VPWR sky130_fd_sc_hd__decap_3
XFILLER_89_629 VGND VGND VPWR VPWR sky130_fd_sc_hd__decap_3
X_3465_ _5698_/Q _5666_/Q _5634_/Q _5602_/Q _3469_/S0 _3828_/S1 VGND VGND VPWR VPWR
+ _3465_/X sky130_fd_sc_hd__mux4_2
X_5204_ _6031_/CLK _5204_/D VGND VGND VPWR VPWR _5204_/Q sky130_fd_sc_hd__dfxtp_2
XFILLER_69_353 VGND VGND VPWR VPWR sky130_fd_sc_hd__decap_3
Xload_slew750 _2492_/A VGND VGND VPWR VPWR _2497_/B sky130_fd_sc_hd__buf_6
X_3396_ _5375_/Q _5343_/Q _5311_/Q _5279_/Q _3810_/S _3808_/S1 VGND VGND VPWR VPWR
+ _3396_/X sky130_fd_sc_hd__mux4_2
Xhold1503 _5205_/Q VGND VGND VPWR VPWR _4124_/B2 sky130_fd_sc_hd__dlygate4sd3_1
Xhold1514 _5566_/Q VGND VGND VPWR VPWR _4512_/B2 sky130_fd_sc_hd__dlygate4sd3_1
Xhold1525 _5270_/Q VGND VGND VPWR VPWR _4193_/B2 sky130_fd_sc_hd__dlygate4sd3_1
X_5135_ _6038_/CLK _5135_/D VGND VGND VPWR VPWR _5135_/Q sky130_fd_sc_hd__dfxtp_2
XFILLER_111_494 VGND VGND VPWR VPWR sky130_fd_sc_hd__fill_2
Xhold1536 _5200_/Q VGND VGND VPWR VPWR _4119_/B2 sky130_fd_sc_hd__dlygate4sd3_1
Xhold1547 _5913_/Q VGND VGND VPWR VPWR _4881_/B2 sky130_fd_sc_hd__dlygate4sd3_1
Xhold1558 _5794_/Q VGND VGND VPWR VPWR _4756_/B2 sky130_fd_sc_hd__dlygate4sd3_1
Xload_slew794 _3015_/S VGND VGND VPWR VPWR _2708_/S sky130_fd_sc_hd__buf_2
X_5066_ _5802_/CLK _5066_/D VGND VGND VPWR VPWR _5066_/Q sky130_fd_sc_hd__dfxtp_2
XFILLER_72_507 VGND VGND VPWR VPWR sky130_fd_sc_hd__decap_3
Xhold1569 _5481_/Q VGND VGND VPWR VPWR _4421_/B2 sky130_fd_sc_hd__dlygate4sd3_1
X_4017_ _5010_/A1 _4017_/A2 _4017_/B1 _4017_/B2 VGND VGND VPWR VPWR _5108_/D sky130_fd_sc_hd__a22o_2
XFILLER_65_570 VGND VGND VPWR VPWR sky130_fd_sc_hd__decap_3
X_5968_ _6064_/CLK _5968_/D VGND VGND VPWR VPWR _5968_/Q sky130_fd_sc_hd__dfxtp_2
X_4919_ _5021_/A1 _4936_/A2 wire133/A _4919_/B2 VGND VGND VPWR VPWR _5949_/D sky130_fd_sc_hd__a22o_2
XFILLER_21_651 VGND VGND VPWR VPWR sky130_fd_sc_hd__decap_3
XFILLER_21_673 VGND VGND VPWR VPWR sky130_fd_sc_hd__decap_3
X_5899_ _5963_/CLK _5899_/D VGND VGND VPWR VPWR _5899_/Q sky130_fd_sc_hd__dfxtp_2
XFILLER_20_183 VGND VGND VPWR VPWR sky130_fd_sc_hd__decap_3
XFILLER_106_244 VGND VGND VPWR VPWR sky130_fd_sc_hd__decap_3
XFILLER_79_106 VGND VGND VPWR VPWR sky130_fd_sc_hd__decap_3
XFILLER_106_288 VGND VGND VPWR VPWR sky130_fd_sc_hd__decap_3
XFILLER_79_128 VGND VGND VPWR VPWR sky130_fd_sc_hd__decap_3
XTAP_TAPCELL_ROW_91_1339 VGND VPWR sky130_fd_sc_hd__tapvpwrvgnd_1
XFILLER_0_533 VGND VGND VPWR VPWR sky130_fd_sc_hd__fill_1
XFILLER_88_640 VGND VGND VPWR VPWR sky130_fd_sc_hd__decap_3
XFILLER_88_662 VGND VGND VPWR VPWR sky130_fd_sc_hd__decap_3
XFILLER_87_172 VGND VGND VPWR VPWR sky130_fd_sc_hd__fill_1
XFILLER_102_483 VGND VGND VPWR VPWR sky130_fd_sc_hd__fill_1
XFILLER_75_334 VGND VGND VPWR VPWR sky130_fd_sc_hd__fill_2
XFILLER_113_60 VGND VGND VPWR VPWR sky130_fd_sc_hd__decap_3
XFILLER_56_592 VGND VGND VPWR VPWR sky130_fd_sc_hd__fill_2
XFILLER_90_315 VGND VGND VPWR VPWR sky130_fd_sc_hd__fill_1
XFILLER_113_93 VGND VGND VPWR VPWR sky130_fd_sc_hd__decap_3
XFILLER_43_231 VGND VGND VPWR VPWR sky130_fd_sc_hd__fill_1
XFILLER_73_53 VGND VGND VPWR VPWR sky130_fd_sc_hd__decap_3
XTAP_TAPCELL_ROW_100_1446 VGND VPWR sky130_fd_sc_hd__tapvpwrvgnd_1
XFILLER_12_684 VGND VGND VPWR VPWR sky130_fd_sc_hd__decap_3
XFILLER_7_132 VGND VGND VPWR VPWR sky130_fd_sc_hd__fill_2
XFILLER_7_165 VGND VGND VPWR VPWR sky130_fd_sc_hd__decap_3
XFILLER_8_677 VGND VGND VPWR VPWR sky130_fd_sc_hd__decap_3
XFILLER_98_61 VGND VGND VPWR VPWR sky130_fd_sc_hd__decap_3
XFILLER_98_72 VGND VGND VPWR VPWR sky130_fd_sc_hd__fill_1
XFILLER_98_94 VGND VGND VPWR VPWR sky130_fd_sc_hd__decap_3
XFILLER_3_393 VGND VGND VPWR VPWR sky130_fd_sc_hd__fill_2
XFILLER_79_640 VGND VGND VPWR VPWR sky130_fd_sc_hd__decap_3
X_3250_ _5688_/Q _5656_/Q _5624_/Q _5592_/Q _3863_/S _3866_/S1 VGND VGND VPWR VPWR
+ _3250_/X sky130_fd_sc_hd__mux4_2
XFILLER_66_301 VGND VGND VPWR VPWR sky130_fd_sc_hd__fill_1
XFILLER_78_150 VGND VGND VPWR VPWR sky130_fd_sc_hd__decap_3
XTAP_TAPCELL_ROW_111_1586 VGND VPWR sky130_fd_sc_hd__tapvpwrvgnd_1
X_3181_ _5429_/Q _5077_/Q _3182_/S VGND VGND VPWR VPWR _3181_/X sky130_fd_sc_hd__mux2_1
XFILLER_14_3 VGND VGND VPWR VPWR sky130_fd_sc_hd__decap_3
XFILLER_78_183 VGND VGND VPWR VPWR sky130_fd_sc_hd__decap_3
XFILLER_81_337 VGND VGND VPWR VPWR sky130_fd_sc_hd__fill_2
XFILLER_93_175 VGND VGND VPWR VPWR sky130_fd_sc_hd__decap_3
XFILLER_93_197 VGND VGND VPWR VPWR sky130_fd_sc_hd__decap_3
XTAP_TAPCELL_ROW_66_1043 VGND VPWR sky130_fd_sc_hd__tapvpwrvgnd_1
XFILLER_34_253 VGND VGND VPWR VPWR sky130_fd_sc_hd__fill_2
XTAP_TAPCELL_ROW_17_451 VGND VPWR sky130_fd_sc_hd__tapvpwrvgnd_1
X_5822_ _5922_/CLK _5822_/D VGND VGND VPWR VPWR _5822_/Q sky130_fd_sc_hd__dfxtp_2
XTAP_TAPCELL_ROW_45_793 VGND VPWR sky130_fd_sc_hd__tapvpwrvgnd_1
X_5753_ _6041_/CLK _5753_/D VGND VGND VPWR VPWR _5753_/Q sky130_fd_sc_hd__dfxtp_2
X_4704_ _4773_/A1 _4706_/A2 _4706_/B1 _4704_/B2 VGND VGND VPWR VPWR _5747_/D sky130_fd_sc_hd__a22o_2
X_2965_ _5196_/Q _5164_/Q _2980_/S VGND VGND VPWR VPWR _2965_/X sky130_fd_sc_hd__mux2_1
X_5684_ _5812_/CLK _5684_/D VGND VGND VPWR VPWR _5684_/Q sky130_fd_sc_hd__dfxtp_2
X_2896_ _5257_/Q _5225_/Q _2896_/S VGND VGND VPWR VPWR _2896_/X sky130_fd_sc_hd__mux2_1
XFILLER_8_81 VGND VGND VPWR VPWR sky130_fd_sc_hd__decap_3
X_4635_ _4772_/A1 _4640_/A2 _4640_/B1 _4635_/B2 VGND VGND VPWR VPWR _5682_/D sky130_fd_sc_hd__a22o_2
X_4566_ _4771_/A1 _4566_/A2 _4566_/B1 _4566_/B2 VGND VGND VPWR VPWR _5617_/D sky130_fd_sc_hd__a22o_2
XTAP_TAPCELL_ROW_77_1172 VGND VPWR sky130_fd_sc_hd__tapvpwrvgnd_1
X_3517_ _5924_/Q _5892_/Q _5860_/Q _5764_/Q _3858_/S _3868_/S1 VGND VGND VPWR VPWR
+ _3518_/B sky130_fd_sc_hd__mux4_2
X_4497_ _4531_/A1 _4503_/A2 _4503_/B1 _4497_/B2 VGND VGND VPWR VPWR _5553_/D sky130_fd_sc_hd__a22o_2
Xhold2001 _5303_/Q VGND VGND VPWR VPWR _4229_/B2 sky130_fd_sc_hd__dlygate4sd3_1
Xhold2012 _5138_/Q VGND VGND VPWR VPWR _4050_/B2 sky130_fd_sc_hd__dlygate4sd3_1
X_3448_ _3454_/A _3448_/B VGND VGND VPWR VPWR _3448_/X sky130_fd_sc_hd__or2_2
Xhold1300 _5646_/Q VGND VGND VPWR VPWR _4597_/B2 sky130_fd_sc_hd__dlygate4sd3_1
Xhold2023 _5719_/Q VGND VGND VPWR VPWR _4674_/B2 sky130_fd_sc_hd__dlygate4sd3_1
Xhold2034 _5915_/Q VGND VGND VPWR VPWR _4883_/B2 sky130_fd_sc_hd__dlygate4sd3_1
Xhold2045 _5576_/Q VGND VGND VPWR VPWR _4522_/B2 sky130_fd_sc_hd__dlygate4sd3_1
X_3379_ _5566_/Q _5534_/Q _3379_/S VGND VGND VPWR VPWR _3379_/X sky130_fd_sc_hd__mux2_1
XFILLER_57_334 VGND VGND VPWR VPWR sky130_fd_sc_hd__fill_2
Xhold1311 _5800_/Q VGND VGND VPWR VPWR _4762_/B2 sky130_fd_sc_hd__dlygate4sd3_1
Xhold1322 _5868_/Q VGND VGND VPWR VPWR _4832_/B2 sky130_fd_sc_hd__dlygate4sd3_1
Xhold1333 _6028_/Q VGND VGND VPWR VPWR _5002_/B2 sky130_fd_sc_hd__dlygate4sd3_1
Xhold2056 _5778_/Q VGND VGND VPWR VPWR _4738_/B2 sky130_fd_sc_hd__dlygate4sd3_1
Xhold2067 _5889_/Q VGND VGND VPWR VPWR _4855_/B2 sky130_fd_sc_hd__dlygate4sd3_1
Xhold2078 _5055_/Q VGND VGND VPWR VPWR _3959_/B2 sky130_fd_sc_hd__dlygate4sd3_1
X_5118_ _5986_/CLK _5118_/D VGND VGND VPWR VPWR _5118_/Q sky130_fd_sc_hd__dfxtp_2
XFILLER_27_24 VGND VGND VPWR VPWR sky130_fd_sc_hd__decap_3
XFILLER_85_676 VGND VGND VPWR VPWR sky130_fd_sc_hd__decap_3
Xhold1344 _5316_/Q VGND VGND VPWR VPWR _4244_/B2 sky130_fd_sc_hd__dlygate4sd3_1
Xhold1355 _5978_/Q VGND VGND VPWR VPWR _4950_/B2 sky130_fd_sc_hd__dlygate4sd3_1
Xhold1366 _5981_/Q VGND VGND VPWR VPWR _4953_/B2 sky130_fd_sc_hd__dlygate4sd3_1
Xhold1377 _5465_/Q VGND VGND VPWR VPWR _4405_/B2 sky130_fd_sc_hd__dlygate4sd3_1
Xhold2089 _5399_/Q VGND VGND VPWR VPWR _4331_/B2 sky130_fd_sc_hd__dlygate4sd3_1
XFILLER_84_197 VGND VGND VPWR VPWR sky130_fd_sc_hd__decap_3
Xhold1388 _5413_/Q VGND VGND VPWR VPWR _4347_/B2 sky130_fd_sc_hd__dlygate4sd3_1
Xhold1399 _5121_/Q VGND VGND VPWR VPWR _4033_/B2 sky130_fd_sc_hd__dlygate4sd3_1
X_5049_ _5692_/CLK _5049_/D VGND VGND VPWR VPWR _5049_/Q sky130_fd_sc_hd__dfxtp_2
XFILLER_25_220 VGND VGND VPWR VPWR sky130_fd_sc_hd__decap_3
XFILLER_40_212 VGND VGND VPWR VPWR sky130_fd_sc_hd__fill_1
XFILLER_40_289 VGND VGND VPWR VPWR sky130_fd_sc_hd__fill_2
XFILLER_107_520 VGND VGND VPWR VPWR sky130_fd_sc_hd__decap_3
XFILLER_5_647 VGND VGND VPWR VPWR sky130_fd_sc_hd__decap_3
XFILLER_107_564 VGND VGND VPWR VPWR sky130_fd_sc_hd__decap_3
XFILLER_4_135 VGND VGND VPWR VPWR sky130_fd_sc_hd__decap_3
XFILLER_108_71 VGND VGND VPWR VPWR sky130_fd_sc_hd__decap_3
XFILLER_68_53 VGND VGND VPWR VPWR sky130_fd_sc_hd__decap_3
XFILLER_67_109 VGND VGND VPWR VPWR sky130_fd_sc_hd__decap_3
XFILLER_95_418 VGND VGND VPWR VPWR sky130_fd_sc_hd__decap_3
XFILLER_95_429 VGND VGND VPWR VPWR sky130_fd_sc_hd__fill_2
XFILLER_76_687 VGND VGND VPWR VPWR sky130_fd_sc_hd__fill_1
XFILLER_63_337 VGND VGND VPWR VPWR sky130_fd_sc_hd__fill_1
XFILLER_91_624 VGND VGND VPWR VPWR sky130_fd_sc_hd__decap_3
XFILLER_84_85 VGND VGND VPWR VPWR sky130_fd_sc_hd__decap_3
XFILLER_16_253 VGND VGND VPWR VPWR sky130_fd_sc_hd__fill_2
XFILLER_16_286 VGND VGND VPWR VPWR sky130_fd_sc_hd__decap_3
XFILLER_31_212 VGND VGND VPWR VPWR sky130_fd_sc_hd__decap_3
XTAP_TAPCELL_ROW_14_421 VGND VPWR sky130_fd_sc_hd__tapvpwrvgnd_1
XTAP_TAPCELL_ROW_42_752 VGND VPWR sky130_fd_sc_hd__tapvpwrvgnd_1
XFILLER_83_6 VGND VGND VPWR VPWR sky130_fd_sc_hd__decap_3
X_2750_ wire647/X _2748_/X _2749_/X _3111_/B2 VGND VGND VPWR VPWR _2750_/X sky130_fd_sc_hd__o22a_2
X_2681_ _3106_/C1 _2677_/X _2680_/X _2675_/X VGND VGND VPWR VPWR _2681_/X sky130_fd_sc_hd__a31o_2
XFILLER_8_474 VGND VGND VPWR VPWR sky130_fd_sc_hd__fill_2
X_4420_ _4659_/A1 _4433_/A2 _4433_/B1 _4420_/B2 VGND VGND VPWR VPWR _5480_/D sky130_fd_sc_hd__a22o_2
XTAP_TAPCELL_ROW_113_1604 VGND VPWR sky130_fd_sc_hd__tapvpwrvgnd_1
X_4351_ _4999_/A1 wire462/X wire242/X _4351_/B2 VGND VGND VPWR VPWR _5417_/D sky130_fd_sc_hd__a22o_2
XFILLER_98_234 VGND VGND VPWR VPWR sky130_fd_sc_hd__fill_1
Xfanout409 _4607_/Y VGND VGND VPWR VPWR _4625_/A2 sky130_fd_sc_hd__clkdlybuf4s25_1
X_4282_ _5032_/A1 _4295_/A2 _4295_/B1 _4282_/B2 VGND VGND VPWR VPWR _5352_/D sky130_fd_sc_hd__a22o_2
X_3302_ _3305_/A _3298_/X _3301_/X _3898_/A1 VGND VGND VPWR VPWR _3302_/X sky130_fd_sc_hd__o211a_2
XFILLER_100_206 VGND VGND VPWR VPWR sky130_fd_sc_hd__decap_3
XFILLER_113_578 VGND VGND VPWR VPWR sky130_fd_sc_hd__decap_3
XFILLER_86_429 VGND VGND VPWR VPWR sky130_fd_sc_hd__decap_3
X_6021_ _6021_/CLK _6021_/D VGND VGND VPWR VPWR _6021_/Q sky130_fd_sc_hd__dfxtp_2
X_3233_ _3239_/B _3234_/B VGND VGND VPWR VPWR _3233_/Y sky130_fd_sc_hd__nor2_4
XFILLER_104_18 VGND VGND VPWR VPWR sky130_fd_sc_hd__decap_3
XFILLER_67_643 VGND VGND VPWR VPWR sky130_fd_sc_hd__decap_3
XFILLER_104_29 VGND VGND VPWR VPWR sky130_fd_sc_hd__fill_1
XFILLER_39_345 VGND VGND VPWR VPWR sky130_fd_sc_hd__fill_1
XFILLER_67_676 VGND VGND VPWR VPWR sky130_fd_sc_hd__decap_3
X_3164_ _5397_/Q _5365_/Q _5333_/Q _5301_/Q _3166_/S _3164_/S1 VGND VGND VPWR VPWR
+ _3164_/X sky130_fd_sc_hd__mux4_2
XFILLER_39_389 VGND VGND VPWR VPWR sky130_fd_sc_hd__decap_3
XFILLER_66_186 VGND VGND VPWR VPWR sky130_fd_sc_hd__decap_3
X_3095_ _3081_/A _3091_/X _3094_/X _3223_/C1 VGND VGND VPWR VPWR _3095_/X sky130_fd_sc_hd__o211a_2
XFILLER_66_197 VGND VGND VPWR VPWR sky130_fd_sc_hd__decap_3
XFILLER_22_223 VGND VGND VPWR VPWR sky130_fd_sc_hd__decap_3
XFILLER_35_595 VGND VGND VPWR VPWR sky130_fd_sc_hd__decap_3
XFILLER_13_15 VGND VGND VPWR VPWR sky130_fd_sc_hd__fill_1
X_5805_ _5805_/CLK _5805_/D VGND VGND VPWR VPWR _5805_/Q sky130_fd_sc_hd__dfxtp_2
X_3997_ _4514_/A1 _4005_/A2 _4005_/B1 _3997_/B2 VGND VGND VPWR VPWR _5088_/D sky130_fd_sc_hd__a22o_2
XFILLER_10_418 VGND VGND VPWR VPWR sky130_fd_sc_hd__fill_2
XFILLER_22_289 VGND VGND VPWR VPWR sky130_fd_sc_hd__fill_2
XFILLER_50_587 VGND VGND VPWR VPWR sky130_fd_sc_hd__fill_1
X_5736_ _5800_/CLK _5736_/D VGND VGND VPWR VPWR _5736_/Q sky130_fd_sc_hd__dfxtp_2
X_2948_ _5195_/Q _5163_/Q _3069_/S VGND VGND VPWR VPWR _2948_/X sky130_fd_sc_hd__mux2_1
XFILLER_108_306 VGND VGND VPWR VPWR sky130_fd_sc_hd__fill_2
XTAP_TAPCELL_ROW_79_1201 VGND VPWR sky130_fd_sc_hd__tapvpwrvgnd_1
X_5667_ _6048_/CLK _5667_/D VGND VGND VPWR VPWR _5667_/Q sky130_fd_sc_hd__dfxtp_2
X_4618_ _4755_/A1 _4634_/A2 _4634_/B1 _4618_/B2 VGND VGND VPWR VPWR _5665_/D sky130_fd_sc_hd__a22o_2
X_2879_ _5576_/Q _5544_/Q _3166_/S VGND VGND VPWR VPWR _2879_/X sky130_fd_sc_hd__mux2_1
X_5598_ _5790_/CLK _5598_/D VGND VGND VPWR VPWR _5598_/Q sky130_fd_sc_hd__dfxtp_2
XFILLER_104_523 VGND VGND VPWR VPWR sky130_fd_sc_hd__fill_1
XFILLER_2_628 VGND VGND VPWR VPWR sky130_fd_sc_hd__decap_3
X_4549_ _5024_/A1 wire421/X _4563_/B1 _4549_/B2 VGND VGND VPWR VPWR _5600_/D sky130_fd_sc_hd__a22o_2
Xfanout943 input29/X VGND VGND VPWR VPWR _5036_/A1 sky130_fd_sc_hd__clkdlybuf4s25_1
Xfanout932 input32/X VGND VGND VPWR VPWR _5039_/A1 sky130_fd_sc_hd__clkdlybuf4s25_1
Xfanout921 input35/X VGND VGND VPWR VPWR _4601_/A1 sky130_fd_sc_hd__clkdlybuf4s25_1
Xfanout910 _4534_/A1 VGND VGND VPWR VPWR _5044_/A1 sky130_fd_sc_hd__clkdlybuf4s25_1
XFILLER_38_45 VGND VGND VPWR VPWR sky130_fd_sc_hd__fill_1
Xfanout976 _4994_/A1 VGND VGND VPWR VPWR _4312_/A1 sky130_fd_sc_hd__clkdlybuf4s25_1
Xfanout965 input23/X VGND VGND VPWR VPWR _5031_/A1 sky130_fd_sc_hd__clkdlybuf4s25_1
Xfanout954 input26/X VGND VGND VPWR VPWR _5034_/A1 sky130_fd_sc_hd__clkdlybuf4s25_1
XFILLER_57_142 VGND VGND VPWR VPWR sky130_fd_sc_hd__decap_3
Xfanout987 input18/X VGND VGND VPWR VPWR _5026_/A1 sky130_fd_sc_hd__clkdlybuf4s25_1
Xfanout998 _5015_/A VGND VGND VPWR VPWR _4879_/A sky130_fd_sc_hd__clkdlybuf4s25_1
Xhold1141 _5650_/Q VGND VGND VPWR VPWR _4601_/B2 sky130_fd_sc_hd__dlygate4sd3_1
XFILLER_57_175 VGND VGND VPWR VPWR sky130_fd_sc_hd__fill_2
XFILLER_57_186 VGND VGND VPWR VPWR sky130_fd_sc_hd__fill_1
XFILLER_58_687 VGND VGND VPWR VPWR sky130_fd_sc_hd__fill_1
XFILLER_72_112 VGND VGND VPWR VPWR sky130_fd_sc_hd__decap_3
Xhold1152 _5327_/Q VGND VGND VPWR VPWR _4255_/B2 sky130_fd_sc_hd__dlygate4sd3_1
Xhold1163 _5863_/Q VGND VGND VPWR VPWR _4827_/B2 sky130_fd_sc_hd__dlygate4sd3_1
Xhold1174 _5191_/Q VGND VGND VPWR VPWR _4110_/B2 sky130_fd_sc_hd__dlygate4sd3_1
Xhold1185 _6021_/Q VGND VGND VPWR VPWR _4995_/B2 sky130_fd_sc_hd__dlygate4sd3_1
XFILLER_54_11 VGND VGND VPWR VPWR sky130_fd_sc_hd__fill_1
XFILLER_73_668 VGND VGND VPWR VPWR sky130_fd_sc_hd__decap_3
Xhold1196 _5634_/Q VGND VGND VPWR VPWR _4585_/B2 sky130_fd_sc_hd__dlygate4sd3_1
XFILLER_54_55 VGND VGND VPWR VPWR sky130_fd_sc_hd__decap_3
XFILLER_72_156 VGND VGND VPWR VPWR sky130_fd_sc_hd__decap_3
XFILLER_26_595 VGND VGND VPWR VPWR sky130_fd_sc_hd__fill_1
XFILLER_41_521 VGND VGND VPWR VPWR sky130_fd_sc_hd__fill_1
XFILLER_54_88 VGND VGND VPWR VPWR sky130_fd_sc_hd__fill_1
XFILLER_110_50 VGND VGND VPWR VPWR sky130_fd_sc_hd__decap_3
XFILLER_13_245 VGND VGND VPWR VPWR sky130_fd_sc_hd__decap_3
XFILLER_110_83 VGND VGND VPWR VPWR sky130_fd_sc_hd__fill_1
XFILLER_110_94 VGND VGND VPWR VPWR sky130_fd_sc_hd__decap_3
XFILLER_41_587 VGND VGND VPWR VPWR sky130_fd_sc_hd__decap_3
Xclkload19 _5691_/CLK VGND VGND VPWR VPWR clkload19/Y sky130_fd_sc_hd__clkinvlp_4
XFILLER_114_309 VGND VGND VPWR VPWR sky130_fd_sc_hd__fill_2
XFILLER_5_477 VGND VGND VPWR VPWR sky130_fd_sc_hd__fill_1
XFILLER_79_63 VGND VGND VPWR VPWR sky130_fd_sc_hd__decap_3
XFILLER_110_504 VGND VGND VPWR VPWR sky130_fd_sc_hd__decap_3
XFILLER_1_650 VGND VGND VPWR VPWR sky130_fd_sc_hd__decap_3
XFILLER_68_429 VGND VGND VPWR VPWR sky130_fd_sc_hd__decap_3
XFILLER_95_215 VGND VGND VPWR VPWR sky130_fd_sc_hd__decap_3
XFILLER_110_526 VGND VGND VPWR VPWR sky130_fd_sc_hd__decap_3
XFILLER_49_643 VGND VGND VPWR VPWR sky130_fd_sc_hd__decap_3
XFILLER_0_193 VGND VGND VPWR VPWR sky130_fd_sc_hd__decap_3
XFILLER_49_654 VGND VGND VPWR VPWR sky130_fd_sc_hd__fill_2
XFILLER_49_687 VGND VGND VPWR VPWR sky130_fd_sc_hd__fill_1
XTAP_TAPCELL_ROW_47_811 VGND VPWR sky130_fd_sc_hd__tapvpwrvgnd_1
XFILLER_64_668 VGND VGND VPWR VPWR sky130_fd_sc_hd__fill_2
XFILLER_63_156 VGND VGND VPWR VPWR sky130_fd_sc_hd__decap_3
XFILLER_63_178 VGND VGND VPWR VPWR sky130_fd_sc_hd__decap_3
X_3920_ _3920_/A _3920_/B VGND VGND VPWR VPWR _3920_/X sky130_fd_sc_hd__or2_2
XFILLER_32_521 VGND VGND VPWR VPWR sky130_fd_sc_hd__decap_3
XTAP_TAPCELL_ROW_63_1002 VGND VPWR sky130_fd_sc_hd__tapvpwrvgnd_1
XPHY_EDGE_ROW_4_Left_120 VGND VGND VPWR VPWR sky130_fd_sc_hd__decap_3
X_3851_ _5203_/Q _5171_/Q _3851_/S VGND VGND VPWR VPWR _3851_/X sky130_fd_sc_hd__mux2_1
XFILLER_81_3 VGND VGND VPWR VPWR sky130_fd_sc_hd__decap_3
X_3782_ _5936_/Q _5904_/Q _5872_/Q _5776_/Q _3785_/S _3788_/S1 VGND VGND VPWR VPWR
+ _3782_/X sky130_fd_sc_hd__mux4_2
X_2802_ _3147_/A1 _2799_/X _2801_/X VGND VGND VPWR VPWR _2802_/X sky130_fd_sc_hd__a21o_2
X_5521_ _5713_/CLK _5521_/D VGND VGND VPWR VPWR _5521_/Q sky130_fd_sc_hd__dfxtp_2
X_2733_ _2936_/A1 _2731_/X _2732_/X _3222_/B2 VGND VGND VPWR VPWR _2733_/X sky130_fd_sc_hd__o22a_2
XFILLER_8_282 VGND VGND VPWR VPWR sky130_fd_sc_hd__fill_1
X_5452_ _5932_/CLK _5452_/D VGND VGND VPWR VPWR _5452_/Q sky130_fd_sc_hd__dfxtp_2
X_2664_ _3118_/A1 _2647_/X _2663_/X _3118_/B2 VGND VGND VPWR VPWR _2664_/X sky130_fd_sc_hd__a22o_2
X_5383_ _5514_/CLK _5383_/D VGND VGND VPWR VPWR _5383_/Q sky130_fd_sc_hd__dfxtp_2
X_4403_ _4437_/A _4403_/B VGND VGND VPWR VPWR _4403_/Y sky130_fd_sc_hd__nor2_2
X_2595_ _2987_/A _2591_/X _2594_/X _3106_/C1 VGND VGND VPWR VPWR _2595_/X sky130_fd_sc_hd__o211a_2
XFILLER_5_60 VGND VGND VPWR VPWR sky130_fd_sc_hd__decap_3
XTAP_TAPCELL_ROW_74_1142 VGND VPWR sky130_fd_sc_hd__tapvpwrvgnd_1
X_4334_ _5016_/A1 wire462/A wire242/X _4334_/B2 VGND VGND VPWR VPWR _5400_/D sky130_fd_sc_hd__a22o_2
XFILLER_99_587 VGND VGND VPWR VPWR sky130_fd_sc_hd__decap_3
Xfanout228 fanout232/X VGND VGND VPWR VPWR _4433_/B1 sky130_fd_sc_hd__clkdlybuf4s25_1
Xfanout217 _4471_/Y VGND VGND VPWR VPWR _4503_/B1 sky130_fd_sc_hd__clkdlybuf4s25_1
Xfanout206 _4505_/Y VGND VGND VPWR VPWR _4528_/B1 sky130_fd_sc_hd__clkdlybuf4s25_1
Xfanout239 _4368_/Y VGND VGND VPWR VPWR _4385_/B1 sky130_fd_sc_hd__clkdlybuf4s25_1
X_6004_ _6036_/CLK _6004_/D VGND VGND VPWR VPWR _6004_/Q sky130_fd_sc_hd__dfxtp_2
X_4265_ _4745_/A _4265_/B VGND VGND VPWR VPWR _4265_/Y sky130_fd_sc_hd__nor2_2
XFILLER_39_142 VGND VGND VPWR VPWR sky130_fd_sc_hd__decap_3
XFILLER_55_602 VGND VGND VPWR VPWR sky130_fd_sc_hd__decap_3
X_4196_ _4946_/B _4298_/B VGND VGND VPWR VPWR _4196_/Y sky130_fd_sc_hd__nor2_2
X_3216_ _5431_/Q _5079_/Q _3217_/S VGND VGND VPWR VPWR _3216_/X sky130_fd_sc_hd__mux2_1
XFILLER_39_186 VGND VGND VPWR VPWR sky130_fd_sc_hd__fill_2
XFILLER_55_613 VGND VGND VPWR VPWR sky130_fd_sc_hd__decap_3
X_3147_ _3147_/A1 _3144_/X _3146_/X VGND VGND VPWR VPWR _3147_/X sky130_fd_sc_hd__a21o_2
XFILLER_27_348 VGND VGND VPWR VPWR sky130_fd_sc_hd__decap_3
XFILLER_82_432 VGND VGND VPWR VPWR sky130_fd_sc_hd__fill_1
XFILLER_70_627 VGND VGND VPWR VPWR sky130_fd_sc_hd__decap_3
X_3078_ _3094_/A1 _3076_/X _3077_/X _3094_/B2 VGND VGND VPWR VPWR _3078_/X sky130_fd_sc_hd__o22a_2
XTAP_TAPCELL_ROW_25_549 VGND VPWR sky130_fd_sc_hd__tapvpwrvgnd_1
XTAP_TAPCELL_ROW_85_1271 VGND VPWR sky130_fd_sc_hd__tapvpwrvgnd_1
XPHY_EDGE_ROW_59_Left_175 VGND VGND VPWR VPWR sky130_fd_sc_hd__decap_3
XFILLER_23_587 VGND VGND VPWR VPWR sky130_fd_sc_hd__decap_3
XFILLER_109_604 VGND VGND VPWR VPWR sky130_fd_sc_hd__decap_3
XFILLER_6_208 VGND VGND VPWR VPWR sky130_fd_sc_hd__fill_1
XFILLER_109_648 VGND VGND VPWR VPWR sky130_fd_sc_hd__decap_3
X_5719_ _5815_/CLK _5719_/D VGND VGND VPWR VPWR _5719_/Q sky130_fd_sc_hd__dfxtp_2
XPHY_EDGE_ROW_68_Left_184 VGND VGND VPWR VPWR sky130_fd_sc_hd__decap_3
XFILLER_49_55 VGND VGND VPWR VPWR sky130_fd_sc_hd__fill_1
Xfanout751 input8/X VGND VGND VPWR VPWR _3228_/A1 sky130_fd_sc_hd__buf_6
Xfanout740 _2492_/Y VGND VGND VPWR VPWR _3206_/A1 sky130_fd_sc_hd__dlymetal6s4s_1
XFILLER_1_18 VGND VGND VPWR VPWR sky130_fd_sc_hd__decap_3
Xfanout773 _2979_/S1 VGND VGND VPWR VPWR _3225_/S1 sky130_fd_sc_hd__clkdlybuf4s25_1
Xfanout762 fanout765/X VGND VGND VPWR VPWR _3113_/S1 sky130_fd_sc_hd__clkdlybuf4s25_1
XFILLER_105_72 VGND VGND VPWR VPWR sky130_fd_sc_hd__decap_3
Xfanout795 fanout822/X VGND VGND VPWR VPWR _3026_/S sky130_fd_sc_hd__dlymetal6s2s_1
XFILLER_100_592 VGND VGND VPWR VPWR sky130_fd_sc_hd__decap_3
XFILLER_46_668 VGND VGND VPWR VPWR sky130_fd_sc_hd__fill_2
XFILLER_65_54 VGND VGND VPWR VPWR sky130_fd_sc_hd__fill_2
XFILLER_85_281 VGND VGND VPWR VPWR sky130_fd_sc_hd__decap_3
XFILLER_61_649 VGND VGND VPWR VPWR sky130_fd_sc_hd__decap_3
XPHY_EDGE_ROW_77_Left_193 VGND VGND VPWR VPWR sky130_fd_sc_hd__decap_3
XFILLER_14_91 VGND VGND VPWR VPWR sky130_fd_sc_hd__decap_3
XFILLER_115_607 VGND VGND VPWR VPWR sky130_fd_sc_hd__decap_3
XFILLER_108_681 VGND VGND VPWR VPWR sky130_fd_sc_hd__decap_3
XFILLER_114_106 VGND VGND VPWR VPWR sky130_fd_sc_hd__decap_3
XFILLER_115_629 VGND VGND VPWR VPWR sky130_fd_sc_hd__decap_3
XFILLER_114_128 VGND VGND VPWR VPWR sky130_fd_sc_hd__fill_2
XFILLER_46_6 VGND VGND VPWR VPWR sky130_fd_sc_hd__fill_1
X_4050_ _5008_/A1 _4050_/A2 _4050_/B1 _4050_/B2 VGND VGND VPWR VPWR _5138_/D sky130_fd_sc_hd__a22o_2
XFILLER_83_207 VGND VGND VPWR VPWR sky130_fd_sc_hd__fill_1
Xinput6 rs1[0] VGND VGND VPWR VPWR input6/X sky130_fd_sc_hd__clkbuf_2
X_3001_ _5933_/Q _5901_/Q _5869_/Q _5773_/Q _2988_/S _3102_/S1 VGND VGND VPWR VPWR
+ _3001_/X sky130_fd_sc_hd__mux4_2
XTAP_TAPCELL_ROW_108_1547 VGND VPWR sky130_fd_sc_hd__tapvpwrvgnd_1
XFILLER_91_262 VGND VGND VPWR VPWR sky130_fd_sc_hd__fill_2
X_4952_ _4986_/A1 _4977_/A2 _4977_/B1 _4952_/B2 VGND VGND VPWR VPWR _5980_/D sky130_fd_sc_hd__a22o_2
X_4883_ _5019_/A1 _4907_/A2 wire139/A _4883_/B2 VGND VGND VPWR VPWR _5915_/D sky130_fd_sc_hd__a22o_2
X_3903_ _3806_/A _3900_/X _3902_/X _3927_/B2 VGND VGND VPWR VPWR _3903_/X sky130_fd_sc_hd__a22o_2
XTAP_TAPCELL_ROW_22_508 VGND VPWR sky130_fd_sc_hd__tapvpwrvgnd_1
XTAP_TAPCELL_ROW_22_519 VGND VPWR sky130_fd_sc_hd__tapvpwrvgnd_1
X_3834_ _3824_/X _3832_/X _3833_/X _3614_/A VGND VGND VPWR VPWR _3834_/X sky130_fd_sc_hd__o31a_2
XFILLER_9_580 VGND VGND VPWR VPWR sky130_fd_sc_hd__decap_3
X_3765_ _5935_/Q _5903_/Q _5871_/Q _5775_/Q _3767_/S _3870_/S1 VGND VGND VPWR VPWR
+ _3765_/X sky130_fd_sc_hd__mux4_2
X_5504_ _5525_/CLK _5504_/D VGND VGND VPWR VPWR _5504_/Q sky130_fd_sc_hd__dfxtp_2
X_3696_ _3687_/A _3691_/X _3694_/X _3695_/X VGND VGND VPWR VPWR _3696_/X sky130_fd_sc_hd__o211a_2
X_2716_ _2727_/A1 _2714_/X _2715_/X _2972_/A1 VGND VGND VPWR VPWR _2716_/X sky130_fd_sc_hd__o22a_2
X_5435_ _6043_/CLK _5435_/D VGND VGND VPWR VPWR _5435_/Q sky130_fd_sc_hd__dfxtp_2
X_2647_ _3184_/A1 _2644_/X _2646_/X VGND VGND VPWR VPWR _2647_/X sky130_fd_sc_hd__a21o_2
XFILLER_114_640 VGND VGND VPWR VPWR sky130_fd_sc_hd__decap_3
XFILLER_114_651 VGND VGND VPWR VPWR sky130_fd_sc_hd__decap_3
X_5366_ _6021_/CLK _5366_/D VGND VGND VPWR VPWR _5366_/Q sky130_fd_sc_hd__dfxtp_2
X_2578_ _5819_/Q _5435_/Q _2578_/S VGND VGND VPWR VPWR _2578_/X sky130_fd_sc_hd__mux2_1
XFILLER_101_323 VGND VGND VPWR VPWR sky130_fd_sc_hd__decap_3
XFILLER_114_684 VGND VGND VPWR VPWR sky130_fd_sc_hd__decap_3
XFILLER_87_546 VGND VGND VPWR VPWR sky130_fd_sc_hd__decap_3
X_5297_ _5713_/CLK _5297_/D VGND VGND VPWR VPWR _5297_/Q sky130_fd_sc_hd__dfxtp_2
X_4317_ _4660_/A1 _4327_/A2 wire248/X _4317_/B2 VGND VGND VPWR VPWR _5385_/D sky130_fd_sc_hd__a22o_2
XFILLER_101_334 VGND VGND VPWR VPWR sky130_fd_sc_hd__fill_2
XFILLER_19_14 VGND VGND VPWR VPWR sky130_fd_sc_hd__decap_3
X_4248_ _5032_/A1 _4261_/A2 _4261_/B1 _4248_/B2 VGND VGND VPWR VPWR _5320_/D sky130_fd_sc_hd__a22o_2
XFILLER_27_101 VGND VGND VPWR VPWR sky130_fd_sc_hd__decap_3
XFILLER_28_624 VGND VGND VPWR VPWR sky130_fd_sc_hd__decap_3
XFILLER_67_270 VGND VGND VPWR VPWR sky130_fd_sc_hd__fill_2
XFILLER_74_218 VGND VGND VPWR VPWR sky130_fd_sc_hd__fill_2
XFILLER_67_281 VGND VGND VPWR VPWR sky130_fd_sc_hd__decap_3
X_4179_ _4998_/A1 _4179_/A2 _4192_/B1 _4179_/B2 VGND VGND VPWR VPWR _5256_/D sky130_fd_sc_hd__a22o_2
XFILLER_82_240 VGND VGND VPWR VPWR sky130_fd_sc_hd__decap_3
XTAP_TAPCELL_ROW_2_277 VGND VPWR sky130_fd_sc_hd__tapvpwrvgnd_1
XPHY_EDGE_ROW_14_Right_14 VGND VGND VPWR VPWR sky130_fd_sc_hd__decap_3
Xwire437 _4471_/B VGND VGND VPWR VPWR wire437/X sky130_fd_sc_hd__clkbuf_4
Xwire459 wire459/A VGND VGND VPWR VPWR wire459/X sky130_fd_sc_hd__buf_4
XFILLER_105_662 VGND VGND VPWR VPWR sky130_fd_sc_hd__decap_3
XFILLER_105_673 VGND VGND VPWR VPWR sky130_fd_sc_hd__decap_3
XPHY_EDGE_ROW_23_Right_23 VGND VGND VPWR VPWR sky130_fd_sc_hd__decap_3
XFILLER_93_505 VGND VGND VPWR VPWR sky130_fd_sc_hd__decap_3
XFILLER_19_613 VGND VGND VPWR VPWR sky130_fd_sc_hd__decap_3
Xfanout592 _3239_/Y VGND VGND VPWR VPWR _3916_/A1 sky130_fd_sc_hd__dlymetal6s2s_1
XPHY_EDGE_ROW_85_Left_201 VGND VGND VPWR VPWR sky130_fd_sc_hd__decap_3
XFILLER_19_679 VGND VGND VPWR VPWR sky130_fd_sc_hd__fill_1
XFILLER_92_85 VGND VGND VPWR VPWR sky130_fd_sc_hd__fill_1
XPHY_EDGE_ROW_32_Right_32 VGND VGND VPWR VPWR sky130_fd_sc_hd__decap_3
XTAP_TAPCELL_ROW_103_1488 VGND VPWR sky130_fd_sc_hd__tapvpwrvgnd_1
XPHY_EDGE_ROW_94_Left_210 VGND VGND VPWR VPWR sky130_fd_sc_hd__decap_3
X_3550_ _3538_/X _3548_/X _3549_/X wire553/A VGND VGND VPWR VPWR _3550_/X sky130_fd_sc_hd__o31a_2
X_2501_ _5368_/Q _5336_/Q _5304_/Q _5272_/Q _2510_/S _3062_/S1 VGND VGND VPWR VPWR
+ _2501_/X sky130_fd_sc_hd__mux4_2
XFILLER_115_437 VGND VGND VPWR VPWR sky130_fd_sc_hd__decap_3
X_5220_ _6038_/CLK _5220_/D VGND VGND VPWR VPWR _5220_/Q sky130_fd_sc_hd__dfxtp_2
X_3481_ _3600_/S _3478_/X _3480_/X _3543_/B2 VGND VGND VPWR VPWR _3481_/X sky130_fd_sc_hd__o22a_2
XFILLER_69_502 VGND VGND VPWR VPWR sky130_fd_sc_hd__fill_2
XPHY_EDGE_ROW_41_Right_41 VGND VGND VPWR VPWR sky130_fd_sc_hd__decap_3
XTAP_TAPCELL_ROW_71_1101 VGND VPWR sky130_fd_sc_hd__tapvpwrvgnd_1
XFILLER_69_513 VGND VGND VPWR VPWR sky130_fd_sc_hd__fill_1
X_5151_ _5802_/CLK _5151_/D VGND VGND VPWR VPWR _5151_/Q sky130_fd_sc_hd__dfxtp_2
XFILLER_111_632 VGND VGND VPWR VPWR sky130_fd_sc_hd__decap_3
XFILLER_111_665 VGND VGND VPWR VPWR sky130_fd_sc_hd__decap_3
XFILLER_69_557 VGND VGND VPWR VPWR sky130_fd_sc_hd__decap_3
Xhold1707 _5071_/Q VGND VGND VPWR VPWR _3975_/B2 sky130_fd_sc_hd__dlygate4sd3_1
X_5082_ _6010_/CLK _5082_/D VGND VGND VPWR VPWR _5082_/Q sky130_fd_sc_hd__dfxtp_2
X_4102_ _4989_/A1 wire516/X wire298/X _4102_/B2 VGND VGND VPWR VPWR _5183_/D sky130_fd_sc_hd__a22o_2
XFILLER_111_676 VGND VGND VPWR VPWR sky130_fd_sc_hd__decap_3
XFILLER_2_50 VGND VGND VPWR VPWR sky130_fd_sc_hd__decap_3
XFILLER_84_527 VGND VGND VPWR VPWR sky130_fd_sc_hd__decap_3
Xhold1718 _6020_/Q VGND VGND VPWR VPWR _4994_/B2 sky130_fd_sc_hd__dlygate4sd3_1
Xhold1729 _5241_/Q VGND VGND VPWR VPWR _4164_/B2 sky130_fd_sc_hd__dlygate4sd3_1
X_4033_ _4515_/A1 wire533/X _4055_/B1 _4033_/B2 VGND VGND VPWR VPWR _5121_/D sky130_fd_sc_hd__a22o_2
XFILLER_110_197 VGND VGND VPWR VPWR sky130_fd_sc_hd__decap_3
XFILLER_49_281 VGND VGND VPWR VPWR sky130_fd_sc_hd__fill_1
XFILLER_112_29 VGND VGND VPWR VPWR sky130_fd_sc_hd__decap_3
XFILLER_37_465 VGND VGND VPWR VPWR sky130_fd_sc_hd__fill_2
XFILLER_64_251 VGND VGND VPWR VPWR sky130_fd_sc_hd__fill_1
XTAP_TAPCELL_ROW_55_909 VGND VPWR sky130_fd_sc_hd__tapvpwrvgnd_1
XFILLER_52_435 VGND VGND VPWR VPWR sky130_fd_sc_hd__fill_1
XFILLER_64_273 VGND VGND VPWR VPWR sky130_fd_sc_hd__decap_3
XFILLER_92_582 VGND VGND VPWR VPWR sky130_fd_sc_hd__decap_3
XPHY_EDGE_ROW_50_Right_50 VGND VGND VPWR VPWR sky130_fd_sc_hd__decap_3
XTAP_TAPCELL_ROW_69_1074 VGND VPWR sky130_fd_sc_hd__tapvpwrvgnd_1
X_5984_ _6030_/CLK _5984_/D VGND VGND VPWR VPWR _5984_/Q sky130_fd_sc_hd__dfxtp_2
XTAP_TAPCELL_ROW_82_1230 VGND VPWR sky130_fd_sc_hd__tapvpwrvgnd_1
XTAP_TAPCELL_ROW_35_666 VGND VPWR sky130_fd_sc_hd__tapvpwrvgnd_1
X_4935_ _5037_/A1 _4943_/A2 _4943_/B1 _4935_/B2 VGND VGND VPWR VPWR _5965_/D sky130_fd_sc_hd__a22o_2
XANTENNA_11 input11/X VGND VGND VPWR VPWR sky130_fd_sc_hd__diode_2
XANTENNA_22 _4179_/A2 VGND VGND VPWR VPWR sky130_fd_sc_hd__diode_2
X_4866_ _5036_/A1 wire367/X wire151/X _4866_/B2 VGND VGND VPWR VPWR _5900_/D sky130_fd_sc_hd__a22o_2
XANTENNA_33 input16/X VGND VGND VPWR VPWR sky130_fd_sc_hd__diode_2
XANTENNA_44 _4745_/B VGND VGND VPWR VPWR sky130_fd_sc_hd__diode_2
X_4797_ _4981_/A _4797_/B VGND VGND VPWR VPWR _5835_/D sky130_fd_sc_hd__and2b_2
X_3817_ _5202_/Q _5170_/Q _3818_/S VGND VGND VPWR VPWR _3817_/X sky130_fd_sc_hd__mux2_1
X_3748_ _3741_/X _3747_/X _3855_/B1 VGND VGND VPWR VPWR _3748_/X sky130_fd_sc_hd__o21a_2
XFILLER_115_9 VGND VGND VPWR VPWR sky130_fd_sc_hd__decap_3
XFILLER_106_448 VGND VGND VPWR VPWR sky130_fd_sc_hd__fill_1
X_3679_ _3261_/A _3662_/X _3667_/X _3678_/X wire630/X VGND VGND VPWR VPWR _3679_/X
+ sky130_fd_sc_hd__a32o_2
X_5418_ _5802_/CLK _5418_/D VGND VGND VPWR VPWR _5418_/Q sky130_fd_sc_hd__dfxtp_2
XTAP_TAPCELL_ROW_93_1370 VGND VPWR sky130_fd_sc_hd__tapvpwrvgnd_1
XTAP_TAPCELL_ROW_7_336 VGND VPWR sky130_fd_sc_hd__tapvpwrvgnd_1
X_5349_ _6000_/CLK _5349_/D VGND VGND VPWR VPWR _5349_/Q sky130_fd_sc_hd__dfxtp_2
XFILLER_87_332 VGND VGND VPWR VPWR sky130_fd_sc_hd__decap_3
XFILLER_87_354 VGND VGND VPWR VPWR sky130_fd_sc_hd__fill_2
XFILLER_47_218 VGND VGND VPWR VPWR sky130_fd_sc_hd__decap_3
XFILLER_75_505 VGND VGND VPWR VPWR sky130_fd_sc_hd__decap_3
XFILLER_101_186 VGND VGND VPWR VPWR sky130_fd_sc_hd__decap_3
XFILLER_101_197 VGND VGND VPWR VPWR sky130_fd_sc_hd__decap_3
XFILLER_46_56 VGND VGND VPWR VPWR sky130_fd_sc_hd__fill_1
XFILLER_43_468 VGND VGND VPWR VPWR sky130_fd_sc_hd__decap_3
XFILLER_62_11 VGND VGND VPWR VPWR sky130_fd_sc_hd__decap_3
XFILLER_24_682 VGND VGND VPWR VPWR sky130_fd_sc_hd__decap_3
XFILLER_62_88 VGND VGND VPWR VPWR sky130_fd_sc_hd__decap_3
Xclkbuf_leaf_50_clk clkload7/A VGND VGND VPWR VPWR _5825_/CLK sky130_fd_sc_hd__clkbuf_8
XFILLER_7_39 VGND VGND VPWR VPWR sky130_fd_sc_hd__decap_3
XFILLER_112_418 VGND VGND VPWR VPWR sky130_fd_sc_hd__fill_2
XFILLER_112_429 VGND VGND VPWR VPWR sky130_fd_sc_hd__fill_2
XFILLER_3_575 VGND VGND VPWR VPWR sky130_fd_sc_hd__fill_1
XFILLER_87_63 VGND VGND VPWR VPWR sky130_fd_sc_hd__fill_1
XFILLER_66_527 VGND VGND VPWR VPWR sky130_fd_sc_hd__decap_3
XFILLER_78_365 VGND VGND VPWR VPWR sky130_fd_sc_hd__decap_3
XFILLER_93_335 VGND VGND VPWR VPWR sky130_fd_sc_hd__fill_1
XFILLER_81_508 VGND VGND VPWR VPWR sky130_fd_sc_hd__fill_1
XFILLER_93_357 VGND VGND VPWR VPWR sky130_fd_sc_hd__decap_3
XFILLER_34_402 VGND VGND VPWR VPWR sky130_fd_sc_hd__fill_1
XFILLER_61_210 VGND VGND VPWR VPWR sky130_fd_sc_hd__fill_1
XTAP_TAPCELL_ROW_105_1506 VGND VPWR sky130_fd_sc_hd__tapvpwrvgnd_1
XFILLER_15_682 VGND VGND VPWR VPWR sky130_fd_sc_hd__decap_3
XFILLER_61_254 VGND VGND VPWR VPWR sky130_fd_sc_hd__decap_3
X_2981_ _5516_/Q _5484_/Q _2981_/S VGND VGND VPWR VPWR _2981_/X sky130_fd_sc_hd__mux2_1
XTAP_TAPCELL_ROW_32_636 VGND VPWR sky130_fd_sc_hd__tapvpwrvgnd_1
Xclkbuf_leaf_41_clk clkbuf_4_14_0_clk/X VGND VGND VPWR VPWR _5578_/CLK sky130_fd_sc_hd__clkbuf_8
X_4720_ _5024_/A1 wire386/A wire166/X _4720_/B2 VGND VGND VPWR VPWR _5760_/D sky130_fd_sc_hd__a22o_2
XTAP_TAPCELL_ROW_60_967 VGND VPWR sky130_fd_sc_hd__tapvpwrvgnd_1
X_4651_ _5024_/A1 wire400/X wire179/X _4651_/B2 VGND VGND VPWR VPWR _5696_/D sky130_fd_sc_hd__a22o_2
Xinput20 wd[12] VGND VGND VPWR VPWR input20/X sky130_fd_sc_hd__clkdlybuf4s25_1
Xinput31 wd[22] VGND VGND VPWR VPWR input31/X sky130_fd_sc_hd__clkdlybuf4s25_1
X_3602_ _3781_/C1 _3600_/X _3601_/X VGND VGND VPWR VPWR _3614_/B sky130_fd_sc_hd__a21o_2
XTAP_TAPCELL_ROW_12_393 VGND VPWR sky130_fd_sc_hd__tapvpwrvgnd_1
Xinput42 wd[3] VGND VGND VPWR VPWR input42/X sky130_fd_sc_hd__clkdlybuf4s25_1
X_4582_ _4753_/A1 _4595_/A2 _4600_/B1 _4582_/B2 VGND VGND VPWR VPWR _5631_/D sky130_fd_sc_hd__a22o_2
X_3533_ _3927_/B2 _3530_/X _3532_/X VGND VGND VPWR VPWR _3533_/X sky130_fd_sc_hd__a21o_2
XFILLER_107_18 VGND VGND VPWR VPWR sky130_fd_sc_hd__decap_3
X_3464_ _3462_/X _3463_/X wire553/A VGND VGND VPWR VPWR _3464_/X sky130_fd_sc_hd__o21a_2
X_5203_ _6037_/CLK _5203_/D VGND VGND VPWR VPWR _5203_/Q sky130_fd_sc_hd__dfxtp_2
XFILLER_97_641 VGND VGND VPWR VPWR sky130_fd_sc_hd__decap_3
XFILLER_97_652 VGND VGND VPWR VPWR sky130_fd_sc_hd__decap_3
X_5134_ _6019_/CLK _5134_/D VGND VGND VPWR VPWR _5134_/Q sky130_fd_sc_hd__dfxtp_2
X_3395_ _3388_/X _3394_/X _3614_/A VGND VGND VPWR VPWR _3395_/X sky130_fd_sc_hd__o21a_2
XFILLER_97_685 VGND VGND VPWR VPWR sky130_fd_sc_hd__decap_3
Xhold1504 _5908_/Q VGND VGND VPWR VPWR _4874_/B2 sky130_fd_sc_hd__dlygate4sd3_1
Xhold1515 _5287_/Q VGND VGND VPWR VPWR _4213_/B2 sky130_fd_sc_hd__dlygate4sd3_1
Xhold1526 _5493_/Q VGND VGND VPWR VPWR _4433_/B2 sky130_fd_sc_hd__dlygate4sd3_1
Xload_slew784 _2529_/S VGND VGND VPWR VPWR _2908_/S sky130_fd_sc_hd__clkbuf_4
XFILLER_57_549 VGND VGND VPWR VPWR sky130_fd_sc_hd__fill_2
XFILLER_84_335 VGND VGND VPWR VPWR sky130_fd_sc_hd__fill_1
Xhold1537 _5331_/Q VGND VGND VPWR VPWR _4259_/B2 sky130_fd_sc_hd__dlygate4sd3_1
Xhold1548 _5910_/Q VGND VGND VPWR VPWR _4876_/B2 sky130_fd_sc_hd__dlygate4sd3_1
Xhold1559 _5228_/Q VGND VGND VPWR VPWR _4149_/B2 sky130_fd_sc_hd__dlygate4sd3_1
X_5065_ _5692_/CLK _5065_/D VGND VGND VPWR VPWR _5065_/Q sky130_fd_sc_hd__dfxtp_2
XFILLER_37_240 VGND VGND VPWR VPWR sky130_fd_sc_hd__decap_3
X_4016_ _5009_/A1 _4018_/A2 _4018_/B1 _4016_/B2 VGND VGND VPWR VPWR _5107_/D sky130_fd_sc_hd__a22o_2
XFILLER_16_15 VGND VGND VPWR VPWR sky130_fd_sc_hd__decap_3
XFILLER_25_424 VGND VGND VPWR VPWR sky130_fd_sc_hd__decap_3
XFILLER_37_273 VGND VGND VPWR VPWR sky130_fd_sc_hd__decap_3
XFILLER_16_48 VGND VGND VPWR VPWR sky130_fd_sc_hd__decap_3
XFILLER_80_530 VGND VGND VPWR VPWR sky130_fd_sc_hd__fill_2
XFILLER_40_405 VGND VGND VPWR VPWR sky130_fd_sc_hd__decap_3
XFILLER_80_585 VGND VGND VPWR VPWR sky130_fd_sc_hd__decap_3
X_5967_ _6063_/CLK _5967_/D VGND VGND VPWR VPWR _5967_/Q sky130_fd_sc_hd__dfxtp_2
XFILLER_21_630 VGND VGND VPWR VPWR sky130_fd_sc_hd__decap_3
Xclkbuf_leaf_32_clk clkload5/A VGND VGND VPWR VPWR _5797_/CLK sky130_fd_sc_hd__clkbuf_8
X_4918_ _5020_/A1 _4941_/A2 wire133/X _4918_/B2 VGND VGND VPWR VPWR _5948_/D sky130_fd_sc_hd__a22o_2
X_5898_ _6060_/CLK _5898_/D VGND VGND VPWR VPWR _5898_/Q sky130_fd_sc_hd__dfxtp_2
XFILLER_21_685 VGND VGND VPWR VPWR sky130_fd_sc_hd__decap_3
X_4849_ _5019_/A1 _4873_/A2 wire146/A _4849_/B2 VGND VGND VPWR VPWR _5883_/D sky130_fd_sc_hd__a22o_2
XFILLER_0_501 VGND VGND VPWR VPWR sky130_fd_sc_hd__decap_3
XFILLER_106_278 VGND VGND VPWR VPWR sky130_fd_sc_hd__decap_3
Xclkbuf_leaf_99_clk clkbuf_4_0_0_clk/X VGND VGND VPWR VPWR _6035_/CLK sky130_fd_sc_hd__clkbuf_8
XFILLER_0_567 VGND VGND VPWR VPWR sky130_fd_sc_hd__fill_2
XFILLER_0_589 VGND VGND VPWR VPWR sky130_fd_sc_hd__decap_3
XFILLER_87_140 VGND VGND VPWR VPWR sky130_fd_sc_hd__decap_3
XFILLER_87_151 VGND VGND VPWR VPWR sky130_fd_sc_hd__decap_3
XFILLER_87_162 VGND VGND VPWR VPWR sky130_fd_sc_hd__decap_3
XFILLER_88_685 VGND VGND VPWR VPWR sky130_fd_sc_hd__decap_3
XFILLER_57_55 VGND VGND VPWR VPWR sky130_fd_sc_hd__fill_1
XFILLER_113_72 VGND VGND VPWR VPWR sky130_fd_sc_hd__decap_3
XFILLER_16_424 VGND VGND VPWR VPWR sky130_fd_sc_hd__decap_3
XFILLER_28_262 VGND VGND VPWR VPWR sky130_fd_sc_hd__decap_3
XFILLER_56_571 VGND VGND VPWR VPWR sky130_fd_sc_hd__decap_3
XFILLER_31_405 VGND VGND VPWR VPWR sky130_fd_sc_hd__fill_2
XFILLER_31_427 VGND VGND VPWR VPWR sky130_fd_sc_hd__decap_3
XFILLER_71_596 VGND VGND VPWR VPWR sky130_fd_sc_hd__decap_3
Xclkbuf_leaf_23_clk clkbuf_4_10_0_clk/X VGND VGND VPWR VPWR _5812_/CLK sky130_fd_sc_hd__clkbuf_8
XTAP_TAPCELL_ROW_100_1447 VGND VPWR sky130_fd_sc_hd__tapvpwrvgnd_1
XFILLER_22_91 VGND VGND VPWR VPWR sky130_fd_sc_hd__decap_3
XFILLER_98_40 VGND VGND VPWR VPWR sky130_fd_sc_hd__fill_1
XFILLER_98_405 VGND VGND VPWR VPWR sky130_fd_sc_hd__decap_3
XFILLER_98_438 VGND VGND VPWR VPWR sky130_fd_sc_hd__decap_3
XPHY_EDGE_ROW_13_Left_129 VGND VGND VPWR VPWR sky130_fd_sc_hd__decap_3
XFILLER_39_505 VGND VGND VPWR VPWR sky130_fd_sc_hd__decap_3
XFILLER_78_162 VGND VGND VPWR VPWR sky130_fd_sc_hd__decap_3
XFILLER_79_685 VGND VGND VPWR VPWR sky130_fd_sc_hd__decap_3
XTAP_TAPCELL_ROW_111_1576 VGND VPWR sky130_fd_sc_hd__tapvpwrvgnd_1
XTAP_TAPCELL_ROW_111_1587 VGND VPWR sky130_fd_sc_hd__tapvpwrvgnd_1
X_3180_ _5717_/Q _5685_/Q _5653_/Q _5621_/Q _3122_/S _3180_/S1 VGND VGND VPWR VPWR
+ _3180_/X sky130_fd_sc_hd__mux4_2
XFILLER_19_284 VGND VGND VPWR VPWR sky130_fd_sc_hd__fill_2
XFILLER_81_327 VGND VGND VPWR VPWR sky130_fd_sc_hd__fill_1
XFILLER_93_165 VGND VGND VPWR VPWR sky130_fd_sc_hd__decap_3
XTAP_TAPCELL_ROW_66_1044 VGND VPWR sky130_fd_sc_hd__tapvpwrvgnd_1
XTAP_TAPCELL_ROW_17_452 VGND VPWR sky130_fd_sc_hd__tapvpwrvgnd_1
X_5821_ _6045_/CLK _5821_/D VGND VGND VPWR VPWR _5821_/Q sky130_fd_sc_hd__dfxtp_2
XFILLER_22_449 VGND VGND VPWR VPWR sky130_fd_sc_hd__fill_2
XPHY_EDGE_ROW_22_Left_138 VGND VGND VPWR VPWR sky130_fd_sc_hd__decap_3
XTAP_TAPCELL_ROW_45_794 VGND VPWR sky130_fd_sc_hd__tapvpwrvgnd_1
X_5752_ _6040_/CLK _5752_/D VGND VGND VPWR VPWR _5752_/Q sky130_fd_sc_hd__dfxtp_2
X_2964_ _5260_/Q _5228_/Q _2980_/S VGND VGND VPWR VPWR _2964_/X sky130_fd_sc_hd__mux2_1
Xclkbuf_leaf_14_clk clkload4/A VGND VGND VPWR VPWR _5547_/CLK sky130_fd_sc_hd__clkbuf_8
X_4703_ _4772_/A1 _4703_/A2 _4703_/B1 _4703_/B2 VGND VGND VPWR VPWR _5746_/D sky130_fd_sc_hd__a22o_2
X_5683_ _5683_/CLK _5683_/D VGND VGND VPWR VPWR _5683_/Q sky130_fd_sc_hd__dfxtp_2
X_2895_ _5129_/Q _5097_/Q _6025_/Q _5993_/Q _2896_/S _3180_/S1 VGND VGND VPWR VPWR
+ _2895_/X sky130_fd_sc_hd__mux4_2
XFILLER_8_71 VGND VGND VPWR VPWR sky130_fd_sc_hd__fill_2
X_4634_ _4771_/A1 _4634_/A2 _4634_/B1 _4634_/B2 VGND VGND VPWR VPWR _5681_/D sky130_fd_sc_hd__a22o_2
X_4565_ _4904_/A1 _4571_/A2 _4571_/B1 _4565_/B2 VGND VGND VPWR VPWR _5616_/D sky130_fd_sc_hd__a22o_2
XTAP_TAPCELL_ROW_77_1173 VGND VPWR sky130_fd_sc_hd__tapvpwrvgnd_1
X_3516_ _3763_/A _3513_/X _3515_/X _3512_/X VGND VGND VPWR VPWR _3516_/X sky130_fd_sc_hd__o211a_2
XPHY_EDGE_ROW_31_Left_147 VGND VGND VPWR VPWR sky130_fd_sc_hd__decap_3
XPHY_EDGE_ROW_4_Right_4 VGND VGND VPWR VPWR sky130_fd_sc_hd__decap_3
X_4496_ _4530_/A1 _4471_/B _4496_/B1 _4496_/B2 VGND VGND VPWR VPWR _5552_/D sky130_fd_sc_hd__a22o_2
XFILLER_103_237 VGND VGND VPWR VPWR sky130_fd_sc_hd__fill_2
Xhold2002 _5917_/Q VGND VGND VPWR VPWR _4885_/B2 sky130_fd_sc_hd__dlygate4sd3_1
X_3447_ _5377_/Q _5345_/Q _5313_/Q _5281_/Q _3398_/S _3808_/S1 VGND VGND VPWR VPWR
+ _3448_/B sky130_fd_sc_hd__mux4_2
XFILLER_97_460 VGND VGND VPWR VPWR sky130_fd_sc_hd__decap_3
Xhold2013 _5210_/Q VGND VGND VPWR VPWR _4131_/B2 sky130_fd_sc_hd__dlygate4sd3_1
Xhold2024 _5555_/Q VGND VGND VPWR VPWR _4499_/B2 sky130_fd_sc_hd__dlygate4sd3_1
Xhold2035 _5973_/Q VGND VGND VPWR VPWR _4943_/B2 sky130_fd_sc_hd__dlygate4sd3_1
X_3378_ _5374_/Q _5342_/Q _5310_/Q _5278_/Q _3707_/S _3820_/S1 VGND VGND VPWR VPWR
+ _3378_/X sky130_fd_sc_hd__mux4_2
XFILLER_111_281 VGND VGND VPWR VPWR sky130_fd_sc_hd__decap_3
XFILLER_85_644 VGND VGND VPWR VPWR sky130_fd_sc_hd__decap_3
Xhold1301 _5178_/Q VGND VGND VPWR VPWR _4097_/B2 sky130_fd_sc_hd__dlygate4sd3_1
Xhold1312 _5810_/Q VGND VGND VPWR VPWR _4772_/B2 sky130_fd_sc_hd__dlygate4sd3_1
Xhold1323 _5647_/Q VGND VGND VPWR VPWR _4598_/B2 sky130_fd_sc_hd__dlygate4sd3_1
Xhold1334 _5521_/Q VGND VGND VPWR VPWR _4463_/B2 sky130_fd_sc_hd__dlygate4sd3_1
Xhold2046 _5922_/Q VGND VGND VPWR VPWR _4890_/B2 sky130_fd_sc_hd__dlygate4sd3_1
Xhold2057 _5437_/Q VGND VGND VPWR VPWR _4374_/B2 sky130_fd_sc_hd__dlygate4sd3_1
Xhold2068 _5239_/Q VGND VGND VPWR VPWR _4160_/B2 sky130_fd_sc_hd__dlygate4sd3_1
Xhold2079 _5356_/Q VGND VGND VPWR VPWR _4286_/B2 sky130_fd_sc_hd__dlygate4sd3_1
X_5117_ _6013_/CLK _5117_/D VGND VGND VPWR VPWR _5117_/Q sky130_fd_sc_hd__dfxtp_2
Xhold1345 _5141_/Q VGND VGND VPWR VPWR _4053_/B2 sky130_fd_sc_hd__dlygate4sd3_1
Xhold1356 _5231_/Q VGND VGND VPWR VPWR _4152_/B2 sky130_fd_sc_hd__dlygate4sd3_1
Xhold1367 _5372_/Q VGND VGND VPWR VPWR _4304_/B2 sky130_fd_sc_hd__dlygate4sd3_1
X_5048_ _5400_/CLK _5048_/D VGND VGND VPWR VPWR _5048_/Q sky130_fd_sc_hd__dfxtp_2
XFILLER_27_69 VGND VGND VPWR VPWR sky130_fd_sc_hd__decap_3
Xhold1378 _5214_/Q VGND VGND VPWR VPWR _4135_/B2 sky130_fd_sc_hd__dlygate4sd3_1
Xhold1389 _5901_/Q VGND VGND VPWR VPWR _4867_/B2 sky130_fd_sc_hd__dlygate4sd3_1
XFILLER_53_530 VGND VGND VPWR VPWR sky130_fd_sc_hd__fill_1
XFILLER_65_390 VGND VGND VPWR VPWR sky130_fd_sc_hd__fill_2
XFILLER_13_416 VGND VGND VPWR VPWR sky130_fd_sc_hd__decap_3
XPHY_EDGE_ROW_40_Left_156 VGND VGND VPWR VPWR sky130_fd_sc_hd__decap_3
Xclkbuf_4_8_0_clk clkbuf_0_clk/X VGND VGND VPWR VPWR clkbuf_4_8_0_clk/X sky130_fd_sc_hd__clkbuf_8
XFILLER_43_57 VGND VGND VPWR VPWR sky130_fd_sc_hd__decap_3
XFILLER_21_460 VGND VGND VPWR VPWR sky130_fd_sc_hd__fill_2
XFILLER_111_3 VGND VGND VPWR VPWR sky130_fd_sc_hd__decap_3
XFILLER_4_103 VGND VGND VPWR VPWR sky130_fd_sc_hd__decap_3
XFILLER_5_626 VGND VGND VPWR VPWR sky130_fd_sc_hd__decap_3
XFILLER_5_659 VGND VGND VPWR VPWR sky130_fd_sc_hd__decap_3
XFILLER_108_50 VGND VGND VPWR VPWR sky130_fd_sc_hd__decap_3
XFILLER_4_18 VGND VGND VPWR VPWR sky130_fd_sc_hd__decap_3
XFILLER_4_29 VGND VGND VPWR VPWR sky130_fd_sc_hd__decap_3
XFILLER_108_83 VGND VGND VPWR VPWR sky130_fd_sc_hd__fill_1
XFILLER_108_94 VGND VGND VPWR VPWR sky130_fd_sc_hd__decap_3
XFILLER_0_353 VGND VGND VPWR VPWR sky130_fd_sc_hd__decap_3
XFILLER_68_98 VGND VGND VPWR VPWR sky130_fd_sc_hd__fill_2
XFILLER_75_143 VGND VGND VPWR VPWR sky130_fd_sc_hd__decap_3
XFILLER_36_519 VGND VGND VPWR VPWR sky130_fd_sc_hd__fill_2
XFILLER_84_42 VGND VGND VPWR VPWR sky130_fd_sc_hd__decap_3
XFILLER_91_636 VGND VGND VPWR VPWR sky130_fd_sc_hd__fill_2
Xhold1890 _6008_/Q VGND VGND VPWR VPWR _4982_/B2 sky130_fd_sc_hd__dlygate4sd3_1
XFILLER_29_593 VGND VGND VPWR VPWR sky130_fd_sc_hd__decap_3
XFILLER_44_563 VGND VGND VPWR VPWR sky130_fd_sc_hd__decap_3
XFILLER_44_585 VGND VGND VPWR VPWR sky130_fd_sc_hd__decap_3
XFILLER_71_393 VGND VGND VPWR VPWR sky130_fd_sc_hd__decap_3
XTAP_TAPCELL_ROW_14_422 VGND VPWR sky130_fd_sc_hd__tapvpwrvgnd_1
XFILLER_31_268 VGND VGND VPWR VPWR sky130_fd_sc_hd__decap_3
XTAP_TAPCELL_ROW_42_753 VGND VPWR sky130_fd_sc_hd__tapvpwrvgnd_1
X_2680_ _2727_/A1 _2678_/X _2679_/X _2972_/A1 VGND VGND VPWR VPWR _2680_/X sky130_fd_sc_hd__o22a_2
XTAP_TAPCELL_ROW_113_1605 VGND VPWR sky130_fd_sc_hd__tapvpwrvgnd_1
X_4350_ _4998_/A1 _4333_/B _4350_/B1 _4350_/B2 VGND VGND VPWR VPWR _5416_/D sky130_fd_sc_hd__a22o_2
XFILLER_113_502 VGND VGND VPWR VPWR sky130_fd_sc_hd__fill_2
X_3301_ _3308_/B2 _3299_/X _3300_/X _3308_/A1 VGND VGND VPWR VPWR _3301_/X sky130_fd_sc_hd__o22a_2
XFILLER_4_681 VGND VGND VPWR VPWR sky130_fd_sc_hd__fill_1
X_4281_ _4727_/A1 _4265_/B _4284_/B1 _4281_/B2 VGND VGND VPWR VPWR _5351_/D sky130_fd_sc_hd__a22o_2
XFILLER_98_279 VGND VGND VPWR VPWR sky130_fd_sc_hd__decap_3
Xclkbuf_leaf_3_clk clkbuf_4_2_0_clk/X VGND VGND VPWR VPWR _6051_/CLK sky130_fd_sc_hd__clkbuf_8
X_6020_ _6036_/CLK _6020_/D VGND VGND VPWR VPWR _6020_/Q sky130_fd_sc_hd__dfxtp_2
X_3232_ _3261_/A _3261_/B VGND VGND VPWR VPWR _3232_/Y sky130_fd_sc_hd__nor2_2
XFILLER_39_335 VGND VGND VPWR VPWR sky130_fd_sc_hd__fill_1
X_3163_ _3152_/X _3161_/X _3162_/X wire570/X VGND VGND VPWR VPWR _3163_/X sky130_fd_sc_hd__o31a_2
XFILLER_81_113 VGND VGND VPWR VPWR sky130_fd_sc_hd__decap_3
X_3094_ _3094_/A1 _3092_/X _3093_/X _3094_/B2 VGND VGND VPWR VPWR _3094_/X sky130_fd_sc_hd__o22a_2
XFILLER_35_552 VGND VGND VPWR VPWR sky130_fd_sc_hd__decap_3
XFILLER_50_533 VGND VGND VPWR VPWR sky130_fd_sc_hd__fill_1
X_5804_ _5804_/CLK _5804_/D VGND VGND VPWR VPWR _5804_/Q sky130_fd_sc_hd__dfxtp_2
X_3996_ _4989_/A1 wire540/X _4020_/B1 _3996_/B2 VGND VGND VPWR VPWR _5087_/D sky130_fd_sc_hd__a22o_2
X_5735_ _5799_/CLK _5735_/D VGND VGND VPWR VPWR _5735_/Q sky130_fd_sc_hd__dfxtp_2
X_2947_ _5259_/Q _5227_/Q _3069_/S VGND VGND VPWR VPWR _2947_/X sky130_fd_sc_hd__mux2_1
XTAP_TAPCELL_ROW_79_1202 VGND VPWR sky130_fd_sc_hd__tapvpwrvgnd_1
X_5666_ _5794_/CLK _5666_/D VGND VGND VPWR VPWR _5666_/Q sky130_fd_sc_hd__dfxtp_2
X_4617_ _5024_/A1 wire407/X wire186/X _4617_/B2 VGND VGND VPWR VPWR _5664_/D sky130_fd_sc_hd__a22o_2
X_2878_ _5512_/Q _5480_/Q _2878_/S VGND VGND VPWR VPWR _2878_/X sky130_fd_sc_hd__mux2_1
X_5597_ _5986_/CLK _5597_/D VGND VGND VPWR VPWR _5597_/Q sky130_fd_sc_hd__dfxtp_2
XFILLER_2_607 VGND VGND VPWR VPWR sky130_fd_sc_hd__decap_3
X_4548_ _4753_/A1 _4566_/A2 _4566_/B1 _4548_/B2 VGND VGND VPWR VPWR _5599_/D sky130_fd_sc_hd__a22o_2
XFILLER_8_9 VGND VGND VPWR VPWR sky130_fd_sc_hd__decap_3
Xfanout900 input40/X VGND VGND VPWR VPWR _4468_/A1 sky130_fd_sc_hd__clkdlybuf4s25_1
X_4479_ _4719_/A1 wire437/X _4502_/B1 _4479_/B2 VGND VGND VPWR VPWR _5535_/D sky130_fd_sc_hd__a22o_2
Xfanout933 input31/X VGND VGND VPWR VPWR _5038_/A1 sky130_fd_sc_hd__clkdlybuf4s25_1
Xfanout922 _4531_/A1 VGND VGND VPWR VPWR _5007_/A1 sky130_fd_sc_hd__clkdlybuf4s25_1
Xfanout911 _4534_/A1 VGND VGND VPWR VPWR _5010_/A1 sky130_fd_sc_hd__clkdlybuf4s25_1
Xfanout977 _5028_/A1 VGND VGND VPWR VPWR _4926_/A1 sky130_fd_sc_hd__clkdlybuf4s25_1
Xfanout966 _4997_/A1 VGND VGND VPWR VPWR _4658_/A1 sky130_fd_sc_hd__clkdlybuf4s25_1
Xfanout955 _5000_/A1 VGND VGND VPWR VPWR _4695_/A1 sky130_fd_sc_hd__clkdlybuf4s25_1
Xfanout944 input29/X VGND VGND VPWR VPWR _4766_/A1 sky130_fd_sc_hd__clkdlybuf4s25_1
XFILLER_38_68 VGND VGND VPWR VPWR sky130_fd_sc_hd__fill_2
Xfanout988 _5016_/A1 VGND VGND VPWR VPWR _4880_/A1 sky130_fd_sc_hd__clkdlybuf4s25_1
Xfanout999 _5015_/A VGND VGND VPWR VPWR _4811_/A sky130_fd_sc_hd__clkdlybuf4s25_1
Xhold1142 _5862_/Q VGND VGND VPWR VPWR _4826_/B2 sky130_fd_sc_hd__dlygate4sd3_1
XFILLER_57_154 VGND VGND VPWR VPWR sky130_fd_sc_hd__decap_3
XFILLER_85_463 VGND VGND VPWR VPWR sky130_fd_sc_hd__fill_1
XFILLER_85_485 VGND VGND VPWR VPWR sky130_fd_sc_hd__decap_3
XPHY_EDGE_ROW_79_Right_79 VGND VGND VPWR VPWR sky130_fd_sc_hd__decap_3
Xhold1153 _6038_/Q VGND VGND VPWR VPWR _5012_/B2 sky130_fd_sc_hd__dlygate4sd3_1
Xhold1164 _5277_/Q VGND VGND VPWR VPWR _4203_/B2 sky130_fd_sc_hd__dlygate4sd3_1
Xhold1175 _5643_/Q VGND VGND VPWR VPWR _4594_/B2 sky130_fd_sc_hd__dlygate4sd3_1
XFILLER_26_541 VGND VGND VPWR VPWR sky130_fd_sc_hd__decap_3
XFILLER_57_198 VGND VGND VPWR VPWR sky130_fd_sc_hd__decap_3
XFILLER_72_124 VGND VGND VPWR VPWR sky130_fd_sc_hd__decap_3
XFILLER_72_135 VGND VGND VPWR VPWR sky130_fd_sc_hd__decap_3
Xhold1186 _5850_/Q VGND VGND VPWR VPWR _4814_/B2 sky130_fd_sc_hd__dlygate4sd3_1
Xhold1197 _5514_/Q VGND VGND VPWR VPWR _4456_/B2 sky130_fd_sc_hd__dlygate4sd3_1
XFILLER_13_202 VGND VGND VPWR VPWR sky130_fd_sc_hd__decap_3
XFILLER_26_585 VGND VGND VPWR VPWR sky130_fd_sc_hd__decap_3
XFILLER_110_62 VGND VGND VPWR VPWR sky130_fd_sc_hd__decap_3
XFILLER_41_599 VGND VGND VPWR VPWR sky130_fd_sc_hd__decap_3
XFILLER_70_88 VGND VGND VPWR VPWR sky130_fd_sc_hd__fill_1
XPHY_EDGE_ROW_88_Right_88 VGND VGND VPWR VPWR sky130_fd_sc_hd__decap_3
XFILLER_107_373 VGND VGND VPWR VPWR sky130_fd_sc_hd__decap_3
XFILLER_79_31 VGND VGND VPWR VPWR sky130_fd_sc_hd__fill_1
XFILLER_1_662 VGND VGND VPWR VPWR sky130_fd_sc_hd__decap_3
XFILLER_1_673 VGND VGND VPWR VPWR sky130_fd_sc_hd__decap_3
XFILLER_103_590 VGND VGND VPWR VPWR sky130_fd_sc_hd__decap_3
XPHY_EDGE_ROW_97_Right_97 VGND VGND VPWR VPWR sky130_fd_sc_hd__decap_3
XTAP_TAPCELL_ROW_47_812 VGND VPWR sky130_fd_sc_hd__tapvpwrvgnd_1
XFILLER_29_390 VGND VGND VPWR VPWR sky130_fd_sc_hd__fill_2
XFILLER_63_124 VGND VGND VPWR VPWR sky130_fd_sc_hd__decap_3
XFILLER_91_422 VGND VGND VPWR VPWR sky130_fd_sc_hd__fill_1
XFILLER_91_444 VGND VGND VPWR VPWR sky130_fd_sc_hd__decap_3
XFILLER_17_541 VGND VGND VPWR VPWR sky130_fd_sc_hd__decap_3
XTAP_TAPCELL_ROW_63_1003 VGND VPWR sky130_fd_sc_hd__tapvpwrvgnd_1
X_3850_ _5267_/Q _5235_/Q _3851_/S VGND VGND VPWR VPWR _3850_/X sky130_fd_sc_hd__mux2_1
X_3781_ _3784_/A _3778_/X _3780_/X _3781_/C1 VGND VGND VPWR VPWR _3781_/X sky130_fd_sc_hd__a211o_2
X_2801_ _3044_/A _2798_/X _2800_/X _3146_/B2 VGND VGND VPWR VPWR _2801_/X sky130_fd_sc_hd__a22o_2
XFILLER_74_3 VGND VGND VPWR VPWR sky130_fd_sc_hd__fill_1
X_5520_ _6027_/CLK _5520_/D VGND VGND VPWR VPWR _5520_/Q sky130_fd_sc_hd__dfxtp_2
X_2732_ _5409_/Q _5057_/Q _2732_/S VGND VGND VPWR VPWR _2732_/X sky130_fd_sc_hd__mux2_1
X_5451_ _6059_/CLK _5451_/D VGND VGND VPWR VPWR _5451_/Q sky130_fd_sc_hd__dfxtp_2
X_2663_ _3184_/A1 _2660_/X _2662_/X VGND VGND VPWR VPWR _2663_/X sky130_fd_sc_hd__a21o_2
XFILLER_99_500 VGND VGND VPWR VPWR sky130_fd_sc_hd__decap_3
X_5382_ _5659_/CLK _5382_/D VGND VGND VPWR VPWR _5382_/Q sky130_fd_sc_hd__dfxtp_2
X_4402_ _4946_/B _4504_/B VGND VGND VPWR VPWR _4402_/Y sky130_fd_sc_hd__nor2_2
X_2594_ wire643/X _2592_/X _2593_/X _2990_/A1 VGND VGND VPWR VPWR _2594_/X sky130_fd_sc_hd__o22a_2
XTAP_TAPCELL_ROW_74_1132 VGND VPWR sky130_fd_sc_hd__tapvpwrvgnd_1
XTAP_TAPCELL_ROW_74_1143 VGND VPWR sky130_fd_sc_hd__tapvpwrvgnd_1
X_4333_ _5015_/A _4333_/B VGND VGND VPWR VPWR _4333_/Y sky130_fd_sc_hd__nor2_2
XFILLER_101_505 VGND VGND VPWR VPWR sky130_fd_sc_hd__decap_3
XFILLER_115_18 VGND VGND VPWR VPWR sky130_fd_sc_hd__decap_3
XFILLER_86_205 VGND VGND VPWR VPWR sky130_fd_sc_hd__decap_3
Xfanout218 fanout224/X VGND VGND VPWR VPWR _4465_/B1 sky130_fd_sc_hd__clkdlybuf4s25_1
X_4264_ _4844_/A _4298_/B VGND VGND VPWR VPWR _4264_/Y sky130_fd_sc_hd__nor2_2
XFILLER_101_527 VGND VGND VPWR VPWR sky130_fd_sc_hd__decap_3
XFILLER_115_29 VGND VGND VPWR VPWR sky130_fd_sc_hd__decap_3
XFILLER_39_110 VGND VGND VPWR VPWR sky130_fd_sc_hd__fill_2
XPHY_EDGE_ROW_105_Left_221 VGND VGND VPWR VPWR sky130_fd_sc_hd__decap_3
X_6003_ _6035_/CLK _6003_/D VGND VGND VPWR VPWR _6003_/Q sky130_fd_sc_hd__dfxtp_2
X_3215_ _3215_/A _3215_/B VGND VGND VPWR VPWR _3215_/X sky130_fd_sc_hd__or2_2
X_4195_ input4/X _4709_/C input5/X VGND VGND VPWR VPWR _4298_/B sky130_fd_sc_hd__or3b_2
XFILLER_82_411 VGND VGND VPWR VPWR sky130_fd_sc_hd__fill_1
X_3146_ _3044_/A _3143_/X _3145_/X _3146_/B2 VGND VGND VPWR VPWR _3146_/X sky130_fd_sc_hd__a22o_2
XFILLER_55_669 VGND VGND VPWR VPWR sky130_fd_sc_hd__decap_3
X_3077_ _5425_/Q _5073_/Q _3077_/S VGND VGND VPWR VPWR _3077_/X sky130_fd_sc_hd__mux2_1
XFILLER_82_477 VGND VGND VPWR VPWR sky130_fd_sc_hd__decap_3
XTAP_TAPCELL_ROW_85_1272 VGND VPWR sky130_fd_sc_hd__tapvpwrvgnd_1
XFILLER_23_555 VGND VGND VPWR VPWR sky130_fd_sc_hd__decap_3
XFILLER_35_393 VGND VGND VPWR VPWR sky130_fd_sc_hd__fill_2
XPHY_EDGE_ROW_114_Left_230 VGND VGND VPWR VPWR sky130_fd_sc_hd__decap_3
X_5718_ _6070_/CLK _5718_/D VGND VGND VPWR VPWR _5718_/Q sky130_fd_sc_hd__dfxtp_2
X_3979_ _5043_/A1 _3981_/A2 wire322/X _3979_/B2 VGND VGND VPWR VPWR _5075_/D sky130_fd_sc_hd__a22o_2
XFILLER_40_25 VGND VGND VPWR VPWR sky130_fd_sc_hd__decap_3
XFILLER_108_137 VGND VGND VPWR VPWR sky130_fd_sc_hd__decap_3
X_5649_ _6053_/CLK _5649_/D VGND VGND VPWR VPWR _5649_/Q sky130_fd_sc_hd__dfxtp_2
XFILLER_2_448 VGND VGND VPWR VPWR sky130_fd_sc_hd__fill_2
XFILLER_6_6 VGND VGND VPWR VPWR sky130_fd_sc_hd__decap_3
XFILLER_104_365 VGND VGND VPWR VPWR sky130_fd_sc_hd__fill_2
XFILLER_49_89 VGND VGND VPWR VPWR sky130_fd_sc_hd__decap_3
Xfanout730 _2492_/Y VGND VGND VPWR VPWR fanout730/X sky130_fd_sc_hd__clkdlybuf4s25_1
Xfanout785 fanout822/X VGND VGND VPWR VPWR _2913_/S sky130_fd_sc_hd__clkdlybuf4s25_1
Xfanout752 fanout765/X VGND VGND VPWR VPWR _2911_/S1 sky130_fd_sc_hd__dlymetal6s4s_1
XFILLER_100_560 VGND VGND VPWR VPWR sky130_fd_sc_hd__fill_2
XFILLER_100_571 VGND VGND VPWR VPWR sky130_fd_sc_hd__decap_3
XFILLER_105_84 VGND VGND VPWR VPWR sky130_fd_sc_hd__decap_3
Xfanout796 _3166_/S VGND VGND VPWR VPWR _3133_/S sky130_fd_sc_hd__clkdlybuf4s25_1
XFILLER_18_349 VGND VGND VPWR VPWR sky130_fd_sc_hd__decap_3
XFILLER_45_135 VGND VGND VPWR VPWR sky130_fd_sc_hd__fill_1
XFILLER_61_606 VGND VGND VPWR VPWR sky130_fd_sc_hd__fill_2
XFILLER_61_617 VGND VGND VPWR VPWR sky130_fd_sc_hd__decap_3
XFILLER_61_628 VGND VGND VPWR VPWR sky130_fd_sc_hd__decap_3
XFILLER_14_533 VGND VGND VPWR VPWR sky130_fd_sc_hd__decap_3
XTAP_TAPCELL_ROW_52_870 VGND VPWR sky130_fd_sc_hd__tapvpwrvgnd_1
XFILLER_108_660 VGND VGND VPWR VPWR sky130_fd_sc_hd__decap_3
XFILLER_68_216 VGND VGND VPWR VPWR sky130_fd_sc_hd__fill_2
XFILLER_110_379 VGND VGND VPWR VPWR sky130_fd_sc_hd__decap_3
Xinput7 rs1[1] VGND VGND VPWR VPWR input7/X sky130_fd_sc_hd__buf_2
X_3000_ _3108_/A _2996_/X _2999_/X _3118_/B2 VGND VGND VPWR VPWR _3000_/X sky130_fd_sc_hd__o211a_2
XFILLER_36_113 VGND VGND VPWR VPWR sky130_fd_sc_hd__fill_2
XTAP_TAPCELL_ROW_108_1548 VGND VPWR sky130_fd_sc_hd__tapvpwrvgnd_1
XFILLER_64_477 VGND VGND VPWR VPWR sky130_fd_sc_hd__fill_1
XFILLER_36_179 VGND VGND VPWR VPWR sky130_fd_sc_hd__decap_3
XFILLER_91_296 VGND VGND VPWR VPWR sky130_fd_sc_hd__decap_3
X_4951_ _4985_/A1 _4977_/A2 _4977_/B1 _4951_/B2 VGND VGND VPWR VPWR _5979_/D sky130_fd_sc_hd__a22o_2
X_4882_ _5018_/A1 _4907_/A2 wire139/A _4882_/B2 VGND VGND VPWR VPWR _5914_/D sky130_fd_sc_hd__a22o_2
X_3902_ _5526_/Q _5494_/Q _3915_/S VGND VGND VPWR VPWR _3902_/X sky130_fd_sc_hd__mux2_1
XFILLER_20_514 VGND VGND VPWR VPWR sky130_fd_sc_hd__fill_1
XFILLER_60_661 VGND VGND VPWR VPWR sky130_fd_sc_hd__decap_3
XTAP_TAPCELL_ROW_22_509 VGND VPWR sky130_fd_sc_hd__tapvpwrvgnd_1
X_3833_ _3261_/X _3819_/X _3827_/X _3833_/B2 VGND VGND VPWR VPWR _3833_/X sky130_fd_sc_hd__a22o_2
XFILLER_20_569 VGND VGND VPWR VPWR sky130_fd_sc_hd__fill_2
X_3764_ _3872_/A _3761_/X _3763_/X _3909_/B1 VGND VGND VPWR VPWR _3764_/X sky130_fd_sc_hd__o211a_2
XFILLER_9_592 VGND VGND VPWR VPWR sky130_fd_sc_hd__decap_3
X_5503_ _6060_/CLK _5503_/D VGND VGND VPWR VPWR _5503_/Q sky130_fd_sc_hd__dfxtp_2
X_3695_ _3695_/A1 _3692_/X _3261_/X VGND VGND VPWR VPWR _3695_/X sky130_fd_sc_hd__o21a_2
X_2715_ _5249_/Q _5217_/Q _2975_/S VGND VGND VPWR VPWR _2715_/X sky130_fd_sc_hd__mux2_1
X_5434_ _6042_/CLK _5434_/D VGND VGND VPWR VPWR _5434_/Q sky130_fd_sc_hd__dfxtp_2
X_2646_ _2755_/A1 _2643_/X _2645_/X _2755_/B2 VGND VGND VPWR VPWR _2646_/X sky130_fd_sc_hd__a22o_2
XFILLER_113_140 VGND VGND VPWR VPWR sky130_fd_sc_hd__fill_1
XFILLER_114_663 VGND VGND VPWR VPWR sky130_fd_sc_hd__decap_3
XFILLER_87_503 VGND VGND VPWR VPWR sky130_fd_sc_hd__fill_1
X_5365_ _5525_/CLK _5365_/D VGND VGND VPWR VPWR _5365_/Q sky130_fd_sc_hd__dfxtp_2
X_2577_ _6043_/Q _5947_/Q _2578_/S VGND VGND VPWR VPWR _2577_/X sky130_fd_sc_hd__mux2_1
XFILLER_87_514 VGND VGND VPWR VPWR sky130_fd_sc_hd__decap_3
XFILLER_99_374 VGND VGND VPWR VPWR sky130_fd_sc_hd__decap_3
XFILLER_99_396 VGND VGND VPWR VPWR sky130_fd_sc_hd__decap_3
X_5296_ _5963_/CLK _5296_/D VGND VGND VPWR VPWR _5296_/Q sky130_fd_sc_hd__dfxtp_2
X_4316_ _5032_/A1 _4316_/A2 wire248/A _4316_/B2 VGND VGND VPWR VPWR _5384_/D sky130_fd_sc_hd__a22o_2
XFILLER_19_26 VGND VGND VPWR VPWR sky130_fd_sc_hd__decap_3
XFILLER_87_558 VGND VGND VPWR VPWR sky130_fd_sc_hd__fill_2
X_4247_ _4727_/A1 _4231_/B _4260_/B1 _4247_/B2 VGND VGND VPWR VPWR _5319_/D sky130_fd_sc_hd__a22o_2
X_4178_ _4658_/A1 wire500/X wire281/X _4178_/B2 VGND VGND VPWR VPWR _5255_/D sky130_fd_sc_hd__a22o_2
XFILLER_27_113 VGND VGND VPWR VPWR sky130_fd_sc_hd__decap_3
XFILLER_28_636 VGND VGND VPWR VPWR sky130_fd_sc_hd__decap_3
XFILLER_28_658 VGND VGND VPWR VPWR sky130_fd_sc_hd__fill_1
XTAP_TAPCELL_ROW_2_278 VGND VPWR sky130_fd_sc_hd__tapvpwrvgnd_1
X_3129_ _3175_/A _3125_/X _3128_/X _3179_/A1 VGND VGND VPWR VPWR _3129_/X sky130_fd_sc_hd__o211a_2
XFILLER_43_628 VGND VGND VPWR VPWR sky130_fd_sc_hd__fill_1
XFILLER_23_330 VGND VGND VPWR VPWR sky130_fd_sc_hd__decap_3
XFILLER_11_503 VGND VGND VPWR VPWR sky130_fd_sc_hd__fill_1
XFILLER_11_514 VGND VGND VPWR VPWR sky130_fd_sc_hd__decap_3
XFILLER_51_24 VGND VGND VPWR VPWR sky130_fd_sc_hd__fill_2
XFILLER_51_57 VGND VGND VPWR VPWR sky130_fd_sc_hd__fill_2
XTAP_TAPCELL_ROW_98_1430 VGND VPWR sky130_fd_sc_hd__tapvpwrvgnd_1
XFILLER_109_479 VGND VGND VPWR VPWR sky130_fd_sc_hd__fill_1
XFILLER_4_3 VGND VGND VPWR VPWR sky130_fd_sc_hd__decap_3
XFILLER_105_685 VGND VGND VPWR VPWR sky130_fd_sc_hd__decap_3
XFILLER_78_525 VGND VGND VPWR VPWR sky130_fd_sc_hd__decap_3
XFILLER_78_536 VGND VGND VPWR VPWR sky130_fd_sc_hd__decap_3
Xfanout560 fanout560/A VGND VGND VPWR VPWR _3224_/A1 sky130_fd_sc_hd__clkdlybuf4s25_1
Xfanout593 _3944_/B2 VGND VGND VPWR VPWR _3543_/B2 sky130_fd_sc_hd__clkdlybuf4s25_1
Xfanout582 _3611_/B2 VGND VGND VPWR VPWR wire583/A sky130_fd_sc_hd__clkdlybuf4s25_1
Xfanout571 _2499_/X VGND VGND VPWR VPWR _3231_/B1 sky130_fd_sc_hd__clkbuf_2
XFILLER_46_455 VGND VGND VPWR VPWR sky130_fd_sc_hd__decap_3
XFILLER_33_127 VGND VGND VPWR VPWR sky130_fd_sc_hd__fill_1
XFILLER_33_149 VGND VGND VPWR VPWR sky130_fd_sc_hd__decap_3
XFILLER_61_447 VGND VGND VPWR VPWR sky130_fd_sc_hd__fill_1
XFILLER_14_341 VGND VGND VPWR VPWR sky130_fd_sc_hd__decap_3
XFILLER_14_363 VGND VGND VPWR VPWR sky130_fd_sc_hd__fill_1
XTAP_TAPCELL_ROW_103_1489 VGND VPWR sky130_fd_sc_hd__tapvpwrvgnd_1
XFILLER_10_580 VGND VGND VPWR VPWR sky130_fd_sc_hd__decap_3
X_3480_ _5506_/Q _5474_/Q _3926_/S VGND VGND VPWR VPWR _3480_/X sky130_fd_sc_hd__mux2_1
X_2500_ _2608_/A _2516_/B VGND VGND VPWR VPWR _2500_/X sky130_fd_sc_hd__and2_2
XTAP_TAPCELL_ROW_71_1102 VGND VPWR sky130_fd_sc_hd__tapvpwrvgnd_1
XFILLER_111_611 VGND VGND VPWR VPWR sky130_fd_sc_hd__decap_3
XFILLER_37_3 VGND VGND VPWR VPWR sky130_fd_sc_hd__decap_3
X_5150_ _5986_/CLK _5150_/D VGND VGND VPWR VPWR _5150_/Q sky130_fd_sc_hd__dfxtp_2
XFILLER_111_644 VGND VGND VPWR VPWR sky130_fd_sc_hd__decap_3
Xhold1708 _5569_/Q VGND VGND VPWR VPWR _4515_/B2 sky130_fd_sc_hd__dlygate4sd3_1
X_5081_ _5683_/CLK _5081_/D VGND VGND VPWR VPWR _5081_/Q sky130_fd_sc_hd__dfxtp_2
X_4101_ _4988_/A1 wire516/X wire298/X _4101_/B2 VGND VGND VPWR VPWR _5182_/D sky130_fd_sc_hd__a22o_2
XFILLER_2_62 VGND VGND VPWR VPWR sky130_fd_sc_hd__decap_3
Xhold1719 _5070_/Q VGND VGND VPWR VPWR _3974_/B2 sky130_fd_sc_hd__dlygate4sd3_1
X_4032_ _4514_/A1 _4040_/A2 _4040_/B1 _4032_/B2 VGND VGND VPWR VPWR _5120_/D sky130_fd_sc_hd__a22o_2
XFILLER_84_539 VGND VGND VPWR VPWR sky130_fd_sc_hd__fill_1
XFILLER_112_19 VGND VGND VPWR VPWR sky130_fd_sc_hd__decap_3
XFILLER_24_105 VGND VGND VPWR VPWR sky130_fd_sc_hd__decap_3
XTAP_TAPCELL_ROW_69_1075 VGND VPWR sky130_fd_sc_hd__tapvpwrvgnd_1
X_5983_ _6026_/CLK _5983_/D VGND VGND VPWR VPWR _5983_/Q sky130_fd_sc_hd__dfxtp_2
X_4934_ _5036_/A1 wire355/X _4945_/B1 _4934_/B2 VGND VGND VPWR VPWR _5964_/D sky130_fd_sc_hd__a22o_2
XTAP_TAPCELL_ROW_82_1231 VGND VPWR sky130_fd_sc_hd__tapvpwrvgnd_1
XTAP_TAPCELL_ROW_35_667 VGND VPWR sky130_fd_sc_hd__tapvpwrvgnd_1
XANTENNA_12 input11/X VGND VGND VPWR VPWR sky130_fd_sc_hd__diode_2
XANTENNA_23 fanout560/A VGND VGND VPWR VPWR sky130_fd_sc_hd__diode_2
XFILLER_20_333 VGND VGND VPWR VPWR sky130_fd_sc_hd__decap_3
X_4865_ _4899_/A1 _4870_/A2 _4874_/B1 _4865_/B2 VGND VGND VPWR VPWR _5899_/D sky130_fd_sc_hd__a22o_2
XANTENNA_34 input16/X VGND VGND VPWR VPWR sky130_fd_sc_hd__diode_2
XANTENNA_45 _4676_/B VGND VGND VPWR VPWR sky130_fd_sc_hd__diode_2
X_4796_ wire1003/X _4796_/B VGND VGND VPWR VPWR _5834_/D sky130_fd_sc_hd__and2b_2
X_3816_ _3827_/S _3816_/B VGND VGND VPWR VPWR _3816_/X sky130_fd_sc_hd__or2_2
X_3747_ _3261_/A _3730_/X _3735_/X _3746_/X wire628/A VGND VGND VPWR VPWR _3747_/X
+ sky130_fd_sc_hd__a32o_2
XFILLER_106_427 VGND VGND VPWR VPWR sky130_fd_sc_hd__decap_3
XFILLER_108_9 VGND VGND VPWR VPWR sky130_fd_sc_hd__decap_3
X_3678_ _3738_/A _3675_/X _3677_/X VGND VGND VPWR VPWR _3678_/X sky130_fd_sc_hd__a21o_2
X_5417_ clkload8/A _5417_/D VGND VGND VPWR VPWR _5417_/Q sky130_fd_sc_hd__dfxtp_2
X_2629_ _2649_/A _2625_/X _2628_/X _3106_/C1 VGND VGND VPWR VPWR _2629_/X sky130_fd_sc_hd__o211a_2
XTAP_TAPCELL_ROW_93_1360 VGND VPWR sky130_fd_sc_hd__tapvpwrvgnd_1
XTAP_TAPCELL_ROW_7_337 VGND VPWR sky130_fd_sc_hd__tapvpwrvgnd_1
X_5348_ _5400_/CLK _5348_/D VGND VGND VPWR VPWR _5348_/Q sky130_fd_sc_hd__dfxtp_2
XTAP_TAPCELL_ROW_93_1371 VGND VPWR sky130_fd_sc_hd__tapvpwrvgnd_1
XFILLER_102_655 VGND VGND VPWR VPWR sky130_fd_sc_hd__fill_2
XFILLER_102_677 VGND VGND VPWR VPWR sky130_fd_sc_hd__decap_3
X_5279_ _5578_/CLK _5279_/D VGND VGND VPWR VPWR _5279_/Q sky130_fd_sc_hd__dfxtp_2
XFILLER_46_24 VGND VGND VPWR VPWR sky130_fd_sc_hd__decap_3
XFILLER_28_466 VGND VGND VPWR VPWR sky130_fd_sc_hd__fill_2
XFILLER_28_477 VGND VGND VPWR VPWR sky130_fd_sc_hd__fill_2
XFILLER_83_594 VGND VGND VPWR VPWR sky130_fd_sc_hd__decap_3
XFILLER_15_127 VGND VGND VPWR VPWR sky130_fd_sc_hd__decap_3
XFILLER_23_193 VGND VGND VPWR VPWR sky130_fd_sc_hd__fill_1
XFILLER_7_18 VGND VGND VPWR VPWR sky130_fd_sc_hd__decap_3
XFILLER_7_304 VGND VGND VPWR VPWR sky130_fd_sc_hd__decap_3
XFILLER_7_315 VGND VGND VPWR VPWR sky130_fd_sc_hd__decap_3
XFILLER_109_221 VGND VGND VPWR VPWR sky130_fd_sc_hd__decap_3
XFILLER_7_337 VGND VGND VPWR VPWR sky130_fd_sc_hd__decap_3
XFILLER_109_254 VGND VGND VPWR VPWR sky130_fd_sc_hd__decap_3
XFILLER_7_359 VGND VGND VPWR VPWR sky130_fd_sc_hd__decap_3
XFILLER_3_554 VGND VGND VPWR VPWR sky130_fd_sc_hd__decap_3
XFILLER_105_471 VGND VGND VPWR VPWR sky130_fd_sc_hd__fill_1
XFILLER_87_31 VGND VGND VPWR VPWR sky130_fd_sc_hd__fill_1
Xload_slew207 _4528_/B1 VGND VGND VPWR VPWR _4535_/B1 sky130_fd_sc_hd__buf_4
XFILLER_105_482 VGND VGND VPWR VPWR sky130_fd_sc_hd__decap_3
XFILLER_87_53 VGND VGND VPWR VPWR sky130_fd_sc_hd__decap_3
Xload_slew229 _4433_/B1 VGND VGND VPWR VPWR _4425_/B1 sky130_fd_sc_hd__clkbuf_2
XFILLER_19_433 VGND VGND VPWR VPWR sky130_fd_sc_hd__decap_3
XFILLER_59_591 VGND VGND VPWR VPWR sky130_fd_sc_hd__fill_1
Xfanout390 _4710_/Y VGND VGND VPWR VPWR _4736_/A2 sky130_fd_sc_hd__clkdlybuf4s25_1
XTAP_TAPCELL_ROW_105_1507 VGND VPWR sky130_fd_sc_hd__tapvpwrvgnd_1
X_2980_ _5580_/Q _5548_/Q _2980_/S VGND VGND VPWR VPWR _2980_/X sky130_fd_sc_hd__mux2_1
XFILLER_42_480 VGND VGND VPWR VPWR sky130_fd_sc_hd__decap_3
XTAP_TAPCELL_ROW_32_637 VGND VPWR sky130_fd_sc_hd__tapvpwrvgnd_1
XTAP_TAPCELL_ROW_60_968 VGND VPWR sky130_fd_sc_hd__tapvpwrvgnd_1
X_4650_ _4753_/A1 _4668_/A2 _4668_/B1 _4650_/B2 VGND VGND VPWR VPWR _5695_/D sky130_fd_sc_hd__a22o_2
Xinput10 rs1[4] VGND VGND VPWR VPWR _2608_/A sky130_fd_sc_hd__clkdlybuf4s25_1
Xinput21 wd[13] VGND VGND VPWR VPWR input21/X sky130_fd_sc_hd__clkdlybuf4s25_1
X_3601_ _3261_/B _3597_/X _3261_/A VGND VGND VPWR VPWR _3601_/X sky130_fd_sc_hd__a21o_2
XTAP_TAPCELL_ROW_12_394 VGND VPWR sky130_fd_sc_hd__tapvpwrvgnd_1
Xinput32 wd[23] VGND VGND VPWR VPWR input32/X sky130_fd_sc_hd__clkdlybuf4s25_1
Xinput43 wd[4] VGND VGND VPWR VPWR input43/X sky130_fd_sc_hd__clkdlybuf4s25_1
X_4581_ _4752_/A1 _4606_/A2 _4606_/B1 _4581_/B2 VGND VGND VPWR VPWR _5630_/D sky130_fd_sc_hd__a22o_2
X_3532_ _3234_/B _3529_/X _3531_/X _3928_/A1 VGND VGND VPWR VPWR _3532_/X sky130_fd_sc_hd__a22o_2
X_3463_ wire630/A _3459_/X _3461_/X _3909_/B1 _3446_/X VGND VGND VPWR VPWR _3463_/X
+ sky130_fd_sc_hd__a32o_2
XFILLER_88_108 VGND VGND VPWR VPWR sky130_fd_sc_hd__decap_3
XFILLER_97_620 VGND VGND VPWR VPWR sky130_fd_sc_hd__decap_3
X_5202_ _5805_/CLK _5202_/D VGND VGND VPWR VPWR _5202_/Q sky130_fd_sc_hd__dfxtp_2
XFILLER_111_430 VGND VGND VPWR VPWR sky130_fd_sc_hd__decap_3
Xload_slew741 _3206_/A1 VGND VGND VPWR VPWR _2937_/A1 sky130_fd_sc_hd__buf_4
X_5133_ _6029_/CLK _5133_/D VGND VGND VPWR VPWR _5133_/Q sky130_fd_sc_hd__dfxtp_2
X_3394_ _3471_/B1 _3377_/X _3382_/X _3393_/X _3832_/C1 VGND VGND VPWR VPWR _3394_/X
+ sky130_fd_sc_hd__a32o_2
XFILLER_96_141 VGND VGND VPWR VPWR sky130_fd_sc_hd__fill_2
Xhold1505 _6010_/Q VGND VGND VPWR VPWR _4984_/B2 sky130_fd_sc_hd__dlygate4sd3_1
Xhold1516 _5432_/Q VGND VGND VPWR VPWR _4369_/B2 sky130_fd_sc_hd__dlygate4sd3_1
Xload_slew774 _3225_/S1 VGND VGND VPWR VPWR _3214_/S1 sky130_fd_sc_hd__buf_2
Xload_slew763 _3113_/S1 VGND VGND VPWR VPWR _2996_/S1 sky130_fd_sc_hd__buf_4
XFILLER_57_528 VGND VGND VPWR VPWR sky130_fd_sc_hd__decap_3
XFILLER_57_539 VGND VGND VPWR VPWR sky130_fd_sc_hd__fill_2
XFILLER_84_325 VGND VGND VPWR VPWR sky130_fd_sc_hd__fill_2
Xhold1527 _5633_/Q VGND VGND VPWR VPWR _4584_/B2 sky130_fd_sc_hd__dlygate4sd3_1
Xhold1538 _5089_/Q VGND VGND VPWR VPWR _3998_/B2 sky130_fd_sc_hd__dlygate4sd3_1
Xhold1549 _5894_/Q VGND VGND VPWR VPWR _4860_/B2 sky130_fd_sc_hd__dlygate4sd3_1
X_5064_ _6046_/CLK _5064_/D VGND VGND VPWR VPWR _5064_/Q sky130_fd_sc_hd__dfxtp_2
X_4015_ _5008_/A1 _4015_/A2 _4015_/B1 _4015_/B2 VGND VGND VPWR VPWR _5106_/D sky130_fd_sc_hd__a22o_2
XFILLER_37_252 VGND VGND VPWR VPWR sky130_fd_sc_hd__decap_3
XFILLER_65_561 VGND VGND VPWR VPWR sky130_fd_sc_hd__decap_3
XFILLER_65_594 VGND VGND VPWR VPWR sky130_fd_sc_hd__fill_2
XFILLER_16_27 VGND VGND VPWR VPWR sky130_fd_sc_hd__fill_1
X_5966_ _6062_/CLK _5966_/D VGND VGND VPWR VPWR _5966_/Q sky130_fd_sc_hd__dfxtp_2
XFILLER_21_620 VGND VGND VPWR VPWR sky130_fd_sc_hd__fill_1
XFILLER_33_491 VGND VGND VPWR VPWR sky130_fd_sc_hd__decap_3
X_5897_ clkload9/A _5897_/D VGND VGND VPWR VPWR _5897_/Q sky130_fd_sc_hd__dfxtp_2
X_4917_ _5019_/A1 _4941_/A2 wire133/A _4917_/B2 VGND VGND VPWR VPWR _5947_/D sky130_fd_sc_hd__a22o_2
XFILLER_20_141 VGND VGND VPWR VPWR sky130_fd_sc_hd__decap_3
XFILLER_21_642 VGND VGND VPWR VPWR sky130_fd_sc_hd__decap_3
X_4848_ _5018_/A1 _4873_/A2 wire146/A _4848_/B2 VGND VGND VPWR VPWR _5882_/D sky130_fd_sc_hd__a22o_2
XFILLER_32_48 VGND VGND VPWR VPWR sky130_fd_sc_hd__fill_2
X_4779_ _4795_/A_N _4779_/B VGND VGND VPWR VPWR _5817_/D sky130_fd_sc_hd__and2b_2
XFILLER_106_224 VGND VGND VPWR VPWR sky130_fd_sc_hd__decap_3
XFILLER_113_7 VGND VGND VPWR VPWR sky130_fd_sc_hd__decap_3
XFILLER_106_6 VGND VGND VPWR VPWR sky130_fd_sc_hd__decap_3
XFILLER_0_513 VGND VGND VPWR VPWR sky130_fd_sc_hd__decap_3
XFILLER_79_119 VGND VGND VPWR VPWR sky130_fd_sc_hd__decap_3
XFILLER_88_631 VGND VGND VPWR VPWR sky130_fd_sc_hd__fill_1
XFILLER_0_579 VGND VGND VPWR VPWR sky130_fd_sc_hd__fill_1
XFILLER_87_130 VGND VGND VPWR VPWR sky130_fd_sc_hd__decap_3
XFILLER_102_474 VGND VGND VPWR VPWR sky130_fd_sc_hd__fill_2
XFILLER_113_40 VGND VGND VPWR VPWR sky130_fd_sc_hd__decap_3
XFILLER_57_89 VGND VGND VPWR VPWR sky130_fd_sc_hd__fill_2
XFILLER_56_583 VGND VGND VPWR VPWR sky130_fd_sc_hd__decap_3
XFILLER_113_84 VGND VGND VPWR VPWR sky130_fd_sc_hd__decap_3
XFILLER_31_439 VGND VGND VPWR VPWR sky130_fd_sc_hd__decap_3
XFILLER_8_602 VGND VGND VPWR VPWR sky130_fd_sc_hd__decap_3
XTAP_TAPCELL_ROW_100_1448 VGND VPWR sky130_fd_sc_hd__tapvpwrvgnd_1
XFILLER_12_675 VGND VGND VPWR VPWR sky130_fd_sc_hd__decap_3
XFILLER_8_635 VGND VGND VPWR VPWR sky130_fd_sc_hd__fill_1
XFILLER_98_52 VGND VGND VPWR VPWR sky130_fd_sc_hd__decap_3
XFILLER_98_85 VGND VGND VPWR VPWR sky130_fd_sc_hd__decap_3
XFILLER_39_517 VGND VGND VPWR VPWR sky130_fd_sc_hd__decap_3
XFILLER_78_141 VGND VGND VPWR VPWR sky130_fd_sc_hd__decap_3
XTAP_TAPCELL_ROW_111_1577 VGND VPWR sky130_fd_sc_hd__tapvpwrvgnd_1
XFILLER_78_174 VGND VGND VPWR VPWR sky130_fd_sc_hd__decap_3
XFILLER_93_111 VGND VGND VPWR VPWR sky130_fd_sc_hd__fill_1
XFILLER_66_358 VGND VGND VPWR VPWR sky130_fd_sc_hd__fill_1
XFILLER_34_200 VGND VGND VPWR VPWR sky130_fd_sc_hd__fill_2
XTAP_TAPCELL_ROW_66_1045 VGND VPWR sky130_fd_sc_hd__tapvpwrvgnd_1
XFILLER_62_564 VGND VGND VPWR VPWR sky130_fd_sc_hd__decap_3
XTAP_TAPCELL_ROW_17_453 VGND VPWR sky130_fd_sc_hd__tapvpwrvgnd_1
X_5820_ _6044_/CLK _5820_/D VGND VGND VPWR VPWR _5820_/Q sky130_fd_sc_hd__dfxtp_2
XTAP_TAPCELL_ROW_45_784 VGND VPWR sky130_fd_sc_hd__tapvpwrvgnd_1
XTAP_TAPCELL_ROW_45_795 VGND VPWR sky130_fd_sc_hd__tapvpwrvgnd_1
X_5751_ _5815_/CLK _5751_/D VGND VGND VPWR VPWR _5751_/Q sky130_fd_sc_hd__dfxtp_2
X_2963_ _5132_/Q _5100_/Q _6028_/Q _5996_/Q _2980_/S _3225_/S1 VGND VGND VPWR VPWR
+ _2963_/X sky130_fd_sc_hd__mux4_2
X_4702_ _4771_/A1 _4708_/A2 _4708_/B1 _4702_/B2 VGND VGND VPWR VPWR _5745_/D sky130_fd_sc_hd__a22o_2
XFILLER_30_472 VGND VGND VPWR VPWR sky130_fd_sc_hd__decap_3
XFILLER_8_50 VGND VGND VPWR VPWR sky130_fd_sc_hd__decap_3
X_5682_ _6013_/CLK _5682_/D VGND VGND VPWR VPWR _5682_/Q sky130_fd_sc_hd__dfxtp_2
X_2894_ _2887_/X _2893_/X _2894_/B1 VGND VGND VPWR VPWR _2894_/X sky130_fd_sc_hd__o21a_2
XFILLER_30_494 VGND VGND VPWR VPWR sky130_fd_sc_hd__decap_3
X_4633_ _4904_/A1 _4639_/A2 _4639_/B1 _4633_/B2 VGND VGND VPWR VPWR _5680_/D sky130_fd_sc_hd__a22o_2
X_4564_ _4903_/A1 _4571_/A2 _4571_/B1 _4564_/B2 VGND VGND VPWR VPWR _5615_/D sky130_fd_sc_hd__a22o_2
XTAP_TAPCELL_ROW_77_1174 VGND VPWR sky130_fd_sc_hd__tapvpwrvgnd_1
X_3515_ _3872_/A _3514_/X _3341_/A VGND VGND VPWR VPWR _3515_/X sky130_fd_sc_hd__o21a_2
XFILLER_103_205 VGND VGND VPWR VPWR sky130_fd_sc_hd__decap_3
XFILLER_89_417 VGND VGND VPWR VPWR sky130_fd_sc_hd__decap_3
XFILLER_89_428 VGND VGND VPWR VPWR sky130_fd_sc_hd__decap_3
X_4495_ _4529_/A1 wire437/X _4502_/B1 _4495_/B2 VGND VGND VPWR VPWR _5551_/D sky130_fd_sc_hd__a22o_2
Xhold2003 _5110_/Q VGND VGND VPWR VPWR _4019_/B2 sky130_fd_sc_hd__dlygate4sd3_1
Xmax_cap398 _4675_/Y VGND VGND VPWR VPWR fanout397/A sky130_fd_sc_hd__buf_2
X_3446_ _3881_/B2 _3443_/X _3445_/X VGND VGND VPWR VPWR _3446_/X sky130_fd_sc_hd__a21o_2
XTAP_TAPCELL_ROW_90_1330 VGND VPWR sky130_fd_sc_hd__tapvpwrvgnd_1
Xhold2014 _5285_/Q VGND VGND VPWR VPWR _4211_/B2 sky130_fd_sc_hd__dlygate4sd3_1
Xhold2025 _5693_/Q VGND VGND VPWR VPWR _4648_/B2 sky130_fd_sc_hd__dlygate4sd3_1
Xhold2036 _5217_/Q VGND VGND VPWR VPWR _4138_/B2 sky130_fd_sc_hd__dlygate4sd3_1
X_3377_ _3709_/A1 _3374_/X _3376_/X _3781_/C1 VGND VGND VPWR VPWR _3377_/X sky130_fd_sc_hd__a211o_2
XFILLER_85_612 VGND VGND VPWR VPWR sky130_fd_sc_hd__decap_3
XFILLER_85_634 VGND VGND VPWR VPWR sky130_fd_sc_hd__decap_3
XFILLER_97_494 VGND VGND VPWR VPWR sky130_fd_sc_hd__decap_3
Xhold1302 _5518_/Q VGND VGND VPWR VPWR _4460_/B2 sky130_fd_sc_hd__dlygate4sd3_1
Xhold1313 _6025_/Q VGND VGND VPWR VPWR _4999_/B2 sky130_fd_sc_hd__dlygate4sd3_1
Xhold1324 _5117_/Q VGND VGND VPWR VPWR _4029_/B2 sky130_fd_sc_hd__dlygate4sd3_1
Xhold2047 _5665_/Q VGND VGND VPWR VPWR _4618_/B2 sky130_fd_sc_hd__dlygate4sd3_1
Xhold2058 _5155_/Q VGND VGND VPWR VPWR _4071_/B2 sky130_fd_sc_hd__dlygate4sd3_1
Xhold2069 _5069_/Q VGND VGND VPWR VPWR _3973_/B2 sky130_fd_sc_hd__dlygate4sd3_1
X_5116_ _6012_/CLK _5116_/D VGND VGND VPWR VPWR _5116_/Q sky130_fd_sc_hd__dfxtp_2
XFILLER_27_15 VGND VGND VPWR VPWR sky130_fd_sc_hd__decap_3
Xhold1335 _5135_/Q VGND VGND VPWR VPWR _4047_/B2 sky130_fd_sc_hd__dlygate4sd3_1
Xhold1346 _5368_/Q VGND VGND VPWR VPWR _4300_/B2 sky130_fd_sc_hd__dlygate4sd3_1
Xhold1357 _5431_/Q VGND VGND VPWR VPWR _4365_/B2 sky130_fd_sc_hd__dlygate4sd3_1
Xhold1368 _5420_/Q VGND VGND VPWR VPWR _4354_/B2 sky130_fd_sc_hd__dlygate4sd3_1
X_5047_ _5047_/A1 wire334/X _5047_/B1 _5047_/B2 VGND VGND VPWR VPWR _6071_/D sky130_fd_sc_hd__a22o_2
Xhold1379 _5120_/Q VGND VGND VPWR VPWR _4032_/B2 sky130_fd_sc_hd__dlygate4sd3_1
XFILLER_25_244 VGND VGND VPWR VPWR sky130_fd_sc_hd__fill_1
X_5949_ _6045_/CLK _5949_/D VGND VGND VPWR VPWR _5949_/Q sky130_fd_sc_hd__dfxtp_2
XFILLER_107_511 VGND VGND VPWR VPWR sky130_fd_sc_hd__decap_3
XFILLER_5_638 VGND VGND VPWR VPWR sky130_fd_sc_hd__decap_3
XFILLER_104_3 VGND VGND VPWR VPWR sky130_fd_sc_hd__decap_3
XFILLER_108_62 VGND VGND VPWR VPWR sky130_fd_sc_hd__decap_3
XFILLER_0_365 VGND VGND VPWR VPWR sky130_fd_sc_hd__decap_3
XFILLER_76_645 VGND VGND VPWR VPWR sky130_fd_sc_hd__decap_3
XFILLER_84_32 VGND VGND VPWR VPWR sky130_fd_sc_hd__fill_2
XFILLER_29_561 VGND VGND VPWR VPWR sky130_fd_sc_hd__decap_3
XFILLER_91_615 VGND VGND VPWR VPWR sky130_fd_sc_hd__fill_1
Xhold1880 _5229_/Q VGND VGND VPWR VPWR _4150_/B2 sky130_fd_sc_hd__dlygate4sd3_1
XFILLER_75_199 VGND VGND VPWR VPWR sky130_fd_sc_hd__fill_1
XFILLER_90_136 VGND VGND VPWR VPWR sky130_fd_sc_hd__decap_3
Xhold1891 _5930_/Q VGND VGND VPWR VPWR _4898_/B2 sky130_fd_sc_hd__dlygate4sd3_1
XFILLER_44_553 VGND VGND VPWR VPWR sky130_fd_sc_hd__fill_1
XTAP_TAPCELL_ROW_14_412 VGND VPWR sky130_fd_sc_hd__tapvpwrvgnd_1
XFILLER_90_9 VGND VGND VPWR VPWR sky130_fd_sc_hd__decap_3
XTAP_TAPCELL_ROW_14_423 VGND VPWR sky130_fd_sc_hd__tapvpwrvgnd_1
XTAP_TAPCELL_ROW_42_754 VGND VPWR sky130_fd_sc_hd__tapvpwrvgnd_1
XFILLER_8_410 VGND VGND VPWR VPWR sky130_fd_sc_hd__decap_3
XFILLER_8_421 VGND VGND VPWR VPWR sky130_fd_sc_hd__decap_3
XFILLER_8_465 VGND VGND VPWR VPWR sky130_fd_sc_hd__decap_3
XTAP_TAPCELL_ROW_113_1606 VGND VPWR sky130_fd_sc_hd__tapvpwrvgnd_1
XFILLER_4_660 VGND VGND VPWR VPWR sky130_fd_sc_hd__decap_3
X_3300_ _5178_/Q _5146_/Q _3300_/S VGND VGND VPWR VPWR _3300_/X sky130_fd_sc_hd__mux2_1
X_4280_ _4520_/A1 _4292_/A2 _4287_/B1 _4280_/B2 VGND VGND VPWR VPWR _5350_/D sky130_fd_sc_hd__a22o_2
X_3231_ _3224_/X _3230_/X _3231_/B1 VGND VGND VPWR VPWR _3231_/X sky130_fd_sc_hd__o21a_2
XFILLER_66_100 VGND VGND VPWR VPWR sky130_fd_sc_hd__decap_3
XFILLER_67_634 VGND VGND VPWR VPWR sky130_fd_sc_hd__decap_3
XFILLER_79_494 VGND VGND VPWR VPWR sky130_fd_sc_hd__decap_3
X_3162_ _3206_/C1 _3154_/X _3156_/X _3196_/C1 _3147_/X VGND VGND VPWR VPWR _3162_/X
+ sky130_fd_sc_hd__a32o_2
X_3093_ _5585_/Q _5553_/Q _3093_/S VGND VGND VPWR VPWR _3093_/X sky130_fd_sc_hd__mux2_1
XFILLER_47_391 VGND VGND VPWR VPWR sky130_fd_sc_hd__fill_1
XFILLER_82_648 VGND VGND VPWR VPWR sky130_fd_sc_hd__decap_3
XFILLER_81_169 VGND VGND VPWR VPWR sky130_fd_sc_hd__decap_3
X_5803_ _5963_/CLK _5803_/D VGND VGND VPWR VPWR _5803_/Q sky130_fd_sc_hd__dfxtp_2
XFILLER_50_545 VGND VGND VPWR VPWR sky130_fd_sc_hd__decap_3
XFILLER_50_556 VGND VGND VPWR VPWR sky130_fd_sc_hd__decap_3
X_3995_ _4752_/A1 _4015_/A2 _4015_/B1 _3995_/B2 VGND VGND VPWR VPWR _5086_/D sky130_fd_sc_hd__a22o_2
XFILLER_10_409 VGND VGND VPWR VPWR sky130_fd_sc_hd__fill_1
X_5734_ _6034_/CLK _5734_/D VGND VGND VPWR VPWR _5734_/Q sky130_fd_sc_hd__dfxtp_2
X_2946_ _3058_/A _2946_/B VGND VGND VPWR VPWR _2946_/X sky130_fd_sc_hd__or2_2
XTAP_TAPCELL_ROW_79_1203 VGND VPWR sky130_fd_sc_hd__tapvpwrvgnd_1
X_5665_ _5825_/CLK _5665_/D VGND VGND VPWR VPWR _5665_/Q sky130_fd_sc_hd__dfxtp_2
X_2877_ _5384_/Q _5352_/Q _5320_/Q _5288_/Q _2878_/S _3164_/S1 VGND VGND VPWR VPWR
+ _2877_/X sky130_fd_sc_hd__mux4_2
X_4616_ _4753_/A1 _4634_/A2 _4634_/B1 _4616_/B2 VGND VGND VPWR VPWR _5663_/D sky130_fd_sc_hd__a22o_2
XPHY_EDGE_ROW_111_Right_111 VGND VGND VPWR VPWR sky130_fd_sc_hd__decap_3
X_5596_ _5692_/CLK _5596_/D VGND VGND VPWR VPWR _5596_/Q sky130_fd_sc_hd__dfxtp_2
XFILLER_2_619 VGND VGND VPWR VPWR sky130_fd_sc_hd__decap_3
X_4547_ _4752_/A1 _4572_/A2 _4572_/B1 _4547_/B2 VGND VGND VPWR VPWR _5598_/D sky130_fd_sc_hd__a22o_2
XFILLER_89_225 VGND VGND VPWR VPWR sky130_fd_sc_hd__decap_3
Xmax_cap184 _4642_/Y VGND VGND VPWR VPWR fanout183/A sky130_fd_sc_hd__clkbuf_2
X_4478_ _4886_/A1 _4498_/A2 _4498_/B1 _4478_/B2 VGND VGND VPWR VPWR _5534_/D sky130_fd_sc_hd__a22o_2
XFILLER_104_569 VGND VGND VPWR VPWR sky130_fd_sc_hd__fill_2
Xfanout934 input31/X VGND VGND VPWR VPWR _4768_/A1 sky130_fd_sc_hd__clkdlybuf4s25_1
Xfanout923 input34/X VGND VGND VPWR VPWR _4531_/A1 sky130_fd_sc_hd__clkdlybuf4s25_1
Xfanout912 input37/X VGND VGND VPWR VPWR _4534_/A1 sky130_fd_sc_hd__clkdlybuf4s25_1
Xfanout901 _4508_/A1 VGND VGND VPWR VPWR _5018_/A1 sky130_fd_sc_hd__clkdlybuf4s25_1
X_3429_ _3433_/A _3425_/X _3428_/X _3781_/C1 VGND VGND VPWR VPWR _3429_/X sky130_fd_sc_hd__a211o_2
XFILLER_57_100 VGND VGND VPWR VPWR sky130_fd_sc_hd__decap_3
Xfanout967 input23/X VGND VGND VPWR VPWR _4997_/A1 sky130_fd_sc_hd__clkdlybuf4s25_1
Xfanout956 input26/X VGND VGND VPWR VPWR _5000_/A1 sky130_fd_sc_hd__clkdlybuf4s25_1
Xfanout945 input28/X VGND VGND VPWR VPWR _5017_/A1 sky130_fd_sc_hd__clkdlybuf4s25_1
XFILLER_57_133 VGND VGND VPWR VPWR sky130_fd_sc_hd__decap_3
XFILLER_85_431 VGND VGND VPWR VPWR sky130_fd_sc_hd__decap_3
Xfanout978 _4994_/A1 VGND VGND VPWR VPWR _5028_/A1 sky130_fd_sc_hd__clkdlybuf4s25_1
Xfanout989 input17/X VGND VGND VPWR VPWR _5016_/A1 sky130_fd_sc_hd__clkdlybuf4s25_1
XFILLER_73_604 VGND VGND VPWR VPWR sky130_fd_sc_hd__decap_3
XFILLER_73_626 VGND VGND VPWR VPWR sky130_fd_sc_hd__decap_3
XFILLER_85_475 VGND VGND VPWR VPWR sky130_fd_sc_hd__fill_2
Xhold1143 _5258_/Q VGND VGND VPWR VPWR _4181_/B2 sky130_fd_sc_hd__dlygate4sd3_1
Xhold1154 _6052_/Q VGND VGND VPWR VPWR _5028_/B2 sky130_fd_sc_hd__dlygate4sd3_1
Xhold1165 _5567_/Q VGND VGND VPWR VPWR _4513_/B2 sky130_fd_sc_hd__dlygate4sd3_1
Xhold1176 _5572_/Q VGND VGND VPWR VPWR _4518_/B2 sky130_fd_sc_hd__dlygate4sd3_1
XFILLER_38_391 VGND VGND VPWR VPWR sky130_fd_sc_hd__decap_3
XFILLER_85_497 VGND VGND VPWR VPWR sky130_fd_sc_hd__decap_3
Xhold1187 _5262_/Q VGND VGND VPWR VPWR _4185_/B2 sky130_fd_sc_hd__dlygate4sd3_1
Xhold1198 _5879_/Q VGND VGND VPWR VPWR _4843_/B2 sky130_fd_sc_hd__dlygate4sd3_1
XFILLER_72_147 VGND VGND VPWR VPWR sky130_fd_sc_hd__decap_3
XFILLER_110_41 VGND VGND VPWR VPWR sky130_fd_sc_hd__decap_3
XFILLER_41_556 VGND VGND VPWR VPWR sky130_fd_sc_hd__decap_3
XFILLER_41_567 VGND VGND VPWR VPWR sky130_fd_sc_hd__fill_2
XFILLER_9_207 VGND VGND VPWR VPWR sky130_fd_sc_hd__decap_3
XFILLER_110_74 VGND VGND VPWR VPWR sky130_fd_sc_hd__decap_3
XFILLER_110_85 VGND VGND VPWR VPWR sky130_fd_sc_hd__decap_3
XFILLER_21_291 VGND VGND VPWR VPWR sky130_fd_sc_hd__decap_3
XFILLER_79_54 VGND VGND VPWR VPWR sky130_fd_sc_hd__fill_2
XFILLER_107_396 VGND VGND VPWR VPWR sky130_fd_sc_hd__fill_2
XFILLER_1_641 VGND VGND VPWR VPWR sky130_fd_sc_hd__decap_3
XFILLER_95_206 VGND VGND VPWR VPWR sky130_fd_sc_hd__decap_3
XFILLER_1_685 VGND VGND VPWR VPWR sky130_fd_sc_hd__decap_3
XFILLER_49_634 VGND VGND VPWR VPWR sky130_fd_sc_hd__decap_3
XFILLER_95_53 VGND VGND VPWR VPWR sky130_fd_sc_hd__decap_3
XFILLER_36_317 VGND VGND VPWR VPWR sky130_fd_sc_hd__decap_3
XFILLER_48_155 VGND VGND VPWR VPWR sky130_fd_sc_hd__fill_2
XTAP_TAPCELL_ROW_47_813 VGND VPWR sky130_fd_sc_hd__tapvpwrvgnd_1
XFILLER_28_91 VGND VGND VPWR VPWR sky130_fd_sc_hd__decap_3
XFILLER_64_648 VGND VGND VPWR VPWR sky130_fd_sc_hd__decap_3
XFILLER_91_434 VGND VGND VPWR VPWR sky130_fd_sc_hd__fill_2
XFILLER_32_512 VGND VGND VPWR VPWR sky130_fd_sc_hd__decap_3
XTAP_TAPCELL_ROW_27_570 VGND VPWR sky130_fd_sc_hd__tapvpwrvgnd_1
XTAP_TAPCELL_ROW_63_1004 VGND VPWR sky130_fd_sc_hd__tapvpwrvgnd_1
XFILLER_32_556 VGND VGND VPWR VPWR sky130_fd_sc_hd__fill_1
X_3780_ _3791_/A1 _3777_/X _3779_/X _3791_/B2 VGND VGND VPWR VPWR _3780_/X sky130_fd_sc_hd__a22o_2
X_2800_ _5508_/Q _5476_/Q _2800_/S VGND VGND VPWR VPWR _2800_/X sky130_fd_sc_hd__mux2_1
X_2731_ _5793_/Q _5729_/Q _2732_/S VGND VGND VPWR VPWR _2731_/X sky130_fd_sc_hd__mux2_1
XFILLER_8_240 VGND VGND VPWR VPWR sky130_fd_sc_hd__decap_3
X_5450_ _6058_/CLK _5450_/D VGND VGND VPWR VPWR _5450_/Q sky130_fd_sc_hd__dfxtp_2
XFILLER_67_3 VGND VGND VPWR VPWR sky130_fd_sc_hd__decap_3
X_4401_ input4/X _4401_/B input5/X VGND VGND VPWR VPWR _4504_/B sky130_fd_sc_hd__or3b_2
X_2662_ _3183_/A1 _2659_/X _2661_/X _2558_/A VGND VGND VPWR VPWR _2662_/X sky130_fd_sc_hd__a22o_2
X_5381_ _6000_/CLK _5381_/D VGND VGND VPWR VPWR _5381_/Q sky130_fd_sc_hd__dfxtp_2
X_2593_ _5243_/Q _5211_/Q _2593_/S VGND VGND VPWR VPWR _2593_/X sky130_fd_sc_hd__mux2_1
XFILLER_5_51 VGND VGND VPWR VPWR sky130_fd_sc_hd__decap_3
XFILLER_99_545 VGND VGND VPWR VPWR sky130_fd_sc_hd__decap_3
XTAP_TAPCELL_ROW_74_1133 VGND VPWR sky130_fd_sc_hd__tapvpwrvgnd_1
X_4332_ _4744_/A _4878_/A VGND VGND VPWR VPWR _4332_/Y sky130_fd_sc_hd__nor2_2
XFILLER_99_578 VGND VGND VPWR VPWR sky130_fd_sc_hd__decap_3
Xfanout208 _4505_/Y VGND VGND VPWR VPWR _4532_/B1 sky130_fd_sc_hd__clkdlybuf4s25_1
X_4263_ _4843_/A1 _4263_/A2 _4263_/B1 _4263_/B2 VGND VGND VPWR VPWR _5335_/D sky130_fd_sc_hd__a22o_2
XFILLER_101_517 VGND VGND VPWR VPWR sky130_fd_sc_hd__fill_2
Xclkbuf_4_7_0_clk clkbuf_0_clk/X VGND VGND VPWR VPWR clkload3/A sky130_fd_sc_hd__clkbuf_8
X_6002_ _6034_/CLK _6002_/D VGND VGND VPWR VPWR _6002_/Q sky130_fd_sc_hd__dfxtp_2
X_3214_ _5719_/Q _5687_/Q _5655_/Q _5623_/Q _3227_/S _3214_/S1 VGND VGND VPWR VPWR
+ _3215_/B sky130_fd_sc_hd__mux4_2
X_4194_ _5013_/A1 wire500/X wire281/X _4194_/B2 VGND VGND VPWR VPWR _5271_/D sky130_fd_sc_hd__a22o_2
XFILLER_27_317 VGND VGND VPWR VPWR sky130_fd_sc_hd__decap_3
X_3145_ _5204_/Q _5172_/Q _3145_/S VGND VGND VPWR VPWR _3145_/X sky130_fd_sc_hd__mux2_1
XFILLER_55_637 VGND VGND VPWR VPWR sky130_fd_sc_hd__decap_3
X_3076_ _5809_/Q _5745_/Q _3077_/S VGND VGND VPWR VPWR _3076_/X sky130_fd_sc_hd__mux2_1
XFILLER_42_309 VGND VGND VPWR VPWR sky130_fd_sc_hd__decap_3
XFILLER_35_361 VGND VGND VPWR VPWR sky130_fd_sc_hd__fill_2
XTAP_TAPCELL_ROW_85_1273 VGND VPWR sky130_fd_sc_hd__tapvpwrvgnd_1
XFILLER_10_206 VGND VGND VPWR VPWR sky130_fd_sc_hd__decap_3
XFILLER_23_578 VGND VGND VPWR VPWR sky130_fd_sc_hd__fill_1
X_3978_ _5008_/A1 wire546/X wire325/X _3978_/B2 VGND VGND VPWR VPWR _5074_/D sky130_fd_sc_hd__a22o_2
X_5717_ _5813_/CLK _5717_/D VGND VGND VPWR VPWR _5717_/Q sky130_fd_sc_hd__dfxtp_2
X_2929_ _3215_/A _2929_/B VGND VGND VPWR VPWR _2929_/X sky130_fd_sc_hd__or2_2
XFILLER_109_617 VGND VGND VPWR VPWR sky130_fd_sc_hd__decap_3
XFILLER_109_639 VGND VGND VPWR VPWR sky130_fd_sc_hd__decap_3
X_5648_ _5867_/CLK _5648_/D VGND VGND VPWR VPWR _5648_/Q sky130_fd_sc_hd__dfxtp_2
X_5579_ _6027_/CLK _5579_/D VGND VGND VPWR VPWR _5579_/Q sky130_fd_sc_hd__dfxtp_2
XFILLER_49_57 VGND VGND VPWR VPWR sky130_fd_sc_hd__decap_3
Xfanout742 _3027_/A1 VGND VGND VPWR VPWR _2690_/A sky130_fd_sc_hd__clkdlybuf4s25_1
XFILLER_105_30 VGND VGND VPWR VPWR sky130_fd_sc_hd__decap_3
Xfanout764 fanout765/X VGND VGND VPWR VPWR _3107_/S1 sky130_fd_sc_hd__clkdlybuf4s25_1
XFILLER_105_52 VGND VGND VPWR VPWR sky130_fd_sc_hd__decap_3
XFILLER_105_63 VGND VGND VPWR VPWR sky130_fd_sc_hd__decap_3
XFILLER_18_306 VGND VGND VPWR VPWR sky130_fd_sc_hd__fill_2
XFILLER_92_209 VGND VGND VPWR VPWR sky130_fd_sc_hd__decap_3
Xfanout786 _3182_/S VGND VGND VPWR VPWR _3170_/S sky130_fd_sc_hd__clkbuf_2
XFILLER_100_583 VGND VGND VPWR VPWR sky130_fd_sc_hd__decap_3
XFILLER_65_45 VGND VGND VPWR VPWR sky130_fd_sc_hd__decap_3
XFILLER_45_147 VGND VGND VPWR VPWR sky130_fd_sc_hd__decap_3
XFILLER_45_169 VGND VGND VPWR VPWR sky130_fd_sc_hd__decap_3
XFILLER_14_589 VGND VGND VPWR VPWR sky130_fd_sc_hd__decap_3
XTAP_TAPCELL_ROW_24_540 VGND VPWR sky130_fd_sc_hd__tapvpwrvgnd_1
XTAP_TAPCELL_ROW_52_871 VGND VPWR sky130_fd_sc_hd__tapvpwrvgnd_1
XFILLER_14_82 VGND VGND VPWR VPWR sky130_fd_sc_hd__fill_2
XFILLER_108_672 VGND VGND VPWR VPWR sky130_fd_sc_hd__decap_3
XFILLER_5_298 VGND VGND VPWR VPWR sky130_fd_sc_hd__decap_3
Xinput8 rs1[2] VGND VGND VPWR VPWR input8/X sky130_fd_sc_hd__clkbuf_4
XFILLER_37_648 VGND VGND VPWR VPWR sky130_fd_sc_hd__fill_1
XTAP_TAPCELL_ROW_108_1549 VGND VPWR sky130_fd_sc_hd__tapvpwrvgnd_1
XFILLER_45_670 VGND VGND VPWR VPWR sky130_fd_sc_hd__fill_2
X_4950_ _4984_/A1 _4977_/A2 _4977_/B1 _4950_/B2 VGND VGND VPWR VPWR _5978_/D sky130_fd_sc_hd__a22o_2
XFILLER_60_640 VGND VGND VPWR VPWR sky130_fd_sc_hd__decap_3
X_4881_ _5017_/A1 _4907_/A2 wire139/X _4881_/B2 VGND VGND VPWR VPWR _5913_/D sky130_fd_sc_hd__a22o_2
X_3901_ _5590_/Q _5558_/Q _3915_/S VGND VGND VPWR VPWR _3901_/X sky130_fd_sc_hd__mux2_1
XFILLER_32_353 VGND VGND VPWR VPWR sky130_fd_sc_hd__decap_3
XFILLER_60_651 VGND VGND VPWR VPWR sky130_fd_sc_hd__fill_1
X_3832_ _3827_/S _3828_/X _3831_/X _3832_/C1 VGND VGND VPWR VPWR _3832_/X sky130_fd_sc_hd__o211a_2
XFILLER_32_397 VGND VGND VPWR VPWR sky130_fd_sc_hd__decap_3
X_5502_ _5502_/CLK _5502_/D VGND VGND VPWR VPWR _5502_/Q sky130_fd_sc_hd__dfxtp_2
X_3763_ _3763_/A _3763_/B VGND VGND VPWR VPWR _3763_/X sky130_fd_sc_hd__or2_2
X_3694_ _3694_/A _3694_/B VGND VGND VPWR VPWR _3694_/X sky130_fd_sc_hd__or2_2
X_2714_ _5185_/Q _5153_/Q _2975_/S VGND VGND VPWR VPWR _2714_/X sky130_fd_sc_hd__mux2_1
XFILLER_10_18 VGND VGND VPWR VPWR sky130_fd_sc_hd__fill_2
X_5433_ clkload9/A _5433_/D VGND VGND VPWR VPWR _5433_/Q sky130_fd_sc_hd__dfxtp_2
X_2645_ _6046_/Q _5950_/Q _2889_/S VGND VGND VPWR VPWR _2645_/X sky130_fd_sc_hd__mux2_1
XFILLER_10_29 VGND VGND VPWR VPWR sky130_fd_sc_hd__decap_3
XFILLER_114_631 VGND VGND VPWR VPWR sky130_fd_sc_hd__decap_3
X_5364_ _5400_/CLK _5364_/D VGND VGND VPWR VPWR _5364_/Q sky130_fd_sc_hd__dfxtp_2
X_4315_ _4727_/A1 _4299_/B _4318_/B1 _4315_/B2 VGND VGND VPWR VPWR _5383_/D sky130_fd_sc_hd__a22o_2
X_2576_ _2987_/A _2576_/B VGND VGND VPWR VPWR _2576_/X sky130_fd_sc_hd__or2_2
XFILLER_101_314 VGND VGND VPWR VPWR sky130_fd_sc_hd__decap_3
XFILLER_114_675 VGND VGND VPWR VPWR sky130_fd_sc_hd__decap_3
XFILLER_87_537 VGND VGND VPWR VPWR sky130_fd_sc_hd__decap_3
XFILLER_99_386 VGND VGND VPWR VPWR sky130_fd_sc_hd__decap_3
X_5295_ _5572_/CLK _5295_/D VGND VGND VPWR VPWR _5295_/Q sky130_fd_sc_hd__dfxtp_2
X_4246_ _4520_/A1 _4258_/A2 _4253_/B1 _4246_/B2 VGND VGND VPWR VPWR _5318_/D sky130_fd_sc_hd__a22o_2
XFILLER_101_369 VGND VGND VPWR VPWR sky130_fd_sc_hd__fill_1
XFILLER_28_604 VGND VGND VPWR VPWR sky130_fd_sc_hd__decap_3
XFILLER_55_401 VGND VGND VPWR VPWR sky130_fd_sc_hd__decap_3
X_4177_ _5030_/A1 _4189_/A2 wire283/X _4177_/B2 VGND VGND VPWR VPWR _5254_/D sky130_fd_sc_hd__a22o_2
XFILLER_82_220 VGND VGND VPWR VPWR sky130_fd_sc_hd__decap_3
X_3128_ wire676/A _3126_/X _3127_/X _3178_/A1 VGND VGND VPWR VPWR _3128_/X sky130_fd_sc_hd__o22a_2
XFILLER_27_158 VGND VGND VPWR VPWR sky130_fd_sc_hd__fill_1
XFILLER_43_607 VGND VGND VPWR VPWR sky130_fd_sc_hd__fill_1
XTAP_TAPCELL_ROW_2_268 VGND VPWR sky130_fd_sc_hd__tapvpwrvgnd_1
XTAP_TAPCELL_ROW_2_279 VGND VPWR sky130_fd_sc_hd__tapvpwrvgnd_1
XFILLER_27_169 VGND VGND VPWR VPWR sky130_fd_sc_hd__decap_3
X_3059_ _5424_/Q _5072_/Q _3060_/S VGND VGND VPWR VPWR _3059_/X sky130_fd_sc_hd__mux2_1
XFILLER_51_640 VGND VGND VPWR VPWR sky130_fd_sc_hd__decap_3
XFILLER_70_448 VGND VGND VPWR VPWR sky130_fd_sc_hd__decap_3
XFILLER_82_297 VGND VGND VPWR VPWR sky130_fd_sc_hd__fill_2
XFILLER_23_353 VGND VGND VPWR VPWR sky130_fd_sc_hd__decap_3
XFILLER_50_150 VGND VGND VPWR VPWR sky130_fd_sc_hd__decap_3
XFILLER_51_673 VGND VGND VPWR VPWR sky130_fd_sc_hd__fill_1
XFILLER_11_526 VGND VGND VPWR VPWR sky130_fd_sc_hd__decap_3
XTAP_TAPCELL_ROW_98_1431 VGND VPWR sky130_fd_sc_hd__tapvpwrvgnd_1
XTAP_TAPCELL_ROW_98_1420 VGND VPWR sky130_fd_sc_hd__tapvpwrvgnd_1
XFILLER_105_653 VGND VGND VPWR VPWR sky130_fd_sc_hd__decap_3
XFILLER_104_141 VGND VGND VPWR VPWR sky130_fd_sc_hd__fill_1
XFILLER_104_174 VGND VGND VPWR VPWR sky130_fd_sc_hd__decap_3
Xfanout572 _3261_/X VGND VGND VPWR VPWR _3898_/A1 sky130_fd_sc_hd__clkdlybuf4s15_2
XFILLER_18_114 VGND VGND VPWR VPWR sky130_fd_sc_hd__decap_3
XFILLER_86_592 VGND VGND VPWR VPWR sky130_fd_sc_hd__fill_1
XTAP_TAPCELL_ROW_57_930 VGND VPWR sky130_fd_sc_hd__tapvpwrvgnd_1
XFILLER_92_21 VGND VGND VPWR VPWR sky130_fd_sc_hd__decap_3
XFILLER_27_681 VGND VGND VPWR VPWR sky130_fd_sc_hd__decap_3
XFILLER_92_54 VGND VGND VPWR VPWR sky130_fd_sc_hd__fill_2
XFILLER_42_640 VGND VGND VPWR VPWR sky130_fd_sc_hd__decap_3
XFILLER_14_353 VGND VGND VPWR VPWR sky130_fd_sc_hd__fill_2
XFILLER_41_150 VGND VGND VPWR VPWR sky130_fd_sc_hd__fill_2
XFILLER_10_592 VGND VGND VPWR VPWR sky130_fd_sc_hd__fill_2
XFILLER_6_541 VGND VGND VPWR VPWR sky130_fd_sc_hd__fill_2
XFILLER_6_563 VGND VGND VPWR VPWR sky130_fd_sc_hd__decap_3
XFILLER_115_417 VGND VGND VPWR VPWR sky130_fd_sc_hd__decap_3
XFILLER_51_6 VGND VGND VPWR VPWR sky130_fd_sc_hd__fill_1
XTAP_TAPCELL_ROW_71_1103 VGND VPWR sky130_fd_sc_hd__tapvpwrvgnd_1
XFILLER_96_312 VGND VGND VPWR VPWR sky130_fd_sc_hd__fill_2
XFILLER_110_100 VGND VGND VPWR VPWR sky130_fd_sc_hd__decap_3
XFILLER_111_623 VGND VGND VPWR VPWR sky130_fd_sc_hd__decap_3
XFILLER_111_656 VGND VGND VPWR VPWR sky130_fd_sc_hd__decap_3
X_5080_ _6027_/CLK _5080_/D VGND VGND VPWR VPWR _5080_/Q sky130_fd_sc_hd__dfxtp_2
X_4100_ _4751_/A1 _4111_/A2 _4124_/B1 _4100_/B2 VGND VGND VPWR VPWR _5181_/D sky130_fd_sc_hd__a22o_2
XFILLER_2_41 VGND VGND VPWR VPWR sky130_fd_sc_hd__decap_3
XFILLER_56_209 VGND VGND VPWR VPWR sky130_fd_sc_hd__decap_3
Xhold1709 _5499_/Q VGND VGND VPWR VPWR _4441_/B2 sky130_fd_sc_hd__dlygate4sd3_1
X_4031_ _4989_/A1 wire533/X _4055_/B1 _4031_/B2 VGND VGND VPWR VPWR _5119_/D sky130_fd_sc_hd__a22o_2
XFILLER_2_74 VGND VGND VPWR VPWR sky130_fd_sc_hd__fill_2
XFILLER_77_592 VGND VGND VPWR VPWR sky130_fd_sc_hd__fill_1
XFILLER_37_445 VGND VGND VPWR VPWR sky130_fd_sc_hd__decap_3
XFILLER_64_242 VGND VGND VPWR VPWR sky130_fd_sc_hd__fill_1
XFILLER_64_253 VGND VGND VPWR VPWR sky130_fd_sc_hd__decap_3
XFILLER_92_573 VGND VGND VPWR VPWR sky130_fd_sc_hd__decap_3
XTAP_TAPCELL_ROW_69_1076 VGND VPWR sky130_fd_sc_hd__tapvpwrvgnd_1
X_5982_ _6050_/CLK _5982_/D VGND VGND VPWR VPWR _5982_/Q sky130_fd_sc_hd__dfxtp_2
X_4933_ _5035_/A1 _4913_/B wire136/X _4933_/B2 VGND VGND VPWR VPWR _5963_/D sky130_fd_sc_hd__a22o_2
XTAP_TAPCELL_ROW_82_1232 VGND VPWR sky130_fd_sc_hd__tapvpwrvgnd_1
XFILLER_32_150 VGND VGND VPWR VPWR sky130_fd_sc_hd__decap_3
XTAP_TAPCELL_ROW_35_668 VGND VPWR sky130_fd_sc_hd__tapvpwrvgnd_1
XANTENNA_13 input16/X VGND VGND VPWR VPWR sky130_fd_sc_hd__diode_2
X_4864_ _5034_/A1 wire367/X wire151/X _4864_/B2 VGND VGND VPWR VPWR _5898_/D sky130_fd_sc_hd__a22o_2
XANTENNA_24 _3207_/B2 VGND VGND VPWR VPWR sky130_fd_sc_hd__diode_2
XANTENNA_35 input16/X VGND VGND VPWR VPWR sky130_fd_sc_hd__diode_2
XANTENNA_46 _3496_/A VGND VGND VPWR VPWR sky130_fd_sc_hd__diode_2
X_4795_ _4795_/A_N _4795_/B VGND VGND VPWR VPWR _5833_/D sky130_fd_sc_hd__and2b_2
X_3815_ _5138_/Q _5106_/Q _6034_/Q _6002_/Q _3721_/S _3826_/S1 VGND VGND VPWR VPWR
+ _3816_/B sky130_fd_sc_hd__mux4_2
XFILLER_21_28 VGND VGND VPWR VPWR sky130_fd_sc_hd__decap_3
X_3746_ _3738_/A _3743_/X _3745_/X VGND VGND VPWR VPWR _3746_/X sky130_fd_sc_hd__a21o_2
XFILLER_106_439 VGND VGND VPWR VPWR sky130_fd_sc_hd__decap_3
X_5416_ _6046_/CLK _5416_/D VGND VGND VPWR VPWR _5416_/Q sky130_fd_sc_hd__dfxtp_2
X_3677_ _3791_/A1 _3674_/X _3676_/X _3745_/B2 VGND VGND VPWR VPWR _3677_/X sky130_fd_sc_hd__a22o_2
X_2628_ _3105_/B2 _2626_/X _2627_/X _3105_/A1 VGND VGND VPWR VPWR _2628_/X sky130_fd_sc_hd__o22a_2
XTAP_TAPCELL_ROW_93_1361 VGND VPWR sky130_fd_sc_hd__tapvpwrvgnd_1
XTAP_TAPCELL_ROW_7_338 VGND VPWR sky130_fd_sc_hd__tapvpwrvgnd_1
X_5347_ _5571_/CLK _5347_/D VGND VGND VPWR VPWR _5347_/Q sky130_fd_sc_hd__dfxtp_2
X_2559_ _5402_/Q _5050_/Q _2582_/S VGND VGND VPWR VPWR _2559_/X sky130_fd_sc_hd__mux2_1
XFILLER_102_645 VGND VGND VPWR VPWR sky130_fd_sc_hd__fill_1
XFILLER_114_483 VGND VGND VPWR VPWR sky130_fd_sc_hd__fill_1
XFILLER_87_345 VGND VGND VPWR VPWR sky130_fd_sc_hd__decap_3
X_5278_ _5800_/CLK _5278_/D VGND VGND VPWR VPWR _5278_/Q sky130_fd_sc_hd__dfxtp_2
X_4229_ _4843_/A1 _4229_/A2 _4229_/B1 _4229_/B2 VGND VGND VPWR VPWR _5303_/D sky130_fd_sc_hd__a22o_2
XFILLER_68_570 VGND VGND VPWR VPWR sky130_fd_sc_hd__fill_1
XFILLER_68_592 VGND VGND VPWR VPWR sky130_fd_sc_hd__decap_3
XFILLER_55_242 VGND VGND VPWR VPWR sky130_fd_sc_hd__decap_3
XTAP_TAPCELL_ROW_54_900 VGND VPWR sky130_fd_sc_hd__tapvpwrvgnd_1
XFILLER_43_459 VGND VGND VPWR VPWR sky130_fd_sc_hd__fill_1
XFILLER_70_223 VGND VGND VPWR VPWR sky130_fd_sc_hd__fill_1
XFILLER_70_234 VGND VGND VPWR VPWR sky130_fd_sc_hd__fill_2
XFILLER_24_673 VGND VGND VPWR VPWR sky130_fd_sc_hd__decap_3
XFILLER_23_150 VGND VGND VPWR VPWR sky130_fd_sc_hd__decap_3
XFILLER_23_183 VGND VGND VPWR VPWR sky130_fd_sc_hd__fill_2
XFILLER_62_57 VGND VGND VPWR VPWR sky130_fd_sc_hd__decap_3
XFILLER_109_211 VGND VGND VPWR VPWR sky130_fd_sc_hd__fill_2
XFILLER_7_327 VGND VGND VPWR VPWR sky130_fd_sc_hd__fill_1
XFILLER_109_266 VGND VGND VPWR VPWR sky130_fd_sc_hd__decap_3
Xwire269 wire269/A VGND VGND VPWR VPWR wire269/X sky130_fd_sc_hd__clkbuf_4
XFILLER_11_94 VGND VGND VPWR VPWR sky130_fd_sc_hd__fill_1
XFILLER_97_109 VGND VGND VPWR VPWR sky130_fd_sc_hd__decap_3
Xload_slew219 _4465_/B1 VGND VGND VPWR VPWR _4460_/B1 sky130_fd_sc_hd__buf_2
XFILLER_66_507 VGND VGND VPWR VPWR sky130_fd_sc_hd__decap_3
XFILLER_16_9 VGND VGND VPWR VPWR sky130_fd_sc_hd__decap_3
Xfanout380 _4744_/Y VGND VGND VPWR VPWR _4776_/A2 sky130_fd_sc_hd__clkdlybuf4s25_1
XFILLER_93_348 VGND VGND VPWR VPWR sky130_fd_sc_hd__decap_3
XFILLER_46_253 VGND VGND VPWR VPWR sky130_fd_sc_hd__decap_3
XTAP_TAPCELL_ROW_105_1508 VGND VPWR sky130_fd_sc_hd__tapvpwrvgnd_1
XFILLER_61_223 VGND VGND VPWR VPWR sky130_fd_sc_hd__fill_1
XFILLER_15_673 VGND VGND VPWR VPWR sky130_fd_sc_hd__decap_3
XFILLER_21_109 VGND VGND VPWR VPWR sky130_fd_sc_hd__decap_3
XFILLER_61_278 VGND VGND VPWR VPWR sky130_fd_sc_hd__fill_2
XFILLER_14_150 VGND VGND VPWR VPWR sky130_fd_sc_hd__fill_1
XFILLER_30_632 VGND VGND VPWR VPWR sky130_fd_sc_hd__decap_3
XFILLER_99_6 VGND VGND VPWR VPWR sky130_fd_sc_hd__decap_3
XTAP_TAPCELL_ROW_32_638 VGND VPWR sky130_fd_sc_hd__tapvpwrvgnd_1
XFILLER_30_643 VGND VGND VPWR VPWR sky130_fd_sc_hd__fill_1
XTAP_TAPCELL_ROW_60_969 VGND VPWR sky130_fd_sc_hd__tapvpwrvgnd_1
XFILLER_30_676 VGND VGND VPWR VPWR sky130_fd_sc_hd__decap_3
Xinput11 rs2[0] VGND VGND VPWR VPWR input11/X sky130_fd_sc_hd__clkbuf_4
Xinput22 wd[14] VGND VGND VPWR VPWR input22/X sky130_fd_sc_hd__clkdlybuf4s25_1
X_4580_ _4987_/A1 _4606_/A2 _4606_/B1 _4580_/B2 VGND VGND VPWR VPWR _5629_/D sky130_fd_sc_hd__a22o_2
X_3600_ _3598_/X _3599_/X _3600_/S VGND VGND VPWR VPWR _3600_/X sky130_fd_sc_hd__mux2_1
XTAP_TAPCELL_ROW_12_395 VGND VPWR sky130_fd_sc_hd__tapvpwrvgnd_1
Xinput33 wd[24] VGND VGND VPWR VPWR input33/X sky130_fd_sc_hd__clkdlybuf4s25_1
Xinput44 wd[5] VGND VGND VPWR VPWR input44/X sky130_fd_sc_hd__clkdlybuf4s25_1
X_3531_ _5573_/Q _5541_/Q _3575_/S VGND VGND VPWR VPWR _3531_/X sky130_fd_sc_hd__mux2_1
XFILLER_6_371 VGND VGND VPWR VPWR sky130_fd_sc_hd__decap_3
XFILLER_115_225 VGND VGND VPWR VPWR sky130_fd_sc_hd__decap_3
X_3462_ _3832_/C1 _3454_/X _3457_/X _3452_/X VGND VGND VPWR VPWR _3462_/X sky130_fd_sc_hd__a31o_2
X_5201_ _6033_/CLK _5201_/D VGND VGND VPWR VPWR _5201_/Q sky130_fd_sc_hd__dfxtp_2
X_3393_ _3709_/A1 _3390_/X _3392_/X VGND VGND VPWR VPWR _3393_/X sky130_fd_sc_hd__a21o_2
XFILLER_69_334 VGND VGND VPWR VPWR sky130_fd_sc_hd__fill_2
XFILLER_97_632 VGND VGND VPWR VPWR sky130_fd_sc_hd__decap_3
Xload_slew731 fanout730/X VGND VGND VPWR VPWR _3108_/A sky130_fd_sc_hd__clkbuf_4
Xload_slew720 fanout719/X VGND VGND VPWR VPWR _3941_/A sky130_fd_sc_hd__clkbuf_4
X_5132_ _6023_/CLK _5132_/D VGND VGND VPWR VPWR _5132_/Q sky130_fd_sc_hd__dfxtp_2
XFILLER_69_345 VGND VGND VPWR VPWR sky130_fd_sc_hd__fill_1
Xhold1506 _5297_/Q VGND VGND VPWR VPWR _4223_/B2 sky130_fd_sc_hd__dlygate4sd3_1
Xhold1517 _5607_/Q VGND VGND VPWR VPWR _4556_/B2 sky130_fd_sc_hd__dlygate4sd3_1
Xload_slew753 _2911_/S1 VGND VGND VPWR VPWR _2610_/S1 sky130_fd_sc_hd__buf_4
Xhold1528 _5319_/Q VGND VGND VPWR VPWR _4247_/B2 sky130_fd_sc_hd__dlygate4sd3_1
Xhold1539 _5931_/Q VGND VGND VPWR VPWR _4899_/B2 sky130_fd_sc_hd__dlygate4sd3_1
Xload_slew797 _3133_/S VGND VGND VPWR VPWR _2772_/S sky130_fd_sc_hd__buf_2
X_5063_ _5258_/CLK _5063_/D VGND VGND VPWR VPWR _5063_/Q sky130_fd_sc_hd__dfxtp_2
XFILLER_37_231 VGND VGND VPWR VPWR sky130_fd_sc_hd__decap_3
XFILLER_84_348 VGND VGND VPWR VPWR sky130_fd_sc_hd__decap_3
X_4014_ _5007_/A1 _3988_/B _4019_/B1 _4014_/B2 VGND VGND VPWR VPWR _5105_/D sky130_fd_sc_hd__a22o_2
XFILLER_25_415 VGND VGND VPWR VPWR sky130_fd_sc_hd__decap_3
XFILLER_65_573 VGND VGND VPWR VPWR sky130_fd_sc_hd__decap_3
XFILLER_80_521 VGND VGND VPWR VPWR sky130_fd_sc_hd__decap_3
X_5965_ _6061_/CLK _5965_/D VGND VGND VPWR VPWR _5965_/Q sky130_fd_sc_hd__dfxtp_2
X_5896_ _6032_/CLK _5896_/D VGND VGND VPWR VPWR _5896_/Q sky130_fd_sc_hd__dfxtp_2
X_4916_ _5018_/A1 _4941_/A2 wire133/A _4916_/B2 VGND VGND VPWR VPWR _5946_/D sky130_fd_sc_hd__a22o_2
XFILLER_21_654 VGND VGND VPWR VPWR sky130_fd_sc_hd__fill_2
X_4847_ _5017_/A1 _4873_/A2 wire146/X _4847_/B2 VGND VGND VPWR VPWR _5881_/D sky130_fd_sc_hd__a22o_2
XFILLER_21_676 VGND VGND VPWR VPWR sky130_fd_sc_hd__decap_3
XFILLER_20_186 VGND VGND VPWR VPWR sky130_fd_sc_hd__fill_2
XFILLER_20_197 VGND VGND VPWR VPWR sky130_fd_sc_hd__fill_2
X_4778_ _3948_/B _4778_/B VGND VGND VPWR VPWR _5816_/D sky130_fd_sc_hd__and2b_2
X_3729_ _3433_/A _3726_/X _3728_/X _3745_/B2 VGND VGND VPWR VPWR _3729_/X sky130_fd_sc_hd__a22o_2
XFILLER_106_247 VGND VGND VPWR VPWR sky130_fd_sc_hd__decap_3
XFILLER_79_109 VGND VGND VPWR VPWR sky130_fd_sc_hd__decap_3
XFILLER_0_525 VGND VGND VPWR VPWR sky130_fd_sc_hd__decap_3
XFILLER_88_643 VGND VGND VPWR VPWR sky130_fd_sc_hd__fill_1
XFILLER_114_291 VGND VGND VPWR VPWR sky130_fd_sc_hd__fill_1
XFILLER_88_665 VGND VGND VPWR VPWR sky130_fd_sc_hd__decap_3
XFILLER_57_57 VGND VGND VPWR VPWR sky130_fd_sc_hd__fill_1
XFILLER_113_52 VGND VGND VPWR VPWR sky130_fd_sc_hd__decap_3
XFILLER_113_63 VGND VGND VPWR VPWR sky130_fd_sc_hd__decap_3
XFILLER_28_253 VGND VGND VPWR VPWR sky130_fd_sc_hd__decap_3
XFILLER_90_307 VGND VGND VPWR VPWR sky130_fd_sc_hd__fill_1
XFILLER_113_96 VGND VGND VPWR VPWR sky130_fd_sc_hd__decap_3
XFILLER_16_437 VGND VGND VPWR VPWR sky130_fd_sc_hd__decap_3
XFILLER_28_286 VGND VGND VPWR VPWR sky130_fd_sc_hd__fill_2
XFILLER_71_521 VGND VGND VPWR VPWR sky130_fd_sc_hd__decap_3
XFILLER_71_587 VGND VGND VPWR VPWR sky130_fd_sc_hd__decap_3
XFILLER_12_643 VGND VGND VPWR VPWR sky130_fd_sc_hd__fill_1
XTAP_TAPCELL_ROW_100_1449 VGND VPWR sky130_fd_sc_hd__tapvpwrvgnd_1
XFILLER_12_687 VGND VGND VPWR VPWR sky130_fd_sc_hd__fill_1
XFILLER_7_102 VGND VGND VPWR VPWR sky130_fd_sc_hd__fill_2
Xclkbuf_leaf_100_clk clkbuf_4_0_0_clk/X VGND VGND VPWR VPWR clkload8/A sky130_fd_sc_hd__clkbuf_8
XFILLER_98_429 VGND VGND VPWR VPWR sky130_fd_sc_hd__decap_3
XFILLER_79_643 VGND VGND VPWR VPWR sky130_fd_sc_hd__decap_3
XFILLER_98_97 VGND VGND VPWR VPWR sky130_fd_sc_hd__decap_3
XFILLER_78_153 VGND VGND VPWR VPWR sky130_fd_sc_hd__decap_3
XTAP_TAPCELL_ROW_111_1578 VGND VPWR sky130_fd_sc_hd__tapvpwrvgnd_1
Xfanout1131 wire1134/A VGND VGND VPWR VPWR _3645_/S sky130_fd_sc_hd__dlymetal6s4s_1
XFILLER_78_186 VGND VGND VPWR VPWR sky130_fd_sc_hd__decap_3
XFILLER_14_6 VGND VGND VPWR VPWR sky130_fd_sc_hd__decap_3
XFILLER_47_540 VGND VGND VPWR VPWR sky130_fd_sc_hd__fill_1
XFILLER_78_197 VGND VGND VPWR VPWR sky130_fd_sc_hd__fill_1
XFILLER_93_134 VGND VGND VPWR VPWR sky130_fd_sc_hd__decap_3
XFILLER_94_679 VGND VGND VPWR VPWR sky130_fd_sc_hd__fill_1
XFILLER_47_90 VGND VGND VPWR VPWR sky130_fd_sc_hd__decap_3
XFILLER_93_178 VGND VGND VPWR VPWR sky130_fd_sc_hd__decap_3
XTAP_TAPCELL_ROW_17_454 VGND VPWR sky130_fd_sc_hd__tapvpwrvgnd_1
XTAP_TAPCELL_ROW_66_1046 VGND VPWR sky130_fd_sc_hd__tapvpwrvgnd_1
XFILLER_15_470 VGND VGND VPWR VPWR sky130_fd_sc_hd__fill_1
XFILLER_62_587 VGND VGND VPWR VPWR sky130_fd_sc_hd__fill_1
XFILLER_97_3 VGND VGND VPWR VPWR sky130_fd_sc_hd__decap_3
XTAP_TAPCELL_ROW_45_785 VGND VPWR sky130_fd_sc_hd__tapvpwrvgnd_1
X_5750_ _5925_/CLK _5750_/D VGND VGND VPWR VPWR _5750_/Q sky130_fd_sc_hd__dfxtp_2
X_2962_ _2955_/X _2961_/X wire570/X VGND VGND VPWR VPWR _2962_/X sky130_fd_sc_hd__o21a_2
X_5681_ _6053_/CLK _5681_/D VGND VGND VPWR VPWR _5681_/Q sky130_fd_sc_hd__dfxtp_2
X_4701_ _4904_/A1 _4707_/A2 _4707_/B1 _4701_/B2 VGND VGND VPWR VPWR _5744_/D sky130_fd_sc_hd__a22o_2
X_4632_ _4903_/A1 _4639_/A2 _4639_/B1 _4632_/B2 VGND VGND VPWR VPWR _5679_/D sky130_fd_sc_hd__a22o_2
X_2893_ _3185_/B2 _2876_/X _2892_/X _3179_/A1 VGND VGND VPWR VPWR _2893_/X sky130_fd_sc_hd__a22o_2
XFILLER_8_62 VGND VGND VPWR VPWR sky130_fd_sc_hd__fill_1
X_4563_ _5038_/A1 wire421/X _4563_/B1 _4563_/B2 VGND VGND VPWR VPWR _5614_/D sky130_fd_sc_hd__a22o_2
X_4494_ _4528_/A1 _4494_/A2 _4494_/B1 _4494_/B2 VGND VGND VPWR VPWR _5550_/D sky130_fd_sc_hd__a22o_2
X_3514_ _5412_/Q _5060_/Q _3514_/S VGND VGND VPWR VPWR _3514_/X sky130_fd_sc_hd__mux2_1
XTAP_TAPCELL_ROW_77_1175 VGND VPWR sky130_fd_sc_hd__tapvpwrvgnd_1
Xmax_cap377 _4810_/Y VGND VGND VPWR VPWR fanout375/A sky130_fd_sc_hd__clkbuf_2
X_3445_ _3806_/A _3442_/X _3444_/X _3385_/A VGND VGND VPWR VPWR _3445_/X sky130_fd_sc_hd__a22o_2
XTAP_TAPCELL_ROW_90_1331 VGND VPWR sky130_fd_sc_hd__tapvpwrvgnd_1
Xhold2004 _5291_/Q VGND VGND VPWR VPWR _4217_/B2 sky130_fd_sc_hd__dlygate4sd3_1
Xhold2015 _5219_/Q VGND VGND VPWR VPWR _4140_/B2 sky130_fd_sc_hd__dlygate4sd3_1
Xhold2026 _5478_/Q VGND VGND VPWR VPWR _4418_/B2 sky130_fd_sc_hd__dlygate4sd3_1
Xload_slew550 _3899_/B1 VGND VGND VPWR VPWR _3855_/B1 sky130_fd_sc_hd__clkbuf_4
X_3376_ _3708_/A1 _3373_/X _3375_/X _3881_/B2 VGND VGND VPWR VPWR _3376_/X sky130_fd_sc_hd__a22o_2
XFILLER_111_250 VGND VGND VPWR VPWR sky130_fd_sc_hd__decap_3
XFILLER_57_315 VGND VGND VPWR VPWR sky130_fd_sc_hd__fill_1
XFILLER_69_186 VGND VGND VPWR VPWR sky130_fd_sc_hd__decap_3
Xhold1303 _5786_/Q VGND VGND VPWR VPWR _4748_/B2 sky130_fd_sc_hd__dlygate4sd3_1
Xhold1314 _5614_/Q VGND VGND VPWR VPWR _4563_/B2 sky130_fd_sc_hd__dlygate4sd3_1
Xhold1325 _5562_/Q VGND VGND VPWR VPWR _4508_/B2 sky130_fd_sc_hd__dlygate4sd3_1
Xhold2037 _5064_/Q VGND VGND VPWR VPWR _3968_/B2 sky130_fd_sc_hd__dlygate4sd3_1
Xhold2048 _5295_/Q VGND VGND VPWR VPWR _4221_/B2 sky130_fd_sc_hd__dlygate4sd3_1
Xhold2059 _5211_/Q VGND VGND VPWR VPWR _4132_/B2 sky130_fd_sc_hd__dlygate4sd3_1
X_5115_ _5938_/CLK _5115_/D VGND VGND VPWR VPWR _5115_/Q sky130_fd_sc_hd__dfxtp_2
XFILLER_27_27 VGND VGND VPWR VPWR sky130_fd_sc_hd__decap_3
Xhold1336 _5309_/Q VGND VGND VPWR VPWR _4237_/B2 sky130_fd_sc_hd__dlygate4sd3_1
Xhold1347 _5876_/Q VGND VGND VPWR VPWR _4840_/B2 sky130_fd_sc_hd__dlygate4sd3_1
Xhold1358 _5380_/Q VGND VGND VPWR VPWR _4312_/B2 sky130_fd_sc_hd__dlygate4sd3_1
Xload_slew594 _3543_/B2 VGND VGND VPWR VPWR _3694_/A sky130_fd_sc_hd__buf_4
X_5046_ _5046_/A1 wire332/X wire118/X _5046_/B2 VGND VGND VPWR VPWR _6070_/D sky130_fd_sc_hd__a22o_2
XFILLER_84_167 VGND VGND VPWR VPWR sky130_fd_sc_hd__decap_3
XFILLER_85_679 VGND VGND VPWR VPWR sky130_fd_sc_hd__fill_1
Xhold1369 _5718_/Q VGND VGND VPWR VPWR _4673_/B2 sky130_fd_sc_hd__dlygate4sd3_1
XFILLER_25_223 VGND VGND VPWR VPWR sky130_fd_sc_hd__fill_1
XFILLER_65_370 VGND VGND VPWR VPWR sky130_fd_sc_hd__decap_3
XFILLER_80_362 VGND VGND VPWR VPWR sky130_fd_sc_hd__fill_2
X_5948_ _6044_/CLK _5948_/D VGND VGND VPWR VPWR _5948_/Q sky130_fd_sc_hd__dfxtp_2
X_5879_ _5879_/CLK _5879_/D VGND VGND VPWR VPWR _5879_/Q sky130_fd_sc_hd__dfxtp_2
XFILLER_5_617 VGND VGND VPWR VPWR sky130_fd_sc_hd__decap_3
XFILLER_107_523 VGND VGND VPWR VPWR sky130_fd_sc_hd__decap_3
XFILLER_4_138 VGND VGND VPWR VPWR sky130_fd_sc_hd__fill_2
XFILLER_107_567 VGND VGND VPWR VPWR sky130_fd_sc_hd__decap_3
XFILLER_108_41 VGND VGND VPWR VPWR sky130_fd_sc_hd__decap_3
XFILLER_108_74 VGND VGND VPWR VPWR sky130_fd_sc_hd__decap_3
XFILLER_108_85 VGND VGND VPWR VPWR sky130_fd_sc_hd__decap_3
XFILLER_0_333 VGND VGND VPWR VPWR sky130_fd_sc_hd__decap_3
XFILLER_68_56 VGND VGND VPWR VPWR sky130_fd_sc_hd__decap_3
XFILLER_68_78 VGND VGND VPWR VPWR sky130_fd_sc_hd__decap_3
XFILLER_76_602 VGND VGND VPWR VPWR sky130_fd_sc_hd__fill_2
XFILLER_91_627 VGND VGND VPWR VPWR sky130_fd_sc_hd__decap_3
Xhold1870 _5395_/Q VGND VGND VPWR VPWR _4327_/B2 sky130_fd_sc_hd__dlygate4sd3_1
Xhold1881 _5146_/Q VGND VGND VPWR VPWR _4062_/B2 sky130_fd_sc_hd__dlygate4sd3_1
XFILLER_84_88 VGND VGND VPWR VPWR sky130_fd_sc_hd__decap_3
Xhold1892 _5302_/Q VGND VGND VPWR VPWR _4228_/B2 sky130_fd_sc_hd__dlygate4sd3_1
XFILLER_16_289 VGND VGND VPWR VPWR sky130_fd_sc_hd__fill_2
XFILLER_31_215 VGND VGND VPWR VPWR sky130_fd_sc_hd__fill_1
XTAP_TAPCELL_ROW_14_413 VGND VPWR sky130_fd_sc_hd__tapvpwrvgnd_1
XTAP_TAPCELL_ROW_42_755 VGND VPWR sky130_fd_sc_hd__tapvpwrvgnd_1
XFILLER_8_455 VGND VGND VPWR VPWR sky130_fd_sc_hd__decap_3
XFILLER_8_477 VGND VGND VPWR VPWR sky130_fd_sc_hd__decap_3
XTAP_TAPCELL_ROW_113_1607 VGND VPWR sky130_fd_sc_hd__tapvpwrvgnd_1
XFILLER_4_672 VGND VGND VPWR VPWR sky130_fd_sc_hd__decap_3
XFILLER_98_215 VGND VGND VPWR VPWR sky130_fd_sc_hd__fill_2
XFILLER_113_559 VGND VGND VPWR VPWR sky130_fd_sc_hd__fill_1
X_3230_ _3230_/A1 _3213_/X _3229_/X _3230_/B2 VGND VGND VPWR VPWR _3230_/X sky130_fd_sc_hd__a22o_2
XFILLER_100_209 VGND VGND VPWR VPWR sky130_fd_sc_hd__fill_1
X_3161_ _3198_/A _3157_/X _3160_/X _3207_/B2 VGND VGND VPWR VPWR _3161_/X sky130_fd_sc_hd__o211a_2
XFILLER_12_3 VGND VGND VPWR VPWR sky130_fd_sc_hd__decap_3
XFILLER_67_646 VGND VGND VPWR VPWR sky130_fd_sc_hd__fill_2
XFILLER_54_307 VGND VGND VPWR VPWR sky130_fd_sc_hd__fill_1
XFILLER_67_679 VGND VGND VPWR VPWR sky130_fd_sc_hd__fill_1
X_3092_ _5521_/Q _5489_/Q _3093_/S VGND VGND VPWR VPWR _3092_/X sky130_fd_sc_hd__mux2_1
XFILLER_66_189 VGND VGND VPWR VPWR sky130_fd_sc_hd__decap_3
XFILLER_35_598 VGND VGND VPWR VPWR sky130_fd_sc_hd__decap_3
XFILLER_62_362 VGND VGND VPWR VPWR sky130_fd_sc_hd__fill_2
X_5802_ _5802_/CLK _5802_/D VGND VGND VPWR VPWR _5802_/Q sky130_fd_sc_hd__dfxtp_2
XFILLER_22_226 VGND VGND VPWR VPWR sky130_fd_sc_hd__fill_1
X_3994_ _4987_/A1 _4015_/A2 _4015_/B1 _3994_/B2 VGND VGND VPWR VPWR _5085_/D sky130_fd_sc_hd__a22o_2
X_5733_ _5797_/CLK _5733_/D VGND VGND VPWR VPWR _5733_/Q sky130_fd_sc_hd__dfxtp_2
X_2945_ _5131_/Q _5099_/Q _6027_/Q _5995_/Q _3069_/S wire772/X VGND VGND VPWR VPWR
+ _2946_/B sky130_fd_sc_hd__mux4_2
X_5664_ _5934_/CLK _5664_/D VGND VGND VPWR VPWR _5664_/Q sky130_fd_sc_hd__dfxtp_2
X_2876_ _3027_/B2 _2873_/X _2875_/X VGND VGND VPWR VPWR _2876_/X sky130_fd_sc_hd__a21o_2
X_5595_ _5691_/CLK _5595_/D VGND VGND VPWR VPWR _5595_/Q sky130_fd_sc_hd__dfxtp_2
X_4615_ _4752_/A1 _4640_/A2 _4640_/B1 _4615_/B2 VGND VGND VPWR VPWR _5662_/D sky130_fd_sc_hd__a22o_2
X_4546_ _4987_/A1 _4572_/A2 _4572_/B1 _4546_/B2 VGND VGND VPWR VPWR _5597_/D sky130_fd_sc_hd__a22o_2
X_4477_ _5021_/A1 _4498_/A2 _4498_/B1 _4477_/B2 VGND VGND VPWR VPWR _5533_/D sky130_fd_sc_hd__a22o_2
Xfanout924 input34/X VGND VGND VPWR VPWR _4771_/A1 sky130_fd_sc_hd__clkdlybuf4s25_1
Xfanout913 _4533_/A1 VGND VGND VPWR VPWR _5043_/A1 sky130_fd_sc_hd__clkdlybuf4s25_1
Xfanout902 _4508_/A1 VGND VGND VPWR VPWR _4984_/A1 sky130_fd_sc_hd__clkdlybuf4s25_1
X_3428_ _3619_/A1 _3426_/X _3427_/X _3745_/B2 VGND VGND VPWR VPWR _3428_/X sky130_fd_sc_hd__a22o_2
Xfanout968 input22/X VGND VGND VPWR VPWR _4894_/A1 sky130_fd_sc_hd__clkdlybuf4s25_1
Xfanout957 _4999_/A1 VGND VGND VPWR VPWR _5033_/A1 sky130_fd_sc_hd__clkdlybuf4s25_1
Xfanout946 input28/X VGND VGND VPWR VPWR _4747_/A1 sky130_fd_sc_hd__clkdlybuf4s25_1
Xfanout935 input31/X VGND VGND VPWR VPWR _4528_/A1 sky130_fd_sc_hd__clkdlybuf4s25_1
X_3359_ _3357_/X _3358_/X _3470_/S VGND VGND VPWR VPWR _3359_/X sky130_fd_sc_hd__mux2_1
XFILLER_112_581 VGND VGND VPWR VPWR sky130_fd_sc_hd__decap_3
XFILLER_112_592 VGND VGND VPWR VPWR sky130_fd_sc_hd__decap_3
XFILLER_97_281 VGND VGND VPWR VPWR sky130_fd_sc_hd__decap_3
Xfanout979 input20/X VGND VGND VPWR VPWR _4994_/A1 sky130_fd_sc_hd__clkdlybuf4s25_1
Xload_slew391 _4736_/A2 VGND VGND VPWR VPWR _4742_/A2 sky130_fd_sc_hd__buf_4
XFILLER_57_145 VGND VGND VPWR VPWR sky130_fd_sc_hd__decap_3
Xhold1144 _6053_/Q VGND VGND VPWR VPWR _5029_/B2 sky130_fd_sc_hd__dlygate4sd3_1
Xhold1155 _5513_/Q VGND VGND VPWR VPWR _4455_/B2 sky130_fd_sc_hd__dlygate4sd3_1
Xhold1166 _5427_/Q VGND VGND VPWR VPWR _4361_/B2 sky130_fd_sc_hd__dlygate4sd3_1
XFILLER_72_115 VGND VGND VPWR VPWR sky130_fd_sc_hd__decap_3
XFILLER_73_638 VGND VGND VPWR VPWR sky130_fd_sc_hd__decap_3
Xhold1177 _5498_/Q VGND VGND VPWR VPWR _4440_/B2 sky130_fd_sc_hd__dlygate4sd3_1
Xhold1188 _5590_/Q VGND VGND VPWR VPWR _4536_/B2 sky130_fd_sc_hd__dlygate4sd3_1
Xhold1199 _5425_/Q VGND VGND VPWR VPWR _4359_/B2 sky130_fd_sc_hd__dlygate4sd3_1
X_5029_ _5029_/A1 wire334/X wire118/A _5029_/B2 VGND VGND VPWR VPWR _6053_/D sky130_fd_sc_hd__a22o_2
XFILLER_72_159 VGND VGND VPWR VPWR sky130_fd_sc_hd__decap_3
XFILLER_110_53 VGND VGND VPWR VPWR sky130_fd_sc_hd__decap_3
XFILLER_13_248 VGND VGND VPWR VPWR sky130_fd_sc_hd__decap_3
XFILLER_70_24 VGND VGND VPWR VPWR sky130_fd_sc_hd__decap_3
XFILLER_9_219 VGND VGND VPWR VPWR sky130_fd_sc_hd__decap_3
XFILLER_110_97 VGND VGND VPWR VPWR sky130_fd_sc_hd__decap_3
XFILLER_21_270 VGND VGND VPWR VPWR sky130_fd_sc_hd__decap_3
XFILLER_21_281 VGND VGND VPWR VPWR sky130_fd_sc_hd__fill_2
XFILLER_1_620 VGND VGND VPWR VPWR sky130_fd_sc_hd__decap_3
XFILLER_79_66 VGND VGND VPWR VPWR sky130_fd_sc_hd__decap_3
XFILLER_110_507 VGND VGND VPWR VPWR sky130_fd_sc_hd__fill_1
XFILLER_1_653 VGND VGND VPWR VPWR sky130_fd_sc_hd__decap_3
XFILLER_0_141 VGND VGND VPWR VPWR sky130_fd_sc_hd__decap_3
XFILLER_110_529 VGND VGND VPWR VPWR sky130_fd_sc_hd__decap_3
XFILLER_49_602 VGND VGND VPWR VPWR sky130_fd_sc_hd__decap_3
XFILLER_95_218 VGND VGND VPWR VPWR sky130_fd_sc_hd__decap_3
XFILLER_76_421 VGND VGND VPWR VPWR sky130_fd_sc_hd__decap_3
XFILLER_36_307 VGND VGND VPWR VPWR sky130_fd_sc_hd__fill_1
XTAP_TAPCELL_ROW_47_814 VGND VPWR sky130_fd_sc_hd__tapvpwrvgnd_1
Xload_slew1130 _3402_/S VGND VGND VPWR VPWR _3700_/S sky130_fd_sc_hd__clkbuf_4
XFILLER_63_159 VGND VGND VPWR VPWR sky130_fd_sc_hd__fill_1
XTAP_TAPCELL_ROW_27_571 VGND VPWR sky130_fd_sc_hd__tapvpwrvgnd_1
XTAP_TAPCELL_ROW_63_1005 VGND VPWR sky130_fd_sc_hd__tapvpwrvgnd_1
XFILLER_12_281 VGND VGND VPWR VPWR sky130_fd_sc_hd__decap_3
XFILLER_81_6 VGND VGND VPWR VPWR sky130_fd_sc_hd__decap_3
X_2730_ _2730_/A _2730_/B VGND VGND VPWR VPWR _2730_/X sky130_fd_sc_hd__or2_2
XFILLER_8_263 VGND VGND VPWR VPWR sky130_fd_sc_hd__decap_3
X_2661_ _5502_/Q _5470_/Q _2998_/S VGND VGND VPWR VPWR _2661_/X sky130_fd_sc_hd__mux2_1
X_4400_ _5013_/A1 wire459/X _4400_/B1 _4400_/B2 VGND VGND VPWR VPWR _5463_/D sky130_fd_sc_hd__a22o_2
XFILLER_5_30 VGND VGND VPWR VPWR sky130_fd_sc_hd__decap_3
X_5380_ _5572_/CLK _5380_/D VGND VGND VPWR VPWR _5380_/Q sky130_fd_sc_hd__dfxtp_2
X_2592_ _5179_/Q _5147_/Q _2593_/S VGND VGND VPWR VPWR _2592_/X sky130_fd_sc_hd__mux2_1
XFILLER_5_63 VGND VGND VPWR VPWR sky130_fd_sc_hd__fill_1
XTAP_TAPCELL_ROW_74_1134 VGND VPWR sky130_fd_sc_hd__tapvpwrvgnd_1
X_4331_ _4843_/A1 _4331_/A2 _4331_/B1 _4331_/B2 VGND VGND VPWR VPWR _5399_/D sky130_fd_sc_hd__a22o_2
XFILLER_4_480 VGND VGND VPWR VPWR sky130_fd_sc_hd__fill_1
Xfanout209 _4505_/Y VGND VGND VPWR VPWR _4530_/B1 sky130_fd_sc_hd__clkdlybuf4s25_1
X_4262_ _5012_/A1 _4263_/A2 _4263_/B1 _4262_/B2 VGND VGND VPWR VPWR _5334_/D sky130_fd_sc_hd__a22o_2
X_6001_ _6033_/CLK _6001_/D VGND VGND VPWR VPWR _6001_/Q sky130_fd_sc_hd__dfxtp_2
X_3213_ _3228_/B2 _3210_/X _3212_/X VGND VGND VPWR VPWR _3213_/X sky130_fd_sc_hd__a21o_2
X_4193_ _5012_/A1 wire500/A wire281/A _4193_/B2 VGND VGND VPWR VPWR _5270_/D sky130_fd_sc_hd__a22o_2
XFILLER_39_145 VGND VGND VPWR VPWR sky130_fd_sc_hd__decap_3
XFILLER_82_402 VGND VGND VPWR VPWR sky130_fd_sc_hd__decap_3
X_3144_ _5268_/Q _5236_/Q _3145_/S VGND VGND VPWR VPWR _3144_/X sky130_fd_sc_hd__mux2_1
XFILLER_54_115 VGND VGND VPWR VPWR sky130_fd_sc_hd__fill_2
XFILLER_94_295 VGND VGND VPWR VPWR sky130_fd_sc_hd__decap_3
XPHY_EDGE_ROW_19_Left_135 VGND VGND VPWR VPWR sky130_fd_sc_hd__decap_3
X_3075_ _5713_/Q _5681_/Q _5649_/Q _5617_/Q _3077_/S _3091_/S1 VGND VGND VPWR VPWR
+ _3075_/X sky130_fd_sc_hd__mux4_2
XFILLER_82_446 VGND VGND VPWR VPWR sky130_fd_sc_hd__fill_1
XFILLER_23_502 VGND VGND VPWR VPWR sky130_fd_sc_hd__fill_2
XFILLER_63_671 VGND VGND VPWR VPWR sky130_fd_sc_hd__fill_1
XFILLER_63_682 VGND VGND VPWR VPWR sky130_fd_sc_hd__decap_3
XTAP_TAPCELL_ROW_85_1274 VGND VPWR sky130_fd_sc_hd__tapvpwrvgnd_1
XFILLER_62_192 VGND VGND VPWR VPWR sky130_fd_sc_hd__decap_3
XFILLER_50_365 VGND VGND VPWR VPWR sky130_fd_sc_hd__fill_1
X_3977_ _4771_/A1 wire548/X wire327/X _3977_/B2 VGND VGND VPWR VPWR _5073_/D sky130_fd_sc_hd__a22o_2
X_5716_ _6068_/CLK _5716_/D VGND VGND VPWR VPWR _5716_/Q sky130_fd_sc_hd__dfxtp_2
X_2928_ _5130_/Q _5098_/Q _6026_/Q _5994_/Q _2863_/S _3214_/S1 VGND VGND VPWR VPWR
+ _2929_/B sky130_fd_sc_hd__mux4_2
XFILLER_109_607 VGND VGND VPWR VPWR sky130_fd_sc_hd__decap_3
XPHY_EDGE_ROW_28_Left_144 VGND VGND VPWR VPWR sky130_fd_sc_hd__decap_3
X_5647_ _5956_/CLK _5647_/D VGND VGND VPWR VPWR _5647_/Q sky130_fd_sc_hd__dfxtp_2
X_2859_ _3081_/A _2855_/X _2858_/X _3223_/C1 VGND VGND VPWR VPWR _2859_/X sky130_fd_sc_hd__o211a_2
X_5578_ _5578_/CLK _5578_/D VGND VGND VPWR VPWR _5578_/Q sky130_fd_sc_hd__dfxtp_2
XFILLER_104_312 VGND VGND VPWR VPWR sky130_fd_sc_hd__fill_2
XFILLER_2_417 VGND VGND VPWR VPWR sky130_fd_sc_hd__decap_3
X_4529_ _4529_/A1 wire431/X _4536_/B1 _4529_/B2 VGND VGND VPWR VPWR _5583_/D sky130_fd_sc_hd__a22o_2
Xfanout732 _3206_/A1 VGND VGND VPWR VPWR _2816_/A sky130_fd_sc_hd__clkdlybuf4s25_1
XFILLER_58_443 VGND VGND VPWR VPWR sky130_fd_sc_hd__fill_1
XPHY_EDGE_ROW_37_Left_153 VGND VGND VPWR VPWR sky130_fd_sc_hd__decap_3
Xfanout765 input7/X VGND VGND VPWR VPWR fanout765/X sky130_fd_sc_hd__clkbuf_2
Xfanout754 fanout765/X VGND VGND VPWR VPWR _3180_/S1 sky130_fd_sc_hd__clkdlybuf4s25_1
XFILLER_105_75 VGND VGND VPWR VPWR sky130_fd_sc_hd__decap_3
XFILLER_46_605 VGND VGND VPWR VPWR sky130_fd_sc_hd__decap_3
Xfanout798 _3166_/S VGND VGND VPWR VPWR _2878_/S sky130_fd_sc_hd__dlymetal6s2s_1
XFILLER_65_57 VGND VGND VPWR VPWR sky130_fd_sc_hd__decap_3
XFILLER_26_362 VGND VGND VPWR VPWR sky130_fd_sc_hd__fill_2
XFILLER_73_479 VGND VGND VPWR VPWR sky130_fd_sc_hd__decap_3
Xclkbuf_leaf_80_clk clkbuf_4_4_0_clk/X VGND VGND VPWR VPWR _6043_/CLK sky130_fd_sc_hd__clkbuf_8
XTAP_TAPCELL_ROW_24_541 VGND VPWR sky130_fd_sc_hd__tapvpwrvgnd_1
XTAP_TAPCELL_ROW_52_872 VGND VPWR sky130_fd_sc_hd__tapvpwrvgnd_1
XPHY_EDGE_ROW_46_Left_162 VGND VGND VPWR VPWR sky130_fd_sc_hd__decap_3
XFILLER_14_94 VGND VGND VPWR VPWR sky130_fd_sc_hd__decap_3
XFILLER_108_651 VGND VGND VPWR VPWR sky130_fd_sc_hd__decap_3
XFILLER_107_150 VGND VGND VPWR VPWR sky130_fd_sc_hd__fill_2
XFILLER_107_172 VGND VGND VPWR VPWR sky130_fd_sc_hd__decap_3
XFILLER_108_684 VGND VGND VPWR VPWR sky130_fd_sc_hd__decap_3
XFILLER_114_109 VGND VGND VPWR VPWR sky130_fd_sc_hd__fill_2
XPHY_EDGE_ROW_55_Left_171 VGND VGND VPWR VPWR sky130_fd_sc_hd__decap_3
XFILLER_64_435 VGND VGND VPWR VPWR sky130_fd_sc_hd__decap_3
XFILLER_91_210 VGND VGND VPWR VPWR sky130_fd_sc_hd__decap_3
Xinput9 rs1[3] VGND VGND VPWR VPWR input9/X sky130_fd_sc_hd__clkdlybuf4s25_1
XFILLER_17_351 VGND VGND VPWR VPWR sky130_fd_sc_hd__decap_3
XFILLER_45_682 VGND VGND VPWR VPWR sky130_fd_sc_hd__decap_3
Xclkbuf_leaf_71_clk clkload3/A VGND VGND VPWR VPWR _5810_/CLK sky130_fd_sc_hd__clkbuf_8
X_4880_ _4880_/A1 _4910_/A2 _4908_/B1 _4880_/B2 VGND VGND VPWR VPWR _5912_/D sky130_fd_sc_hd__a22o_2
X_3900_ _5398_/Q _5366_/Q _5334_/Q _5302_/Q _3762_/S _3917_/S1 VGND VGND VPWR VPWR
+ _3900_/X sky130_fd_sc_hd__mux4_2
XFILLER_32_365 VGND VGND VPWR VPWR sky130_fd_sc_hd__decap_3
XPHY_EDGE_ROW_64_Left_180 VGND VGND VPWR VPWR sky130_fd_sc_hd__decap_3
X_3831_ _3831_/A1 _3829_/X _3830_/X _3831_/B2 VGND VGND VPWR VPWR _3831_/X sky130_fd_sc_hd__o22a_2
XFILLER_60_685 VGND VGND VPWR VPWR sky130_fd_sc_hd__decap_3
X_3762_ _5199_/Q _5167_/Q _3762_/S VGND VGND VPWR VPWR _3763_/B sky130_fd_sc_hd__mux2_1
X_5501_ _5922_/CLK _5501_/D VGND VGND VPWR VPWR _5501_/Q sky130_fd_sc_hd__dfxtp_2
XFILLER_9_583 VGND VGND VPWR VPWR sky130_fd_sc_hd__decap_3
X_3693_ _5196_/Q _5164_/Q _3693_/S VGND VGND VPWR VPWR _3694_/B sky130_fd_sc_hd__mux2_1
X_2713_ _5121_/Q _5089_/Q _6017_/Q _5985_/Q _2980_/S _3225_/S1 VGND VGND VPWR VPWR
+ _2713_/X sky130_fd_sc_hd__mux4_2
X_5432_ _6040_/CLK _5432_/D VGND VGND VPWR VPWR _5432_/Q sky130_fd_sc_hd__dfxtp_2
X_2644_ _5822_/Q _5438_/Q _2889_/S VGND VGND VPWR VPWR _2644_/X sky130_fd_sc_hd__mux2_1
XFILLER_114_610 VGND VGND VPWR VPWR sky130_fd_sc_hd__decap_3
X_5363_ _5500_/CLK _5363_/D VGND VGND VPWR VPWR _5363_/Q sky130_fd_sc_hd__dfxtp_2
X_2575_ _5915_/Q _5883_/Q _5851_/Q _5755_/Q _2564_/S wire760/X VGND VGND VPWR VPWR
+ _2576_/B sky130_fd_sc_hd__mux4_2
XFILLER_114_643 VGND VGND VPWR VPWR sky130_fd_sc_hd__fill_1
XFILLER_114_654 VGND VGND VPWR VPWR sky130_fd_sc_hd__decap_3
X_4314_ _4520_/A1 _4329_/A2 _4321_/B1 _4314_/B2 VGND VGND VPWR VPWR _5382_/D sky130_fd_sc_hd__a22o_2
XFILLER_114_687 VGND VGND VPWR VPWR sky130_fd_sc_hd__fill_1
XFILLER_87_505 VGND VGND VPWR VPWR sky130_fd_sc_hd__decap_3
X_5294_ _5838_/CLK _5294_/D VGND VGND VPWR VPWR _5294_/Q sky130_fd_sc_hd__dfxtp_2
XFILLER_101_337 VGND VGND VPWR VPWR sky130_fd_sc_hd__decap_3
XFILLER_19_17 VGND VGND VPWR VPWR sky130_fd_sc_hd__fill_1
XFILLER_87_549 VGND VGND VPWR VPWR sky130_fd_sc_hd__decap_3
X_4245_ _4519_/A1 _4231_/B _4260_/B1 _4245_/B2 VGND VGND VPWR VPWR _5317_/D sky130_fd_sc_hd__a22o_2
X_4176_ _4995_/A1 _4188_/A2 _4191_/B1 _4176_/B2 VGND VGND VPWR VPWR _5253_/D sky130_fd_sc_hd__a22o_2
XFILLER_28_627 VGND VGND VPWR VPWR sky130_fd_sc_hd__decap_3
X_3127_ _5203_/Q _5171_/Q _3170_/S VGND VGND VPWR VPWR _3127_/X sky130_fd_sc_hd__mux2_1
XFILLER_55_446 VGND VGND VPWR VPWR sky130_fd_sc_hd__fill_2
XTAP_TAPCELL_ROW_2_269 VGND VPWR sky130_fd_sc_hd__tapvpwrvgnd_1
X_3058_ _3058_/A _3058_/B VGND VGND VPWR VPWR _3058_/X sky130_fd_sc_hd__or2_2
XFILLER_23_321 VGND VGND VPWR VPWR sky130_fd_sc_hd__fill_1
Xclkbuf_leaf_62_clk clkbuf_4_12_0_clk/X VGND VGND VPWR VPWR _5879_/CLK sky130_fd_sc_hd__clkbuf_8
XFILLER_11_505 VGND VGND VPWR VPWR sky130_fd_sc_hd__fill_1
XTAP_TAPCELL_ROW_21_500 VGND VPWR sky130_fd_sc_hd__tapvpwrvgnd_1
Xwire407 wire407/A VGND VGND VPWR VPWR wire407/X sky130_fd_sc_hd__buf_4
XTAP_TAPCELL_ROW_98_1421 VGND VPWR sky130_fd_sc_hd__tapvpwrvgnd_1
XFILLER_104_131 VGND VGND VPWR VPWR sky130_fd_sc_hd__fill_2
XFILLER_105_665 VGND VGND VPWR VPWR sky130_fd_sc_hd__decap_3
XFILLER_105_676 VGND VGND VPWR VPWR sky130_fd_sc_hd__decap_3
Xfanout551 _3235_/X VGND VGND VPWR VPWR _3614_/A sky130_fd_sc_hd__buf_2
XFILLER_58_251 VGND VGND VPWR VPWR sky130_fd_sc_hd__fill_1
XFILLER_86_560 VGND VGND VPWR VPWR sky130_fd_sc_hd__decap_3
Xfanout584 _3239_/Y VGND VGND VPWR VPWR _3896_/A1 sky130_fd_sc_hd__dlymetal6s2s_1
Xfanout573 _3261_/X VGND VGND VPWR VPWR _3909_/B1 sky130_fd_sc_hd__clkbuf_4
Xfanout562 _3207_/B2 VGND VGND VPWR VPWR _3185_/A1 sky130_fd_sc_hd__clkdlybuf4s25_1
XTAP_TAPCELL_ROW_29_600 VGND VPWR sky130_fd_sc_hd__tapvpwrvgnd_1
Xfanout595 _3239_/Y VGND VGND VPWR VPWR _3944_/B2 sky130_fd_sc_hd__buf_2
XFILLER_18_159 VGND VGND VPWR VPWR sky130_fd_sc_hd__fill_1
XTAP_TAPCELL_ROW_57_931 VGND VPWR sky130_fd_sc_hd__tapvpwrvgnd_1
Xclkbuf_leaf_53_clk clkload7/A VGND VGND VPWR VPWR _6026_/CLK sky130_fd_sc_hd__clkbuf_8
XFILLER_42_685 VGND VGND VPWR VPWR sky130_fd_sc_hd__decap_3
Xclkbuf_4_6_0_clk clkbuf_0_clk/X VGND VGND VPWR VPWR clkbuf_4_6_0_clk/X sky130_fd_sc_hd__clkbuf_8
XFILLER_111_602 VGND VGND VPWR VPWR sky130_fd_sc_hd__decap_3
XTAP_TAPCELL_ROW_71_1104 VGND VPWR sky130_fd_sc_hd__tapvpwrvgnd_1
XFILLER_111_635 VGND VGND VPWR VPWR sky130_fd_sc_hd__decap_3
XFILLER_111_668 VGND VGND VPWR VPWR sky130_fd_sc_hd__decap_3
XFILLER_111_679 VGND VGND VPWR VPWR sky130_fd_sc_hd__decap_3
XFILLER_2_53 VGND VGND VPWR VPWR sky130_fd_sc_hd__decap_3
XFILLER_96_357 VGND VGND VPWR VPWR sky130_fd_sc_hd__decap_3
XPHY_EDGE_ROW_10_Right_10 VGND VGND VPWR VPWR sky130_fd_sc_hd__decap_3
X_4030_ _4752_/A1 _4050_/A2 _4050_/B1 _4030_/B2 VGND VGND VPWR VPWR _5118_/D sky130_fd_sc_hd__a22o_2
XFILLER_110_178 VGND VGND VPWR VPWR sky130_fd_sc_hd__fill_2
XFILLER_37_402 VGND VGND VPWR VPWR sky130_fd_sc_hd__decap_3
XFILLER_92_552 VGND VGND VPWR VPWR sky130_fd_sc_hd__fill_1
XFILLER_64_276 VGND VGND VPWR VPWR sky130_fd_sc_hd__decap_3
XFILLER_92_585 VGND VGND VPWR VPWR sky130_fd_sc_hd__decap_3
XTAP_TAPCELL_ROW_69_1077 VGND VPWR sky130_fd_sc_hd__tapvpwrvgnd_1
X_5981_ _6013_/CLK _5981_/D VGND VGND VPWR VPWR _5981_/Q sky130_fd_sc_hd__dfxtp_2
Xclkbuf_leaf_44_clk clkbuf_4_14_0_clk/X VGND VGND VPWR VPWR _6053_/CLK sky130_fd_sc_hd__clkbuf_8
X_4932_ _5034_/A1 wire355/X _4945_/B1 _4932_/B2 VGND VGND VPWR VPWR _5962_/D sky130_fd_sc_hd__a22o_2
XTAP_TAPCELL_ROW_35_669 VGND VPWR sky130_fd_sc_hd__tapvpwrvgnd_1
XTAP_TAPCELL_ROW_82_1233 VGND VPWR sky130_fd_sc_hd__tapvpwrvgnd_1
XANTENNA_14 fanout157/A VGND VGND VPWR VPWR sky130_fd_sc_hd__diode_2
XFILLER_20_302 VGND VGND VPWR VPWR sky130_fd_sc_hd__decap_3
X_4863_ _4999_/A1 _4873_/A2 wire146/X _4863_/B2 VGND VGND VPWR VPWR _5897_/D sky130_fd_sc_hd__a22o_2
XANTENNA_25 _3941_/A VGND VGND VPWR VPWR sky130_fd_sc_hd__diode_2
XANTENNA_36 _3239_/Y VGND VGND VPWR VPWR sky130_fd_sc_hd__diode_2
XANTENNA_47 _3155_/S0 VGND VGND VPWR VPWR sky130_fd_sc_hd__diode_2
X_4794_ _5015_/A _4794_/B VGND VGND VPWR VPWR _5832_/D sky130_fd_sc_hd__and2b_2
X_3814_ _3798_/X _3807_/X _3813_/X _3946_/B1 VGND VGND VPWR VPWR _3814_/X sky130_fd_sc_hd__o31a_2
X_3745_ _3745_/A1 _3742_/X _3744_/X _3745_/B2 VGND VGND VPWR VPWR _3745_/X sky130_fd_sc_hd__a22o_2
Xoutput110 _3395_/X VGND VGND VPWR VPWR rd2[6] sky130_fd_sc_hd__dlymetal6s2s_1
X_5415_ _5799_/CLK _5415_/D VGND VGND VPWR VPWR _5415_/Q sky130_fd_sc_hd__dfxtp_2
X_3676_ _6059_/Q _5963_/Q _3676_/S VGND VGND VPWR VPWR _3676_/X sky130_fd_sc_hd__mux2_1
X_2627_ _5181_/Q _5149_/Q _2627_/S VGND VGND VPWR VPWR _2627_/X sky130_fd_sc_hd__mux2_1
XFILLER_114_451 VGND VGND VPWR VPWR sky130_fd_sc_hd__decap_3
XTAP_TAPCELL_ROW_7_328 VGND VPWR sky130_fd_sc_hd__tapvpwrvgnd_1
XTAP_TAPCELL_ROW_7_339 VGND VPWR sky130_fd_sc_hd__tapvpwrvgnd_1
X_5346_ _5704_/CLK _5346_/D VGND VGND VPWR VPWR _5346_/Q sky130_fd_sc_hd__dfxtp_2
X_2558_ _2558_/A _2558_/B VGND VGND VPWR VPWR _2561_/A sky130_fd_sc_hd__and2_2
XTAP_TAPCELL_ROW_93_1362 VGND VPWR sky130_fd_sc_hd__tapvpwrvgnd_1
XFILLER_87_335 VGND VGND VPWR VPWR sky130_fd_sc_hd__fill_1
X_5277_ _5885_/CLK _5277_/D VGND VGND VPWR VPWR _5277_/Q sky130_fd_sc_hd__dfxtp_2
X_4228_ _5012_/A1 _4229_/A2 _4229_/B1 _4228_/B2 VGND VGND VPWR VPWR _5302_/D sky130_fd_sc_hd__a22o_2
XFILLER_83_530 VGND VGND VPWR VPWR sky130_fd_sc_hd__decap_3
XPHY_EDGE_ROW_106_Right_106 VGND VGND VPWR VPWR sky130_fd_sc_hd__decap_3
X_4159_ _5012_/A1 wire508/A wire290/A _4159_/B2 VGND VGND VPWR VPWR _5238_/D sky130_fd_sc_hd__a22o_2
XFILLER_102_10 VGND VGND VPWR VPWR sky130_fd_sc_hd__decap_3
XTAP_TAPCELL_ROW_54_901 VGND VPWR sky130_fd_sc_hd__tapvpwrvgnd_1
XFILLER_43_449 VGND VGND VPWR VPWR sky130_fd_sc_hd__fill_2
XFILLER_62_14 VGND VGND VPWR VPWR sky130_fd_sc_hd__decap_3
Xclkbuf_leaf_35_clk clkload4/A VGND VGND VPWR VPWR _6038_/CLK sky130_fd_sc_hd__clkbuf_8
XFILLER_24_685 VGND VGND VPWR VPWR sky130_fd_sc_hd__decap_3
Xwire248 wire248/A VGND VGND VPWR VPWR wire248/X sky130_fd_sc_hd__clkbuf_4
XFILLER_87_11 VGND VGND VPWR VPWR sky130_fd_sc_hd__fill_1
XFILLER_19_413 VGND VGND VPWR VPWR sky130_fd_sc_hd__fill_2
Xfanout392 _4675_/Y VGND VGND VPWR VPWR _4676_/B sky130_fd_sc_hd__clkdlybuf4s25_1
Xfanout381 fanout383/A VGND VGND VPWR VPWR _4762_/A2 sky130_fd_sc_hd__clkdlybuf4s25_1
Xfanout370 _4810_/Y VGND VGND VPWR VPWR wire371/A sky130_fd_sc_hd__clkdlybuf4s25_1
XFILLER_74_530 VGND VGND VPWR VPWR sky130_fd_sc_hd__fill_2
XFILLER_86_390 VGND VGND VPWR VPWR sky130_fd_sc_hd__decap_3
XTAP_TAPCELL_ROW_105_1509 VGND VPWR sky130_fd_sc_hd__tapvpwrvgnd_1
XFILLER_61_257 VGND VGND VPWR VPWR sky130_fd_sc_hd__fill_1
Xclkbuf_leaf_26_clk clkbuf_4_10_0_clk/X VGND VGND VPWR VPWR _5956_/CLK sky130_fd_sc_hd__clkbuf_8
XFILLER_15_685 VGND VGND VPWR VPWR sky130_fd_sc_hd__decap_3
XTAP_TAPCELL_ROW_32_628 VGND VPWR sky130_fd_sc_hd__tapvpwrvgnd_1
XTAP_TAPCELL_ROW_32_639 VGND VPWR sky130_fd_sc_hd__tapvpwrvgnd_1
Xinput12 rs2[1] VGND VGND VPWR VPWR input12/X sky130_fd_sc_hd__clkbuf_2
XTAP_TAPCELL_ROW_12_396 VGND VPWR sky130_fd_sc_hd__tapvpwrvgnd_1
Xinput23 wd[15] VGND VGND VPWR VPWR input23/X sky130_fd_sc_hd__clkdlybuf4s25_1
Xinput34 wd[25] VGND VGND VPWR VPWR input34/X sky130_fd_sc_hd__clkdlybuf4s25_1
Xinput45 wd[6] VGND VGND VPWR VPWR input45/X sky130_fd_sc_hd__clkdlybuf4s25_1
Xwire760 wire760/A VGND VGND VPWR VPWR wire760/X sky130_fd_sc_hd__clkbuf_4
X_3530_ _5509_/Q _5477_/Q _3575_/S VGND VGND VPWR VPWR _3530_/X sky130_fd_sc_hd__mux2_1
XFILLER_6_350 VGND VGND VPWR VPWR sky130_fd_sc_hd__decap_3
X_3461_ _3806_/A _3461_/B VGND VGND VPWR VPWR _3461_/X sky130_fd_sc_hd__or2_2
X_5200_ _6032_/CLK _5200_/D VGND VGND VPWR VPWR _5200_/Q sky130_fd_sc_hd__dfxtp_2
X_3392_ _3708_/A1 _3389_/X _3391_/X _3881_/B2 VGND VGND VPWR VPWR _3392_/X sky130_fd_sc_hd__a22o_2
XFILLER_111_410 VGND VGND VPWR VPWR sky130_fd_sc_hd__decap_3
XFILLER_69_313 VGND VGND VPWR VPWR sky130_fd_sc_hd__fill_1
Xload_slew710 _3597_/S VGND VGND VPWR VPWR _3470_/S sky130_fd_sc_hd__buf_4
X_5131_ _5547_/CLK _5131_/D VGND VGND VPWR VPWR _5131_/Q sky130_fd_sc_hd__dfxtp_2
XFILLER_97_655 VGND VGND VPWR VPWR sky130_fd_sc_hd__fill_1
Xhold1507 _5158_/Q VGND VGND VPWR VPWR _4074_/B2 sky130_fd_sc_hd__dlygate4sd3_1
Xload_slew743 _2690_/A VGND VGND VPWR VPWR _2611_/A sky130_fd_sc_hd__clkbuf_4
X_5062_ _6066_/CLK _5062_/D VGND VGND VPWR VPWR _5062_/Q sky130_fd_sc_hd__dfxtp_2
XFILLER_111_465 VGND VGND VPWR VPWR sky130_fd_sc_hd__decap_3
XFILLER_96_176 VGND VGND VPWR VPWR sky130_fd_sc_hd__decap_3
Xhold1518 _5339_/Q VGND VGND VPWR VPWR _4269_/B2 sky130_fd_sc_hd__dlygate4sd3_1
Xhold1529 _5783_/Q VGND VGND VPWR VPWR _4743_/B2 sky130_fd_sc_hd__dlygate4sd3_1
Xload_slew787 _3170_/S VGND VGND VPWR VPWR _2897_/S sky130_fd_sc_hd__buf_4
Xload_slew776 _2979_/S1 VGND VGND VPWR VPWR _2503_/B sky130_fd_sc_hd__buf_6
X_4013_ _4530_/A1 _3988_/B _4017_/B1 _4013_/B2 VGND VGND VPWR VPWR _5104_/D sky130_fd_sc_hd__a22o_2
XFILLER_37_243 VGND VGND VPWR VPWR sky130_fd_sc_hd__fill_1
XFILLER_37_276 VGND VGND VPWR VPWR sky130_fd_sc_hd__decap_3
XFILLER_16_18 VGND VGND VPWR VPWR sky130_fd_sc_hd__decap_3
XFILLER_16_29 VGND VGND VPWR VPWR sky130_fd_sc_hd__fill_2
XFILLER_25_427 VGND VGND VPWR VPWR sky130_fd_sc_hd__decap_3
XFILLER_65_585 VGND VGND VPWR VPWR sky130_fd_sc_hd__decap_3
XFILLER_80_533 VGND VGND VPWR VPWR sky130_fd_sc_hd__decap_3
XFILLER_40_408 VGND VGND VPWR VPWR sky130_fd_sc_hd__decap_3
Xclkbuf_leaf_17_clk clkbuf_4_8_0_clk/X VGND VGND VPWR VPWR _6059_/CLK sky130_fd_sc_hd__clkbuf_8
X_5964_ _6060_/CLK _5964_/D VGND VGND VPWR VPWR _5964_/Q sky130_fd_sc_hd__dfxtp_2
XFILLER_33_482 VGND VGND VPWR VPWR sky130_fd_sc_hd__decap_3
X_5895_ _5943_/CLK _5895_/D VGND VGND VPWR VPWR _5895_/Q sky130_fd_sc_hd__dfxtp_2
X_4915_ _5017_/A1 _4941_/A2 wire133/X _4915_/B2 VGND VGND VPWR VPWR _5945_/D sky130_fd_sc_hd__a22o_2
XFILLER_21_633 VGND VGND VPWR VPWR sky130_fd_sc_hd__decap_3
X_4846_ _4880_/A1 _4876_/A2 _4874_/B1 _4846_/B2 VGND VGND VPWR VPWR _5880_/D sky130_fd_sc_hd__a22o_2
X_4777_ _4777_/A1 _4777_/A2 _4777_/B1 _4777_/B2 VGND VGND VPWR VPWR _5815_/D sky130_fd_sc_hd__a22o_2
XFILLER_106_215 VGND VGND VPWR VPWR sky130_fd_sc_hd__fill_1
X_3728_ _5518_/Q _5486_/Q _3743_/S VGND VGND VPWR VPWR _3728_/X sky130_fd_sc_hd__mux2_1
X_3659_ _5259_/Q _5227_/Q _3665_/S VGND VGND VPWR VPWR _3659_/X sky130_fd_sc_hd__mux2_1
X_5329_ _5713_/CLK _5329_/D VGND VGND VPWR VPWR _5329_/Q sky130_fd_sc_hd__dfxtp_2
XFILLER_87_165 VGND VGND VPWR VPWR sky130_fd_sc_hd__decap_3
XFILLER_113_31 VGND VGND VPWR VPWR sky130_fd_sc_hd__decap_3
XFILLER_56_530 VGND VGND VPWR VPWR sky130_fd_sc_hd__fill_2
XFILLER_75_349 VGND VGND VPWR VPWR sky130_fd_sc_hd__decap_3
XFILLER_56_574 VGND VGND VPWR VPWR sky130_fd_sc_hd__decap_3
XFILLER_71_500 VGND VGND VPWR VPWR sky130_fd_sc_hd__decap_3
XFILLER_113_75 VGND VGND VPWR VPWR sky130_fd_sc_hd__decap_3
XFILLER_16_416 VGND VGND VPWR VPWR sky130_fd_sc_hd__decap_3
XFILLER_16_427 VGND VGND VPWR VPWR sky130_fd_sc_hd__fill_2
XFILLER_43_257 VGND VGND VPWR VPWR sky130_fd_sc_hd__decap_3
XFILLER_73_57 VGND VGND VPWR VPWR sky130_fd_sc_hd__decap_3
XFILLER_71_599 VGND VGND VPWR VPWR sky130_fd_sc_hd__fill_1
XFILLER_12_633 VGND VGND VPWR VPWR sky130_fd_sc_hd__fill_2
XFILLER_11_198 VGND VGND VPWR VPWR sky130_fd_sc_hd__fill_1
XFILLER_22_94 VGND VGND VPWR VPWR sky130_fd_sc_hd__decap_3
XFILLER_7_169 VGND VGND VPWR VPWR sky130_fd_sc_hd__decap_3
XFILLER_98_21 VGND VGND VPWR VPWR sky130_fd_sc_hd__decap_3
XFILLER_98_408 VGND VGND VPWR VPWR sky130_fd_sc_hd__decap_3
XFILLER_98_419 VGND VGND VPWR VPWR sky130_fd_sc_hd__fill_1
XFILLER_78_110 VGND VGND VPWR VPWR sky130_fd_sc_hd__decap_3
XFILLER_105_292 VGND VGND VPWR VPWR sky130_fd_sc_hd__decap_3
XFILLER_39_508 VGND VGND VPWR VPWR sky130_fd_sc_hd__decap_3
XTAP_TAPCELL_ROW_111_1579 VGND VPWR sky130_fd_sc_hd__tapvpwrvgnd_1
Xfanout1121 _3943_/S VGND VGND VPWR VPWR _3580_/S sky130_fd_sc_hd__clkbuf_2
Xfanout1110 _3915_/S VGND VGND VPWR VPWR _3762_/S sky130_fd_sc_hd__dlymetal6s4s_1
XFILLER_78_165 VGND VGND VPWR VPWR sky130_fd_sc_hd__decap_3
XFILLER_93_113 VGND VGND VPWR VPWR sky130_fd_sc_hd__decap_3
XFILLER_19_265 VGND VGND VPWR VPWR sky130_fd_sc_hd__decap_3
XFILLER_62_533 VGND VGND VPWR VPWR sky130_fd_sc_hd__decap_3
XTAP_TAPCELL_ROW_17_455 VGND VPWR sky130_fd_sc_hd__tapvpwrvgnd_1
XTAP_TAPCELL_ROW_66_1036 VGND VPWR sky130_fd_sc_hd__tapvpwrvgnd_1
XTAP_TAPCELL_ROW_66_1047 VGND VPWR sky130_fd_sc_hd__tapvpwrvgnd_1
XTAP_TAPCELL_ROW_45_786 VGND VPWR sky130_fd_sc_hd__tapvpwrvgnd_1
X_2961_ _3073_/A1 _2944_/X _2960_/X _3185_/A1 VGND VGND VPWR VPWR _2961_/X sky130_fd_sc_hd__a22o_2
XFILLER_30_430 VGND VGND VPWR VPWR sky130_fd_sc_hd__decap_3
X_5680_ _5867_/CLK _5680_/D VGND VGND VPWR VPWR _5680_/Q sky130_fd_sc_hd__dfxtp_2
X_4700_ _4903_/A1 _4707_/A2 _4707_/B1 _4700_/B2 VGND VGND VPWR VPWR _5743_/D sky130_fd_sc_hd__a22o_2
XFILLER_8_41 VGND VGND VPWR VPWR sky130_fd_sc_hd__decap_3
X_4631_ _5038_/A1 wire407/X wire186/X _4631_/B2 VGND VGND VPWR VPWR _5678_/D sky130_fd_sc_hd__a22o_2
X_2892_ _3028_/A1 _2889_/X _2891_/X VGND VGND VPWR VPWR _2892_/X sky130_fd_sc_hd__a21o_2
XFILLER_7_670 VGND VGND VPWR VPWR sky130_fd_sc_hd__fill_2
XFILLER_8_96 VGND VGND VPWR VPWR sky130_fd_sc_hd__decap_3
X_4562_ _4767_/A1 _4572_/A2 _4572_/B1 _4562_/B2 VGND VGND VPWR VPWR _5613_/D sky130_fd_sc_hd__a22o_2
X_4493_ _4527_/A1 _4498_/A2 _4498_/B1 _4493_/B2 VGND VGND VPWR VPWR _5549_/D sky130_fd_sc_hd__a22o_2
X_3513_ _5796_/Q _5732_/Q _3858_/S VGND VGND VPWR VPWR _3513_/X sky130_fd_sc_hd__mux2_1
XTAP_TAPCELL_ROW_77_1176 VGND VPWR sky130_fd_sc_hd__tapvpwrvgnd_1
Xclkbuf_leaf_6_clk clkbuf_4_2_0_clk/X VGND VGND VPWR VPWR _6062_/CLK sky130_fd_sc_hd__clkbuf_8
X_3444_ _5249_/Q _5217_/Q _3700_/S VGND VGND VPWR VPWR _3444_/X sky130_fd_sc_hd__mux2_1
XTAP_TAPCELL_ROW_90_1332 VGND VPWR sky130_fd_sc_hd__tapvpwrvgnd_1
XFILLER_97_441 VGND VGND VPWR VPWR sky130_fd_sc_hd__decap_3
Xhold2005 _5457_/Q VGND VGND VPWR VPWR _4394_/B2 sky130_fd_sc_hd__dlygate4sd3_1
Xhold2016 _5739_/Q VGND VGND VPWR VPWR _4696_/B2 sky130_fd_sc_hd__dlygate4sd3_1
Xhold2027 _5740_/Q VGND VGND VPWR VPWR _4697_/B2 sky130_fd_sc_hd__dlygate4sd3_1
X_3375_ _5182_/Q _5150_/Q _3375_/S VGND VGND VPWR VPWR _3375_/X sky130_fd_sc_hd__mux2_1
XFILLER_84_102 VGND VGND VPWR VPWR sky130_fd_sc_hd__decap_3
XFILLER_85_625 VGND VGND VPWR VPWR sky130_fd_sc_hd__decap_3
Xhold1304 _5405_/Q VGND VGND VPWR VPWR _4339_/B2 sky130_fd_sc_hd__dlygate4sd3_1
Xhold1315 _5501_/Q VGND VGND VPWR VPWR _4443_/B2 sky130_fd_sc_hd__dlygate4sd3_1
Xhold2038 _5136_/Q VGND VGND VPWR VPWR _4048_/B2 sky130_fd_sc_hd__dlygate4sd3_1
Xhold2049 _5137_/Q VGND VGND VPWR VPWR _4049_/B2 sky130_fd_sc_hd__dlygate4sd3_1
X_5114_ _5914_/CLK _5114_/D VGND VGND VPWR VPWR _5114_/Q sky130_fd_sc_hd__dfxtp_2
XFILLER_85_647 VGND VGND VPWR VPWR sky130_fd_sc_hd__decap_3
Xhold1326 _5193_/Q VGND VGND VPWR VPWR _4112_/B2 sky130_fd_sc_hd__dlygate4sd3_1
Xhold1337 _5564_/Q VGND VGND VPWR VPWR _4510_/B2 sky130_fd_sc_hd__dlygate4sd3_1
Xhold1348 _5313_/Q VGND VGND VPWR VPWR _4241_/B2 sky130_fd_sc_hd__dlygate4sd3_1
Xhold1359 _5977_/Q VGND VGND VPWR VPWR _4949_/B2 sky130_fd_sc_hd__dlygate4sd3_1
X_5045_ _5045_/A1 _5045_/A2 _5045_/B1 _5045_/B2 VGND VGND VPWR VPWR _6069_/D sky130_fd_sc_hd__a22o_2
XFILLER_38_585 VGND VGND VPWR VPWR sky130_fd_sc_hd__decap_3
XFILLER_13_419 VGND VGND VPWR VPWR sky130_fd_sc_hd__fill_2
X_5947_ _6043_/CLK _5947_/D VGND VGND VPWR VPWR _5947_/Q sky130_fd_sc_hd__dfxtp_2
XFILLER_43_49 VGND VGND VPWR VPWR sky130_fd_sc_hd__decap_3
X_5878_ _6063_/CLK _5878_/D VGND VGND VPWR VPWR _5878_/Q sky130_fd_sc_hd__dfxtp_2
X_4829_ _4999_/A1 wire371/X wire153/X _4829_/B2 VGND VGND VPWR VPWR _5865_/D sky130_fd_sc_hd__a22o_2
XFILLER_4_106 VGND VGND VPWR VPWR sky130_fd_sc_hd__decap_3
XFILLER_5_607 VGND VGND VPWR VPWR sky130_fd_sc_hd__decap_3
XFILLER_5_629 VGND VGND VPWR VPWR sky130_fd_sc_hd__decap_3
XFILLER_111_6 VGND VGND VPWR VPWR sky130_fd_sc_hd__decap_3
XFILLER_108_53 VGND VGND VPWR VPWR sky130_fd_sc_hd__decap_3
XFILLER_108_97 VGND VGND VPWR VPWR sky130_fd_sc_hd__fill_1
XFILLER_102_240 VGND VGND VPWR VPWR sky130_fd_sc_hd__decap_3
XFILLER_29_530 VGND VGND VPWR VPWR sky130_fd_sc_hd__decap_3
XFILLER_63_308 VGND VGND VPWR VPWR sky130_fd_sc_hd__fill_2
XFILLER_84_45 VGND VGND VPWR VPWR sky130_fd_sc_hd__fill_1
XFILLER_91_617 VGND VGND VPWR VPWR sky130_fd_sc_hd__fill_2
Xhold1860 _5486_/Q VGND VGND VPWR VPWR _4426_/B2 sky130_fd_sc_hd__dlygate4sd3_1
Xhold1871 _5475_/Q VGND VGND VPWR VPWR _4415_/B2 sky130_fd_sc_hd__dlygate4sd3_1
XFILLER_17_50 VGND VGND VPWR VPWR sky130_fd_sc_hd__decap_3
XFILLER_29_596 VGND VGND VPWR VPWR sky130_fd_sc_hd__decap_3
XFILLER_84_78 VGND VGND VPWR VPWR sky130_fd_sc_hd__decap_3
Xhold1882 _5962_/Q VGND VGND VPWR VPWR _4932_/B2 sky130_fd_sc_hd__dlygate4sd3_1
Xhold1893 _5897_/Q VGND VGND VPWR VPWR _4863_/B2 sky130_fd_sc_hd__dlygate4sd3_1
XFILLER_16_235 VGND VGND VPWR VPWR sky130_fd_sc_hd__fill_1
XFILLER_44_544 VGND VGND VPWR VPWR sky130_fd_sc_hd__decap_3
XFILLER_44_566 VGND VGND VPWR VPWR sky130_fd_sc_hd__fill_2
XTAP_TAPCELL_ROW_14_414 VGND VPWR sky130_fd_sc_hd__tapvpwrvgnd_1
XTAP_TAPCELL_ROW_42_756 VGND VPWR sky130_fd_sc_hd__tapvpwrvgnd_1
XFILLER_8_401 VGND VGND VPWR VPWR sky130_fd_sc_hd__decap_3
XFILLER_8_445 VGND VGND VPWR VPWR sky130_fd_sc_hd__decap_3
XFILLER_4_651 VGND VGND VPWR VPWR sky130_fd_sc_hd__decap_3
XTAP_TAPCELL_ROW_113_1608 VGND VPWR sky130_fd_sc_hd__tapvpwrvgnd_1
X_3160_ wire651/X _3158_/X _3159_/X wire685/X VGND VGND VPWR VPWR _3160_/X sky130_fd_sc_hd__o22a_2
XFILLER_66_113 VGND VGND VPWR VPWR sky130_fd_sc_hd__fill_1
X_3091_ _5393_/Q _5361_/Q _5329_/Q _5297_/Q _3083_/S _3091_/S1 VGND VGND VPWR VPWR
+ _3091_/X sky130_fd_sc_hd__mux4_2
XFILLER_81_116 VGND VGND VPWR VPWR sky130_fd_sc_hd__decap_3
XFILLER_35_555 VGND VGND VPWR VPWR sky130_fd_sc_hd__decap_3
XPHY_EDGE_ROW_8_Right_8 VGND VGND VPWR VPWR sky130_fd_sc_hd__decap_3
X_5801_ _6041_/CLK _5801_/D VGND VGND VPWR VPWR _5801_/Q sky130_fd_sc_hd__dfxtp_2
X_5732_ _5956_/CLK _5732_/D VGND VGND VPWR VPWR _5732_/Q sky130_fd_sc_hd__dfxtp_2
X_3993_ _5020_/A1 _4018_/A2 _4018_/B1 _3993_/B2 VGND VGND VPWR VPWR _5084_/D sky130_fd_sc_hd__a22o_2
X_2944_ wire693/A _2941_/X _2943_/X VGND VGND VPWR VPWR _2944_/X sky130_fd_sc_hd__a21o_2
X_5663_ _5825_/CLK _5663_/D VGND VGND VPWR VPWR _5663_/Q sky130_fd_sc_hd__dfxtp_2
X_2875_ _3027_/A1 _2872_/X _2874_/X _3028_/A1 VGND VGND VPWR VPWR _2875_/X sky130_fd_sc_hd__a22o_2
X_5594_ _5691_/CLK _5594_/D VGND VGND VPWR VPWR _5594_/Q sky130_fd_sc_hd__dfxtp_2
X_4614_ _4987_/A1 _4640_/A2 _4640_/B1 _4614_/B2 VGND VGND VPWR VPWR _5661_/D sky130_fd_sc_hd__a22o_2
X_4545_ _4750_/A1 wire421/X _4570_/B1 _4545_/B2 VGND VGND VPWR VPWR _5596_/D sky130_fd_sc_hd__a22o_2
X_4476_ _4510_/A1 _4501_/A2 _4501_/B1 _4476_/B2 VGND VGND VPWR VPWR _5532_/D sky130_fd_sc_hd__a22o_2
XPHY_EDGE_ROW_39_Right_39 VGND VGND VPWR VPWR sky130_fd_sc_hd__decap_3
Xfanout925 input34/X VGND VGND VPWR VPWR _5041_/A1 sky130_fd_sc_hd__clkdlybuf4s25_1
Xfanout914 _4533_/A1 VGND VGND VPWR VPWR _5009_/A1 sky130_fd_sc_hd__clkdlybuf4s25_1
Xfanout903 _4508_/A1 VGND VGND VPWR VPWR _4645_/A1 sky130_fd_sc_hd__clkdlybuf4s25_1
X_3427_ _5184_/Q _5152_/Q _3427_/S VGND VGND VPWR VPWR _3427_/X sky130_fd_sc_hd__mux2_1
XFILLER_38_27 VGND VGND VPWR VPWR sky130_fd_sc_hd__fill_1
Xfanout958 input25/X VGND VGND VPWR VPWR _4999_/A1 sky130_fd_sc_hd__clkdlybuf4s25_1
Xfanout947 _4983_/A1 VGND VGND VPWR VPWR _4507_/A1 sky130_fd_sc_hd__clkdlybuf4s25_1
Xfanout936 input31/X VGND VGND VPWR VPWR _5004_/A1 sky130_fd_sc_hd__clkdlybuf4s25_1
X_3358_ _5821_/Q _5437_/Q _6045_/Q _5949_/Q _3821_/S _3828_/S1 VGND VGND VPWR VPWR
+ _3358_/X sky130_fd_sc_hd__mux4_2
XFILLER_97_271 VGND VGND VPWR VPWR sky130_fd_sc_hd__fill_1
Xfanout969 input22/X VGND VGND VPWR VPWR _5030_/A1 sky130_fd_sc_hd__clkdlybuf4s25_1
XFILLER_57_157 VGND VGND VPWR VPWR sky130_fd_sc_hd__decap_3
XFILLER_73_617 VGND VGND VPWR VPWR sky130_fd_sc_hd__decap_3
Xhold1145 _5497_/Q VGND VGND VPWR VPWR _4439_/B2 sky130_fd_sc_hd__dlygate4sd3_1
Xhold1156 _6064_/Q VGND VGND VPWR VPWR _5040_/B2 sky130_fd_sc_hd__dlygate4sd3_1
Xhold1167 _5571_/Q VGND VGND VPWR VPWR _4517_/B2 sky130_fd_sc_hd__dlygate4sd3_1
X_3289_ _5562_/Q _5530_/Q _3822_/S VGND VGND VPWR VPWR _3289_/X sky130_fd_sc_hd__mux2_1
XFILLER_85_488 VGND VGND VPWR VPWR sky130_fd_sc_hd__decap_3
Xhold1178 _5583_/Q VGND VGND VPWR VPWR _4529_/B2 sky130_fd_sc_hd__dlygate4sd3_1
Xhold1189 _5853_/Q VGND VGND VPWR VPWR _4817_/B2 sky130_fd_sc_hd__dlygate4sd3_1
X_5028_ _5028_/A1 wire332/X wire118/X _5028_/B2 VGND VGND VPWR VPWR _6052_/D sky130_fd_sc_hd__a22o_2
XFILLER_26_544 VGND VGND VPWR VPWR sky130_fd_sc_hd__decap_3
XFILLER_54_37 VGND VGND VPWR VPWR sky130_fd_sc_hd__fill_2
XFILLER_72_138 VGND VGND VPWR VPWR sky130_fd_sc_hd__fill_2
XFILLER_13_205 VGND VGND VPWR VPWR sky130_fd_sc_hd__fill_2
XFILLER_41_503 VGND VGND VPWR VPWR sky130_fd_sc_hd__fill_1
XFILLER_110_21 VGND VGND VPWR VPWR sky130_fd_sc_hd__decap_3
XFILLER_110_32 VGND VGND VPWR VPWR sky130_fd_sc_hd__decap_3
XPHY_EDGE_ROW_48_Right_48 VGND VGND VPWR VPWR sky130_fd_sc_hd__decap_3
XFILLER_110_65 VGND VGND VPWR VPWR sky130_fd_sc_hd__decap_3
XFILLER_70_47 VGND VGND VPWR VPWR sky130_fd_sc_hd__decap_3
XFILLER_107_321 VGND VGND VPWR VPWR sky130_fd_sc_hd__decap_3
XFILLER_107_376 VGND VGND VPWR VPWR sky130_fd_sc_hd__fill_1
XPHY_EDGE_ROW_57_Right_57 VGND VGND VPWR VPWR sky130_fd_sc_hd__decap_3
XFILLER_1_632 VGND VGND VPWR VPWR sky130_fd_sc_hd__decap_3
XFILLER_1_665 VGND VGND VPWR VPWR sky130_fd_sc_hd__decap_3
XFILLER_1_676 VGND VGND VPWR VPWR sky130_fd_sc_hd__decap_3
XFILLER_49_625 VGND VGND VPWR VPWR sky130_fd_sc_hd__decap_3
XFILLER_76_400 VGND VGND VPWR VPWR sky130_fd_sc_hd__fill_2
XFILLER_103_593 VGND VGND VPWR VPWR sky130_fd_sc_hd__decap_3
XFILLER_48_102 VGND VGND VPWR VPWR sky130_fd_sc_hd__decap_3
XFILLER_48_113 VGND VGND VPWR VPWR sky130_fd_sc_hd__decap_3
XFILLER_95_88 VGND VGND VPWR VPWR sky130_fd_sc_hd__decap_3
XFILLER_28_60 VGND VGND VPWR VPWR sky130_fd_sc_hd__decap_3
XFILLER_29_360 VGND VGND VPWR VPWR sky130_fd_sc_hd__fill_2
XFILLER_63_127 VGND VGND VPWR VPWR sky130_fd_sc_hd__decap_3
XFILLER_64_639 VGND VGND VPWR VPWR sky130_fd_sc_hd__decap_3
XTAP_TAPCELL_ROW_47_815 VGND VPWR sky130_fd_sc_hd__tapvpwrvgnd_1
Xload_slew1120 _3475_/S VGND VGND VPWR VPWR _3936_/S sky130_fd_sc_hd__buf_2
XFILLER_17_555 VGND VGND VPWR VPWR sky130_fd_sc_hd__decap_3
XFILLER_91_447 VGND VGND VPWR VPWR sky130_fd_sc_hd__fill_1
XFILLER_91_469 VGND VGND VPWR VPWR sky130_fd_sc_hd__fill_1
Xhold1690 _5449_/Q VGND VGND VPWR VPWR _4386_/B2 sky130_fd_sc_hd__dlygate4sd3_1
XFILLER_44_363 VGND VGND VPWR VPWR sky130_fd_sc_hd__fill_1
XPHY_EDGE_ROW_66_Right_66 VGND VGND VPWR VPWR sky130_fd_sc_hd__decap_3
XTAP_TAPCELL_ROW_63_1006 VGND VPWR sky130_fd_sc_hd__tapvpwrvgnd_1
XFILLER_17_599 VGND VGND VPWR VPWR sky130_fd_sc_hd__fill_2
XTAP_TAPCELL_ROW_27_572 VGND VPWR sky130_fd_sc_hd__tapvpwrvgnd_1
XFILLER_44_92 VGND VGND VPWR VPWR sky130_fd_sc_hd__decap_3
XFILLER_8_231 VGND VGND VPWR VPWR sky130_fd_sc_hd__decap_3
XFILLER_8_253 VGND VGND VPWR VPWR sky130_fd_sc_hd__fill_1
X_2660_ _5566_/Q _5534_/Q _2660_/S VGND VGND VPWR VPWR _2660_/X sky130_fd_sc_hd__mux2_1
XFILLER_99_503 VGND VGND VPWR VPWR sky130_fd_sc_hd__fill_1
XPHY_EDGE_ROW_75_Right_75 VGND VGND VPWR VPWR sky130_fd_sc_hd__decap_3
X_2591_ _5115_/Q _5083_/Q _6011_/Q _5979_/Q _2564_/S wire760/X VGND VGND VPWR VPWR
+ _2591_/X sky130_fd_sc_hd__mux4_2
XFILLER_5_42 VGND VGND VPWR VPWR sky130_fd_sc_hd__decap_3
XTAP_TAPCELL_ROW_74_1135 VGND VPWR sky130_fd_sc_hd__tapvpwrvgnd_1
X_4330_ _4468_/A1 _4331_/A2 _4331_/B1 _4330_/B2 VGND VGND VPWR VPWR _5398_/D sky130_fd_sc_hd__a22o_2
X_4261_ _4775_/A1 _4261_/A2 _4261_/B1 _4261_/B2 VGND VGND VPWR VPWR _5333_/D sky130_fd_sc_hd__a22o_2
XFILLER_101_508 VGND VGND VPWR VPWR sky130_fd_sc_hd__fill_2
XFILLER_113_368 VGND VGND VPWR VPWR sky130_fd_sc_hd__decap_3
XFILLER_86_208 VGND VGND VPWR VPWR sky130_fd_sc_hd__decap_3
X_6000_ _6000_/CLK _6000_/D VGND VGND VPWR VPWR _6000_/Q sky130_fd_sc_hd__dfxtp_2
X_3212_ _2497_/B _3209_/X _3211_/X _3229_/A1 VGND VGND VPWR VPWR _3212_/X sky130_fd_sc_hd__a22o_2
XFILLER_39_113 VGND VGND VPWR VPWR sky130_fd_sc_hd__decap_3
X_4192_ _4943_/A1 _4192_/A2 _4192_/B1 _4192_/B2 VGND VGND VPWR VPWR _5269_/D sky130_fd_sc_hd__a22o_2
XFILLER_39_157 VGND VGND VPWR VPWR sky130_fd_sc_hd__decap_3
XFILLER_55_617 VGND VGND VPWR VPWR sky130_fd_sc_hd__decap_3
X_3143_ _5140_/Q _5108_/Q _6036_/Q _6004_/Q _2800_/S _3202_/S1 VGND VGND VPWR VPWR
+ _3143_/X sky130_fd_sc_hd__mux4_2
XPHY_EDGE_ROW_84_Right_84 VGND VGND VPWR VPWR sky130_fd_sc_hd__decap_3
X_3074_ _3067_/X _3073_/X wire570/X VGND VGND VPWR VPWR _3074_/X sky130_fd_sc_hd__o21a_2
XTAP_TAPCELL_ROW_85_1275 VGND VPWR sky130_fd_sc_hd__tapvpwrvgnd_1
XTAP_TAPCELL_ROW_85_1264 VGND VPWR sky130_fd_sc_hd__tapvpwrvgnd_1
XFILLER_23_536 VGND VGND VPWR VPWR sky130_fd_sc_hd__decap_3
XFILLER_24_18 VGND VGND VPWR VPWR sky130_fd_sc_hd__fill_2
XFILLER_23_558 VGND VGND VPWR VPWR sky130_fd_sc_hd__fill_2
XFILLER_23_569 VGND VGND VPWR VPWR sky130_fd_sc_hd__decap_3
X_3976_ _5040_/A1 _3982_/A2 _3982_/B1 _3976_/B2 VGND VGND VPWR VPWR _5072_/D sky130_fd_sc_hd__a22o_2
X_5715_ _5813_/CLK _5715_/D VGND VGND VPWR VPWR _5715_/Q sky130_fd_sc_hd__dfxtp_2
X_2927_ _2937_/A1 _2923_/X _2926_/X _3224_/A1 VGND VGND VPWR VPWR _2927_/X sky130_fd_sc_hd__o211a_2
X_5646_ _5934_/CLK _5646_/D VGND VGND VPWR VPWR _5646_/Q sky130_fd_sc_hd__dfxtp_2
XPHY_EDGE_ROW_93_Right_93 VGND VGND VPWR VPWR sky130_fd_sc_hd__decap_3
X_2858_ _3222_/A1 _2856_/X _2857_/X _3222_/B2 VGND VGND VPWR VPWR _2858_/X sky130_fd_sc_hd__o22a_2
X_5577_ clkload8/A _5577_/D VGND VGND VPWR VPWR _5577_/Q sky130_fd_sc_hd__dfxtp_2
X_2789_ _5252_/Q _5220_/Q _2789_/S VGND VGND VPWR VPWR _2789_/X sky130_fd_sc_hd__mux2_1
X_4528_ _4528_/A1 _4528_/A2 _4528_/B1 _4528_/B2 VGND VGND VPWR VPWR _5582_/D sky130_fd_sc_hd__a22o_2
XFILLER_6_9 VGND VGND VPWR VPWR sky130_fd_sc_hd__decap_3
Xfanout700 _2495_/Y VGND VGND VPWR VPWR _3781_/C1 sky130_fd_sc_hd__clkdlybuf4s25_1
X_4459_ _4527_/A1 _4459_/A2 _4459_/B1 _4459_/B2 VGND VGND VPWR VPWR _5517_/D sky130_fd_sc_hd__a22o_2
Xfanout722 _3108_/A VGND VGND VPWR VPWR _3175_/A sky130_fd_sc_hd__clkdlybuf4s25_1
Xfanout711 _3906_/A VGND VGND VPWR VPWR _3548_/A1 sky130_fd_sc_hd__clkdlybuf4s25_1
XFILLER_105_21 VGND VGND VPWR VPWR sky130_fd_sc_hd__decap_3
XFILLER_98_580 VGND VGND VPWR VPWR sky130_fd_sc_hd__decap_3
Xfanout766 wire772/A VGND VGND VPWR VPWR _3057_/S1 sky130_fd_sc_hd__clkdlybuf4s25_1
Xfanout755 fanout765/X VGND VGND VPWR VPWR _3013_/S1 sky130_fd_sc_hd__clkdlybuf4s25_1
Xfanout744 _3027_/A1 VGND VGND VPWR VPWR _2755_/A1 sky130_fd_sc_hd__clkdlybuf4s25_1
XFILLER_100_530 VGND VGND VPWR VPWR sky130_fd_sc_hd__fill_2
Xfanout788 _3182_/S VGND VGND VPWR VPWR _2534_/S sky130_fd_sc_hd__dlymetal6s4s_1
Xfanout777 _2979_/S1 VGND VGND VPWR VPWR _3091_/S1 sky130_fd_sc_hd__clkdlybuf4s25_1
XFILLER_100_574 VGND VGND VPWR VPWR sky130_fd_sc_hd__decap_3
XFILLER_105_87 VGND VGND VPWR VPWR sky130_fd_sc_hd__decap_3
XFILLER_60_108 VGND VGND VPWR VPWR sky130_fd_sc_hd__decap_3
XFILLER_14_536 VGND VGND VPWR VPWR sky130_fd_sc_hd__decap_3
XFILLER_26_385 VGND VGND VPWR VPWR sky130_fd_sc_hd__fill_1
XFILLER_81_57 VGND VGND VPWR VPWR sky130_fd_sc_hd__fill_2
XTAP_TAPCELL_ROW_24_542 VGND VPWR sky130_fd_sc_hd__tapvpwrvgnd_1
XFILLER_14_62 VGND VGND VPWR VPWR sky130_fd_sc_hd__fill_2
XFILLER_81_79 VGND VGND VPWR VPWR sky130_fd_sc_hd__decap_3
XTAP_TAPCELL_ROW_52_873 VGND VPWR sky130_fd_sc_hd__tapvpwrvgnd_1
XFILLER_108_663 VGND VGND VPWR VPWR sky130_fd_sc_hd__decap_3
XFILLER_107_162 VGND VGND VPWR VPWR sky130_fd_sc_hd__decap_3
XFILLER_64_447 VGND VGND VPWR VPWR sky130_fd_sc_hd__fill_2
XFILLER_91_299 VGND VGND VPWR VPWR sky130_fd_sc_hd__fill_2
XFILLER_32_344 VGND VGND VPWR VPWR sky130_fd_sc_hd__decap_3
X_3830_ _5810_/Q _5746_/Q _3830_/S VGND VGND VPWR VPWR _3830_/X sky130_fd_sc_hd__mux2_1
X_3761_ _5263_/Q _5231_/Q _3762_/S VGND VGND VPWR VPWR _3761_/X sky130_fd_sc_hd__mux2_1
XFILLER_9_551 VGND VGND VPWR VPWR sky130_fd_sc_hd__decap_3
X_5500_ _5500_/CLK _5500_/D VGND VGND VPWR VPWR _5500_/Q sky130_fd_sc_hd__dfxtp_2
X_2712_ _2711_/X _2712_/B _2712_/C _2712_/D VGND VGND VPWR VPWR _2712_/X sky130_fd_sc_hd__and4b_2
XFILLER_72_3 VGND VGND VPWR VPWR sky130_fd_sc_hd__decap_3
X_3692_ _5260_/Q _5228_/Q _3693_/S VGND VGND VPWR VPWR _3692_/X sky130_fd_sc_hd__mux2_1
X_5431_ _5799_/CLK _5431_/D VGND VGND VPWR VPWR _5431_/Q sky130_fd_sc_hd__dfxtp_2
X_2643_ _5918_/Q _5886_/Q _5854_/Q _5758_/Q _2889_/S _3113_/S1 VGND VGND VPWR VPWR
+ _2643_/X sky130_fd_sc_hd__mux4_2
XFILLER_114_622 VGND VGND VPWR VPWR sky130_fd_sc_hd__decap_3
X_5362_ _5502_/CLK _5362_/D VGND VGND VPWR VPWR _5362_/Q sky130_fd_sc_hd__dfxtp_2
X_2574_ _2573_/X _2574_/B _2574_/C _2619_/A VGND VGND VPWR VPWR _2574_/X sky130_fd_sc_hd__and4b_2
X_4313_ _4519_/A1 _4299_/B _4328_/B1 _4313_/B2 VGND VGND VPWR VPWR _5381_/D sky130_fd_sc_hd__a22o_2
XFILLER_114_666 VGND VGND VPWR VPWR sky130_fd_sc_hd__decap_3
XFILLER_87_517 VGND VGND VPWR VPWR sky130_fd_sc_hd__decap_3
XFILLER_87_528 VGND VGND VPWR VPWR sky130_fd_sc_hd__decap_3
XFILLER_99_377 VGND VGND VPWR VPWR sky130_fd_sc_hd__decap_3
X_5293_ _5885_/CLK _5293_/D VGND VGND VPWR VPWR _5293_/Q sky130_fd_sc_hd__dfxtp_2
XFILLER_113_176 VGND VGND VPWR VPWR sky130_fd_sc_hd__decap_3
XFILLER_99_399 VGND VGND VPWR VPWR sky130_fd_sc_hd__decap_3
X_4244_ _4312_/A1 _4260_/A2 _4260_/B1 _4244_/B2 VGND VGND VPWR VPWR _5316_/D sky130_fd_sc_hd__a22o_2
X_4175_ _4312_/A1 _4188_/A2 _4191_/B1 _4175_/B2 VGND VGND VPWR VPWR _5252_/D sky130_fd_sc_hd__a22o_2
XFILLER_27_116 VGND VGND VPWR VPWR sky130_fd_sc_hd__fill_1
XFILLER_28_639 VGND VGND VPWR VPWR sky130_fd_sc_hd__decap_3
X_3126_ _5267_/Q _5235_/Q _3170_/S VGND VGND VPWR VPWR _3126_/X sky130_fd_sc_hd__mux2_1
X_3057_ _5712_/Q _5680_/Q _5648_/Q _5616_/Q _2942_/S _3057_/S1 VGND VGND VPWR VPWR
+ _3058_/B sky130_fd_sc_hd__mux4_2
XFILLER_23_333 VGND VGND VPWR VPWR sky130_fd_sc_hd__decap_3
XFILLER_50_141 VGND VGND VPWR VPWR sky130_fd_sc_hd__fill_1
XFILLER_11_517 VGND VGND VPWR VPWR sky130_fd_sc_hd__fill_1
XFILLER_50_174 VGND VGND VPWR VPWR sky130_fd_sc_hd__decap_3
XFILLER_51_686 VGND VGND VPWR VPWR sky130_fd_sc_hd__fill_2
XTAP_TAPCELL_ROW_21_501 VGND VPWR sky130_fd_sc_hd__tapvpwrvgnd_1
X_3959_ _4989_/A1 wire546/A wire325/A _3959_/B2 VGND VGND VPWR VPWR _5055_/D sky130_fd_sc_hd__a22o_2
XTAP_TAPCELL_ROW_98_1422 VGND VPWR sky130_fd_sc_hd__tapvpwrvgnd_1
XFILLER_109_438 VGND VGND VPWR VPWR sky130_fd_sc_hd__fill_2
X_5629_ _5986_/CLK _5629_/D VGND VGND VPWR VPWR _5629_/Q sky130_fd_sc_hd__dfxtp_2
XFILLER_105_644 VGND VGND VPWR VPWR sky130_fd_sc_hd__decap_3
XFILLER_4_6 VGND VGND VPWR VPWR sky130_fd_sc_hd__decap_3
XFILLER_78_506 VGND VGND VPWR VPWR sky130_fd_sc_hd__decap_3
XFILLER_78_517 VGND VGND VPWR VPWR sky130_fd_sc_hd__fill_1
XFILLER_78_528 VGND VGND VPWR VPWR sky130_fd_sc_hd__decap_3
XFILLER_78_539 VGND VGND VPWR VPWR sky130_fd_sc_hd__fill_1
Xfanout541 wire548/A VGND VGND VPWR VPWR _3974_/A2 sky130_fd_sc_hd__clkdlybuf4s25_1
Xfanout530 wire533/A VGND VGND VPWR VPWR _4052_/A2 sky130_fd_sc_hd__clkdlybuf4s25_1
Xfanout563 _3207_/B2 VGND VGND VPWR VPWR _3118_/B2 sky130_fd_sc_hd__clkdlybuf4s25_1
Xfanout552 _3235_/X VGND VGND VPWR VPWR wire553/A sky130_fd_sc_hd__dlymetal6s2s_1
XTAP_TAPCELL_ROW_29_601 VGND VPWR sky130_fd_sc_hd__tapvpwrvgnd_1
XFILLER_18_149 VGND VGND VPWR VPWR sky130_fd_sc_hd__fill_1
XFILLER_73_222 VGND VGND VPWR VPWR sky130_fd_sc_hd__fill_2
XFILLER_92_12 VGND VGND VPWR VPWR sky130_fd_sc_hd__decap_3
XTAP_TAPCELL_ROW_57_932 VGND VPWR sky130_fd_sc_hd__tapvpwrvgnd_1
XFILLER_33_108 VGND VGND VPWR VPWR sky130_fd_sc_hd__decap_3
XFILLER_26_182 VGND VGND VPWR VPWR sky130_fd_sc_hd__decap_3
XFILLER_42_631 VGND VGND VPWR VPWR sky130_fd_sc_hd__decap_3
XFILLER_92_67 VGND VGND VPWR VPWR sky130_fd_sc_hd__decap_3
XFILLER_92_78 VGND VGND VPWR VPWR sky130_fd_sc_hd__decap_3
XPHY_EDGE_ROW_1_Left_117 VGND VGND VPWR VPWR sky130_fd_sc_hd__decap_3
XFILLER_14_344 VGND VGND VPWR VPWR sky130_fd_sc_hd__decap_3
XFILLER_10_583 VGND VGND VPWR VPWR sky130_fd_sc_hd__decap_3
XTAP_TAPCELL_ROW_71_1105 VGND VPWR sky130_fd_sc_hd__tapvpwrvgnd_1
XFILLER_111_614 VGND VGND VPWR VPWR sky130_fd_sc_hd__fill_2
XFILLER_111_647 VGND VGND VPWR VPWR sky130_fd_sc_hd__decap_3
XFILLER_1_281 VGND VGND VPWR VPWR sky130_fd_sc_hd__fill_1
XFILLER_2_21 VGND VGND VPWR VPWR sky130_fd_sc_hd__decap_3
XFILLER_2_32 VGND VGND VPWR VPWR sky130_fd_sc_hd__decap_3
XFILLER_2_65 VGND VGND VPWR VPWR sky130_fd_sc_hd__decap_3
XFILLER_37_425 VGND VGND VPWR VPWR sky130_fd_sc_hd__fill_1
XFILLER_92_531 VGND VGND VPWR VPWR sky130_fd_sc_hd__fill_1
XFILLER_24_108 VGND VGND VPWR VPWR sky130_fd_sc_hd__decap_3
XFILLER_64_266 VGND VGND VPWR VPWR sky130_fd_sc_hd__fill_1
XTAP_TAPCELL_ROW_69_1078 VGND VPWR sky130_fd_sc_hd__tapvpwrvgnd_1
X_5980_ _6012_/CLK _5980_/D VGND VGND VPWR VPWR _5980_/Q sky130_fd_sc_hd__dfxtp_2
XFILLER_18_683 VGND VGND VPWR VPWR sky130_fd_sc_hd__decap_3
X_4931_ _5033_/A1 _4941_/A2 wire133/X _4931_/B2 VGND VGND VPWR VPWR _5961_/D sky130_fd_sc_hd__a22o_2
XFILLER_32_141 VGND VGND VPWR VPWR sky130_fd_sc_hd__decap_3
X_4862_ _5032_/A1 _4845_/B wire151/A _4862_/B2 VGND VGND VPWR VPWR _5896_/D sky130_fd_sc_hd__a22o_2
XTAP_TAPCELL_ROW_82_1234 VGND VPWR sky130_fd_sc_hd__tapvpwrvgnd_1
X_3813_ _3253_/X _3800_/X _3803_/X _3812_/X VGND VGND VPWR VPWR _3813_/X sky130_fd_sc_hd__a31o_2
XANTENNA_15 fanout157/A VGND VGND VPWR VPWR sky130_fd_sc_hd__diode_2
XANTENNA_26 _3108_/A VGND VGND VPWR VPWR sky130_fd_sc_hd__diode_2
XANTENNA_37 _4878_/Y VGND VGND VPWR VPWR sky130_fd_sc_hd__diode_2
XFILLER_20_336 VGND VGND VPWR VPWR sky130_fd_sc_hd__decap_3
XFILLER_20_347 VGND VGND VPWR VPWR sky130_fd_sc_hd__decap_3
X_4793_ wire1003/X _4793_/B VGND VGND VPWR VPWR _5831_/D sky130_fd_sc_hd__and2b_2
XFILLER_20_358 VGND VGND VPWR VPWR sky130_fd_sc_hd__decap_3
X_3744_ _6062_/Q _5966_/Q _3744_/S VGND VGND VPWR VPWR _3744_/X sky130_fd_sc_hd__mux2_1
X_3675_ _5835_/Q _5451_/Q _3790_/S VGND VGND VPWR VPWR _3675_/X sky130_fd_sc_hd__mux2_1
XFILLER_106_419 VGND VGND VPWR VPWR sky130_fd_sc_hd__fill_1
Xoutput100 _3834_/X VGND VGND VPWR VPWR rd2[26] sky130_fd_sc_hd__dlymetal6s2s_1
X_5414_ _6034_/CLK _5414_/D VGND VGND VPWR VPWR _5414_/Q sky130_fd_sc_hd__dfxtp_2
X_2626_ _5245_/Q _5213_/Q _2627_/S VGND VGND VPWR VPWR _2626_/X sky130_fd_sc_hd__mux2_1
Xoutput111 _3419_/X VGND VGND VPWR VPWR rd2[7] sky130_fd_sc_hd__clkbuf_2
XTAP_TAPCELL_ROW_7_329 VGND VPWR sky130_fd_sc_hd__tapvpwrvgnd_1
X_5345_ _5578_/CLK _5345_/D VGND VGND VPWR VPWR _5345_/Q sky130_fd_sc_hd__dfxtp_2
X_2557_ _5786_/Q _5722_/Q _2582_/S VGND VGND VPWR VPWR _2558_/B sky130_fd_sc_hd__mux2_1
XTAP_TAPCELL_ROW_93_1363 VGND VPWR sky130_fd_sc_hd__tapvpwrvgnd_1
XFILLER_101_113 VGND VGND VPWR VPWR sky130_fd_sc_hd__decap_3
X_5276_ _5513_/CLK _5276_/D VGND VGND VPWR VPWR _5276_/Q sky130_fd_sc_hd__dfxtp_2
X_4227_ _4775_/A1 _4227_/A2 _4227_/B1 _4227_/B2 VGND VGND VPWR VPWR _5301_/D sky130_fd_sc_hd__a22o_2
XFILLER_46_27 VGND VGND VPWR VPWR sky130_fd_sc_hd__fill_1
X_4158_ _4943_/A1 _4158_/A2 _4158_/B1 _4158_/B2 VGND VGND VPWR VPWR _5237_/D sky130_fd_sc_hd__a22o_2
XTAP_TAPCELL_ROW_54_902 VGND VPWR sky130_fd_sc_hd__tapvpwrvgnd_1
X_4089_ _4943_/A1 _4089_/A2 _4089_/B1 _4089_/B2 VGND VGND VPWR VPWR _5173_/D sky130_fd_sc_hd__a22o_2
X_3109_ _5810_/Q _5746_/Q _3110_/S VGND VGND VPWR VPWR _3109_/X sky130_fd_sc_hd__mux2_1
XFILLER_102_22 VGND VGND VPWR VPWR sky130_fd_sc_hd__decap_3
XFILLER_83_597 VGND VGND VPWR VPWR sky130_fd_sc_hd__fill_1
XFILLER_23_141 VGND VGND VPWR VPWR sky130_fd_sc_hd__decap_3
XFILLER_51_483 VGND VGND VPWR VPWR sky130_fd_sc_hd__decap_3
XTAP_TAPCELL_ROW_102_1470 VGND VPWR sky130_fd_sc_hd__tapvpwrvgnd_1
XTAP_TAPCELL_ROW_62_990 VGND VPWR sky130_fd_sc_hd__tapvpwrvgnd_1
XFILLER_7_318 VGND VGND VPWR VPWR sky130_fd_sc_hd__decap_3
Xwire238 wire238/A VGND VGND VPWR VPWR wire238/X sky130_fd_sc_hd__clkbuf_4
XFILLER_109_257 VGND VGND VPWR VPWR sky130_fd_sc_hd__decap_3
XPHY_EDGE_ROW_83_Left_199 VGND VGND VPWR VPWR sky130_fd_sc_hd__decap_3
XFILLER_11_52 VGND VGND VPWR VPWR sky130_fd_sc_hd__decap_3
XFILLER_2_3 VGND VGND VPWR VPWR sky130_fd_sc_hd__decap_3
XFILLER_3_557 VGND VGND VPWR VPWR sky130_fd_sc_hd__decap_3
XFILLER_78_358 VGND VGND VPWR VPWR sky130_fd_sc_hd__decap_3
XFILLER_46_200 VGND VGND VPWR VPWR sky130_fd_sc_hd__fill_1
XFILLER_59_561 VGND VGND VPWR VPWR sky130_fd_sc_hd__decap_3
XFILLER_19_436 VGND VGND VPWR VPWR sky130_fd_sc_hd__decap_3
XFILLER_74_597 VGND VGND VPWR VPWR sky130_fd_sc_hd__decap_3
XFILLER_14_130 VGND VGND VPWR VPWR sky130_fd_sc_hd__decap_3
XFILLER_14_141 VGND VGND VPWR VPWR sky130_fd_sc_hd__decap_3
XTAP_TAPCELL_ROW_32_629 VGND VPWR sky130_fd_sc_hd__tapvpwrvgnd_1
XFILLER_30_645 VGND VGND VPWR VPWR sky130_fd_sc_hd__decap_3
XFILLER_42_483 VGND VGND VPWR VPWR sky130_fd_sc_hd__fill_1
XFILLER_52_81 VGND VGND VPWR VPWR sky130_fd_sc_hd__decap_3
Xinput13 rs2[2] VGND VGND VPWR VPWR input13/X sky130_fd_sc_hd__clkbuf_2
Xinput24 wd[16] VGND VGND VPWR VPWR input24/X sky130_fd_sc_hd__clkdlybuf4s25_1
Xinput35 wd[26] VGND VGND VPWR VPWR input35/X sky130_fd_sc_hd__clkdlybuf4s25_1
Xinput46 wd[7] VGND VGND VPWR VPWR input46/X sky130_fd_sc_hd__clkdlybuf4s25_1
XFILLER_6_362 VGND VGND VPWR VPWR sky130_fd_sc_hd__fill_2
XTAP_TAPCELL_ROW_12_397 VGND VPWR sky130_fd_sc_hd__tapvpwrvgnd_1
Xwire772 wire772/A VGND VGND VPWR VPWR wire772/X sky130_fd_sc_hd__clkbuf_4
X_3460_ _5825_/Q _5441_/Q _6049_/Q _5953_/Q _3683_/S _3698_/S1 VGND VGND VPWR VPWR
+ _3461_/B sky130_fd_sc_hd__mux4_2
X_3391_ _5790_/Q _5726_/Q _3821_/S VGND VGND VPWR VPWR _3391_/X sky130_fd_sc_hd__mux2_1
XFILLER_35_3 VGND VGND VPWR VPWR sky130_fd_sc_hd__decap_3
XFILLER_97_612 VGND VGND VPWR VPWR sky130_fd_sc_hd__decap_3
XFILLER_97_623 VGND VGND VPWR VPWR sky130_fd_sc_hd__decap_3
X_5130_ _6023_/CLK _5130_/D VGND VGND VPWR VPWR _5130_/Q sky130_fd_sc_hd__dfxtp_2
XFILLER_111_433 VGND VGND VPWR VPWR sky130_fd_sc_hd__decap_3
XFILLER_111_444 VGND VGND VPWR VPWR sky130_fd_sc_hd__decap_3
XFILLER_96_122 VGND VGND VPWR VPWR sky130_fd_sc_hd__fill_1
Xhold1508 _5274_/Q VGND VGND VPWR VPWR _4200_/B2 sky130_fd_sc_hd__dlygate4sd3_1
Xload_slew733 _2816_/A VGND VGND VPWR VPWR _3058_/A sky130_fd_sc_hd__buf_4
X_5061_ _5713_/CLK _5061_/D VGND VGND VPWR VPWR _5061_/Q sky130_fd_sc_hd__dfxtp_2
Xhold1519 _5769_/Q VGND VGND VPWR VPWR _4729_/B2 sky130_fd_sc_hd__dlygate4sd3_1
Xload_slew799 _2878_/S VGND VGND VPWR VPWR _3021_/S sky130_fd_sc_hd__clkbuf_4
X_4012_ _5005_/A1 _4017_/A2 _4019_/B1 _4012_/B2 VGND VGND VPWR VPWR _5103_/D sky130_fd_sc_hd__a22o_2
XFILLER_37_222 VGND VGND VPWR VPWR sky130_fd_sc_hd__fill_2
XFILLER_65_542 VGND VGND VPWR VPWR sky130_fd_sc_hd__fill_1
XFILLER_77_391 VGND VGND VPWR VPWR sky130_fd_sc_hd__fill_1
XFILLER_37_255 VGND VGND VPWR VPWR sky130_fd_sc_hd__decap_3
XFILLER_65_564 VGND VGND VPWR VPWR sky130_fd_sc_hd__decap_3
X_5963_ _5963_/CLK _5963_/D VGND VGND VPWR VPWR _5963_/Q sky130_fd_sc_hd__dfxtp_2
XFILLER_80_556 VGND VGND VPWR VPWR sky130_fd_sc_hd__decap_3
X_4914_ _5016_/A1 _4913_/B wire136/X _4914_/B2 VGND VGND VPWR VPWR _5944_/D sky130_fd_sc_hd__a22o_2
XFILLER_80_589 VGND VGND VPWR VPWR sky130_fd_sc_hd__fill_2
X_5894_ _6043_/CLK _5894_/D VGND VGND VPWR VPWR _5894_/Q sky130_fd_sc_hd__dfxtp_2
XFILLER_21_645 VGND VGND VPWR VPWR sky130_fd_sc_hd__decap_3
XFILLER_32_29 VGND VGND VPWR VPWR sky130_fd_sc_hd__fill_2
XFILLER_33_494 VGND VGND VPWR VPWR sky130_fd_sc_hd__fill_2
XFILLER_60_280 VGND VGND VPWR VPWR sky130_fd_sc_hd__decap_3
X_4845_ _4913_/A _4845_/B VGND VGND VPWR VPWR _4845_/Y sky130_fd_sc_hd__nor2_2
XFILLER_21_667 VGND VGND VPWR VPWR sky130_fd_sc_hd__decap_3
X_4776_ _4776_/A1 _4776_/A2 _4776_/B1 _4776_/B2 VGND VGND VPWR VPWR _5814_/D sky130_fd_sc_hd__a22o_2
XFILLER_20_177 VGND VGND VPWR VPWR sky130_fd_sc_hd__decap_3
X_3727_ _5582_/Q _5550_/Q _3727_/S VGND VGND VPWR VPWR _3727_/X sky130_fd_sc_hd__mux2_1
XFILLER_106_227 VGND VGND VPWR VPWR sky130_fd_sc_hd__fill_2
XFILLER_106_238 VGND VGND VPWR VPWR sky130_fd_sc_hd__decap_3
XFILLER_106_9 VGND VGND VPWR VPWR sky130_fd_sc_hd__decap_3
X_3658_ _5131_/Q _5099_/Q _6027_/Q _5995_/Q _3665_/S _3905_/S1 VGND VGND VPWR VPWR
+ _3658_/X sky130_fd_sc_hd__mux4_2
X_3589_ _5415_/Q _5063_/Q _3943_/S VGND VGND VPWR VPWR _3589_/X sky130_fd_sc_hd__mux2_1
X_2609_ _5116_/Q _5084_/Q _6012_/Q _5980_/Q _2897_/S _2610_/S1 VGND VGND VPWR VPWR
+ _2609_/X sky130_fd_sc_hd__mux4_2
XFILLER_0_516 VGND VGND VPWR VPWR sky130_fd_sc_hd__decap_3
XFILLER_87_111 VGND VGND VPWR VPWR sky130_fd_sc_hd__fill_1
X_5328_ _5963_/CLK _5328_/D VGND VGND VPWR VPWR _5328_/Q sky130_fd_sc_hd__dfxtp_2
XFILLER_102_477 VGND VGND VPWR VPWR sky130_fd_sc_hd__decap_3
Xclkbuf_4_5_0_clk clkbuf_0_clk/X VGND VGND VPWR VPWR clkload2/A sky130_fd_sc_hd__clkbuf_8
X_5259_ _5547_/CLK _5259_/D VGND VGND VPWR VPWR _5259_/Q sky130_fd_sc_hd__dfxtp_2
XFILLER_113_10 VGND VGND VPWR VPWR sky130_fd_sc_hd__decap_3
XFILLER_28_200 VGND VGND VPWR VPWR sky130_fd_sc_hd__fill_1
XFILLER_113_43 VGND VGND VPWR VPWR sky130_fd_sc_hd__decap_3
XFILLER_16_406 VGND VGND VPWR VPWR sky130_fd_sc_hd__fill_2
XFILLER_83_350 VGND VGND VPWR VPWR sky130_fd_sc_hd__decap_3
XFILLER_90_309 VGND VGND VPWR VPWR sky130_fd_sc_hd__decap_3
XFILLER_113_87 VGND VGND VPWR VPWR sky130_fd_sc_hd__decap_3
XFILLER_43_225 VGND VGND VPWR VPWR sky130_fd_sc_hd__decap_3
XFILLER_56_586 VGND VGND VPWR VPWR sky130_fd_sc_hd__fill_2
XFILLER_73_69 VGND VGND VPWR VPWR sky130_fd_sc_hd__fill_1
XFILLER_12_645 VGND VGND VPWR VPWR sky130_fd_sc_hd__fill_1
XFILLER_11_155 VGND VGND VPWR VPWR sky130_fd_sc_hd__fill_2
XFILLER_12_678 VGND VGND VPWR VPWR sky130_fd_sc_hd__decap_3
XPHY_EDGE_ROW_91_Left_207 VGND VGND VPWR VPWR sky130_fd_sc_hd__decap_3
XFILLER_98_55 VGND VGND VPWR VPWR sky130_fd_sc_hd__decap_3
XFILLER_79_634 VGND VGND VPWR VPWR sky130_fd_sc_hd__decap_3
XFILLER_98_88 VGND VGND VPWR VPWR sky130_fd_sc_hd__decap_3
XFILLER_78_144 VGND VGND VPWR VPWR sky130_fd_sc_hd__decap_3
Xfanout1100 _3908_/S VGND VGND VPWR VPWR _3907_/S sky130_fd_sc_hd__clkdlybuf4s25_1
XFILLER_66_317 VGND VGND VPWR VPWR sky130_fd_sc_hd__decap_3
XFILLER_78_177 VGND VGND VPWR VPWR sky130_fd_sc_hd__decap_3
Xfanout1133 _3689_/S VGND VGND VPWR VPWR wire1134/A sky130_fd_sc_hd__clkdlybuf4s25_1
Xfanout190 fanout190/A VGND VGND VPWR VPWR _4634_/B1 sky130_fd_sc_hd__clkdlybuf4s25_1
XFILLER_93_169 VGND VGND VPWR VPWR sky130_fd_sc_hd__decap_3
XFILLER_62_512 VGND VGND VPWR VPWR sky130_fd_sc_hd__decap_3
XFILLER_62_567 VGND VGND VPWR VPWR sky130_fd_sc_hd__fill_1
XTAP_TAPCELL_ROW_66_1037 VGND VPWR sky130_fd_sc_hd__tapvpwrvgnd_1
XFILLER_62_589 VGND VGND VPWR VPWR sky130_fd_sc_hd__fill_2
XTAP_TAPCELL_ROW_17_456 VGND VPWR sky130_fd_sc_hd__tapvpwrvgnd_1
XTAP_TAPCELL_ROW_45_787 VGND VPWR sky130_fd_sc_hd__tapvpwrvgnd_1
X_2960_ _3027_/B2 _2957_/X _2959_/X VGND VGND VPWR VPWR _2960_/X sky130_fd_sc_hd__a21o_2
XFILLER_42_291 VGND VGND VPWR VPWR sky130_fd_sc_hd__decap_3
X_2891_ _3027_/A1 _2888_/X _2890_/X _3027_/B2 VGND VGND VPWR VPWR _2891_/X sky130_fd_sc_hd__a22o_2
X_4630_ _4767_/A1 _4640_/A2 _4640_/B1 _4630_/B2 VGND VGND VPWR VPWR _5677_/D sky130_fd_sc_hd__a22o_2
XFILLER_30_475 VGND VGND VPWR VPWR sky130_fd_sc_hd__fill_1
XFILLER_30_497 VGND VGND VPWR VPWR sky130_fd_sc_hd__fill_1
XFILLER_8_53 VGND VGND VPWR VPWR sky130_fd_sc_hd__decap_3
X_4561_ _5036_/A1 _4566_/A2 _4566_/B1 _4561_/B2 VGND VGND VPWR VPWR _5612_/D sky130_fd_sc_hd__a22o_2
XFILLER_7_682 VGND VGND VPWR VPWR sky130_fd_sc_hd__decap_3
Xwire591 wire591/A VGND VGND VPWR VPWR _3763_/A sky130_fd_sc_hd__clkbuf_4
X_4492_ _4526_/A1 _4503_/A2 _4503_/B1 _4492_/B2 VGND VGND VPWR VPWR _5548_/D sky130_fd_sc_hd__a22o_2
X_3512_ _3867_/A _3512_/B VGND VGND VPWR VPWR _3512_/X sky130_fd_sc_hd__or2_2
XTAP_TAPCELL_ROW_77_1177 VGND VPWR sky130_fd_sc_hd__tapvpwrvgnd_1
X_3443_ _5185_/Q _5153_/Q _3700_/S VGND VGND VPWR VPWR _3443_/X sky130_fd_sc_hd__mux2_1
XFILLER_103_208 VGND VGND VPWR VPWR sky130_fd_sc_hd__fill_1
XTAP_TAPCELL_ROW_90_1333 VGND VPWR sky130_fd_sc_hd__tapvpwrvgnd_1
XFILLER_69_122 VGND VGND VPWR VPWR sky130_fd_sc_hd__decap_3
Xhold2006 _5092_/Q VGND VGND VPWR VPWR _4001_/B2 sky130_fd_sc_hd__dlygate4sd3_1
Xhold2017 _5726_/Q VGND VGND VPWR VPWR _4683_/B2 sky130_fd_sc_hd__dlygate4sd3_1
X_5113_ _5683_/CLK _5113_/D VGND VGND VPWR VPWR _5113_/Q sky130_fd_sc_hd__dfxtp_2
X_3374_ _5246_/Q _5214_/Q _3375_/S VGND VGND VPWR VPWR _3374_/X sky130_fd_sc_hd__mux2_1
XFILLER_85_615 VGND VGND VPWR VPWR sky130_fd_sc_hd__fill_1
Xhold1305 _5989_/Q VGND VGND VPWR VPWR _4961_/B2 sky130_fd_sc_hd__dlygate4sd3_1
Xhold1316 _5415_/Q VGND VGND VPWR VPWR _4349_/B2 sky130_fd_sc_hd__dlygate4sd3_1
Xhold2028 _5756_/Q VGND VGND VPWR VPWR _4716_/B2 sky130_fd_sc_hd__dlygate4sd3_1
Xhold2039 _5951_/Q VGND VGND VPWR VPWR _4921_/B2 sky130_fd_sc_hd__dlygate4sd3_1
XFILLER_27_18 VGND VGND VPWR VPWR sky130_fd_sc_hd__decap_3
XFILLER_38_531 VGND VGND VPWR VPWR sky130_fd_sc_hd__fill_1
XFILLER_97_497 VGND VGND VPWR VPWR sky130_fd_sc_hd__decap_3
Xhold1327 _5242_/Q VGND VGND VPWR VPWR _4165_/B2 sky130_fd_sc_hd__dlygate4sd3_1
Xhold1338 _5803_/Q VGND VGND VPWR VPWR _4765_/B2 sky130_fd_sc_hd__dlygate4sd3_1
Xhold1349 _5757_/Q VGND VGND VPWR VPWR _4717_/B2 sky130_fd_sc_hd__dlygate4sd3_1
Xload_slew596 _3944_/B2 VGND VGND VPWR VPWR _3404_/A sky130_fd_sc_hd__buf_4
Xload_slew585 _3896_/A1 VGND VGND VPWR VPWR _3611_/B2 sky130_fd_sc_hd__buf_4
X_5044_ _5044_/A1 wire332/X wire118/X _5044_/B2 VGND VGND VPWR VPWR _6068_/D sky130_fd_sc_hd__a22o_2
XFILLER_72_309 VGND VGND VPWR VPWR sky130_fd_sc_hd__fill_1
XFILLER_93_681 VGND VGND VPWR VPWR sky130_fd_sc_hd__decap_3
XFILLER_25_225 VGND VGND VPWR VPWR sky130_fd_sc_hd__fill_1
XFILLER_53_556 VGND VGND VPWR VPWR sky130_fd_sc_hd__decap_3
XFILLER_80_353 VGND VGND VPWR VPWR sky130_fd_sc_hd__decap_3
X_5946_ _6042_/CLK _5946_/D VGND VGND VPWR VPWR _5946_/Q sky130_fd_sc_hd__dfxtp_2
X_5877_ _6069_/CLK _5877_/D VGND VGND VPWR VPWR _5877_/Q sky130_fd_sc_hd__dfxtp_2
X_4828_ _5032_/A1 wire376/A _4843_/B1 _4828_/B2 VGND VGND VPWR VPWR _5864_/D sky130_fd_sc_hd__a22o_2
X_4759_ _5029_/A1 _4776_/A2 _4776_/B1 _4759_/B2 VGND VGND VPWR VPWR _5797_/D sky130_fd_sc_hd__a22o_2
XFILLER_107_514 VGND VGND VPWR VPWR sky130_fd_sc_hd__decap_3
XFILLER_104_6 VGND VGND VPWR VPWR sky130_fd_sc_hd__decap_3
XFILLER_108_21 VGND VGND VPWR VPWR sky130_fd_sc_hd__decap_3
XFILLER_108_32 VGND VGND VPWR VPWR sky130_fd_sc_hd__decap_3
XFILLER_108_65 VGND VGND VPWR VPWR sky130_fd_sc_hd__decap_3
XFILLER_68_47 VGND VGND VPWR VPWR sky130_fd_sc_hd__decap_3
XFILLER_76_648 VGND VGND VPWR VPWR sky130_fd_sc_hd__fill_2
XFILLER_29_542 VGND VGND VPWR VPWR sky130_fd_sc_hd__decap_3
XFILLER_29_564 VGND VGND VPWR VPWR sky130_fd_sc_hd__fill_1
XFILLER_75_169 VGND VGND VPWR VPWR sky130_fd_sc_hd__decap_3
Xhold1850 _5062_/Q VGND VGND VPWR VPWR _3966_/B2 sky130_fd_sc_hd__dlygate4sd3_1
Xhold1861 _6067_/Q VGND VGND VPWR VPWR _5043_/B2 sky130_fd_sc_hd__dlygate4sd3_1
Xhold1872 _5933_/Q VGND VGND VPWR VPWR _4901_/B2 sky130_fd_sc_hd__dlygate4sd3_1
XFILLER_16_214 VGND VGND VPWR VPWR sky130_fd_sc_hd__decap_3
Xhold1883 _5547_/Q VGND VGND VPWR VPWR _4491_/B2 sky130_fd_sc_hd__dlygate4sd3_1
Xhold1894 _5393_/Q VGND VGND VPWR VPWR _4325_/B2 sky130_fd_sc_hd__dlygate4sd3_1
XFILLER_90_139 VGND VGND VPWR VPWR sky130_fd_sc_hd__fill_1
XFILLER_44_589 VGND VGND VPWR VPWR sky130_fd_sc_hd__decap_3
XTAP_TAPCELL_ROW_14_415 VGND VPWR sky130_fd_sc_hd__tapvpwrvgnd_1
XFILLER_12_464 VGND VGND VPWR VPWR sky130_fd_sc_hd__decap_3
XFILLER_8_413 VGND VGND VPWR VPWR sky130_fd_sc_hd__decap_3
XTAP_TAPCELL_ROW_42_757 VGND VPWR sky130_fd_sc_hd__tapvpwrvgnd_1
XFILLER_8_424 VGND VGND VPWR VPWR sky130_fd_sc_hd__fill_2
XFILLER_8_468 VGND VGND VPWR VPWR sky130_fd_sc_hd__decap_3
XFILLER_4_641 VGND VGND VPWR VPWR sky130_fd_sc_hd__decap_3
XTAP_TAPCELL_ROW_113_1609 VGND VPWR sky130_fd_sc_hd__tapvpwrvgnd_1
XFILLER_4_663 VGND VGND VPWR VPWR sky130_fd_sc_hd__decap_3
XFILLER_98_206 VGND VGND VPWR VPWR sky130_fd_sc_hd__fill_1
XFILLER_66_103 VGND VGND VPWR VPWR sky130_fd_sc_hd__fill_2
XFILLER_67_637 VGND VGND VPWR VPWR sky130_fd_sc_hd__decap_3
X_3090_ _3081_/A _3086_/X _3089_/X _3230_/A1 VGND VGND VPWR VPWR _3090_/X sky130_fd_sc_hd__o211a_2
XFILLER_54_309 VGND VGND VPWR VPWR sky130_fd_sc_hd__fill_2
XFILLER_75_670 VGND VGND VPWR VPWR sky130_fd_sc_hd__fill_2
XFILLER_75_681 VGND VGND VPWR VPWR sky130_fd_sc_hd__decap_3
XFILLER_81_106 VGND VGND VPWR VPWR sky130_fd_sc_hd__decap_3
XFILLER_35_589 VGND VGND VPWR VPWR sky130_fd_sc_hd__decap_3
X_5800_ _5800_/CLK _5800_/D VGND VGND VPWR VPWR _5800_/Q sky130_fd_sc_hd__dfxtp_2
X_3992_ _5019_/A1 _4018_/A2 _4018_/B1 _3992_/B2 VGND VGND VPWR VPWR _5083_/D sky130_fd_sc_hd__a22o_2
XFILLER_50_548 VGND VGND VPWR VPWR sky130_fd_sc_hd__decap_3
X_5731_ _6051_/CLK _5731_/D VGND VGND VPWR VPWR _5731_/Q sky130_fd_sc_hd__dfxtp_2
X_2943_ _3055_/A1 _2940_/X _2942_/X wire659/A VGND VGND VPWR VPWR _2943_/X sky130_fd_sc_hd__a22o_2
X_5662_ _5790_/CLK _5662_/D VGND VGND VPWR VPWR _5662_/Q sky130_fd_sc_hd__dfxtp_2
X_2874_ _5416_/Q _5064_/Q _2889_/S VGND VGND VPWR VPWR _2874_/X sky130_fd_sc_hd__mux2_1
X_5593_ _5785_/CLK _5593_/D VGND VGND VPWR VPWR _5593_/Q sky130_fd_sc_hd__dfxtp_2
X_4613_ _4750_/A1 wire407/X wire186/A _4613_/B2 VGND VGND VPWR VPWR _5660_/D sky130_fd_sc_hd__a22o_2
X_4544_ _4749_/A1 _4557_/A2 _4557_/B1 _4544_/B2 VGND VGND VPWR VPWR _5595_/D sky130_fd_sc_hd__a22o_2
XFILLER_104_517 VGND VGND VPWR VPWR sky130_fd_sc_hd__decap_3
XFILLER_89_228 VGND VGND VPWR VPWR sky130_fd_sc_hd__decap_3
X_4475_ _4509_/A1 _4498_/A2 _4498_/B1 _4475_/B2 VGND VGND VPWR VPWR _5531_/D sky130_fd_sc_hd__a22o_2
Xmax_cap198 _4574_/Y VGND VGND VPWR VPWR fanout197/A sky130_fd_sc_hd__clkbuf_2
Xfanout915 _4533_/A1 VGND VGND VPWR VPWR _4773_/A1 sky130_fd_sc_hd__clkdlybuf4s25_1
Xfanout904 input39/X VGND VGND VPWR VPWR _4508_/A1 sky130_fd_sc_hd__clkdlybuf4s25_1
X_3426_ _5248_/Q _5216_/Q _3427_/S VGND VGND VPWR VPWR _3426_/X sky130_fd_sc_hd__mux2_1
XFILLER_85_401 VGND VGND VPWR VPWR sky130_fd_sc_hd__fill_2
Xfanout948 input28/X VGND VGND VPWR VPWR _4983_/A1 sky130_fd_sc_hd__clkdlybuf4s25_1
Xfanout937 input30/X VGND VGND VPWR VPWR _5037_/A1 sky130_fd_sc_hd__clkdlybuf4s25_1
Xfanout926 _5040_/A1 VGND VGND VPWR VPWR _4904_/A1 sky130_fd_sc_hd__clkdlybuf4s25_1
X_3357_ _5917_/Q _5885_/Q _5853_/Q _5757_/Q _3707_/S _3705_/S1 VGND VGND VPWR VPWR
+ _3357_/X sky130_fd_sc_hd__mux4_2
XFILLER_58_626 VGND VGND VPWR VPWR sky130_fd_sc_hd__decap_3
XFILLER_85_434 VGND VGND VPWR VPWR sky130_fd_sc_hd__decap_3
Xload_slew382 _4762_/A2 VGND VGND VPWR VPWR _4772_/A2 sky130_fd_sc_hd__clkbuf_4
Xfanout959 input25/X VGND VGND VPWR VPWR _4660_/A1 sky130_fd_sc_hd__clkdlybuf4s25_1
XFILLER_57_136 VGND VGND VPWR VPWR sky130_fd_sc_hd__decap_3
XFILLER_73_607 VGND VGND VPWR VPWR sky130_fd_sc_hd__fill_1
Xhold1146 _5505_/Q VGND VGND VPWR VPWR _4447_/B2 sky130_fd_sc_hd__dlygate4sd3_1
Xhold1157 _6034_/Q VGND VGND VPWR VPWR _5008_/B2 sky130_fd_sc_hd__dlygate4sd3_1
Xload_slew393 _4676_/B VGND VGND VPWR VPWR _4706_/A2 sky130_fd_sc_hd__clkbuf_4
X_5027_ _5027_/A1 _5038_/A2 wire115/X _5027_/B2 VGND VGND VPWR VPWR _6051_/D sky130_fd_sc_hd__a22o_2
X_3288_ _5370_/Q _5338_/Q _5306_/Q _5274_/Q _3822_/S _3820_/S1 VGND VGND VPWR VPWR
+ _3288_/X sky130_fd_sc_hd__mux4_2
XFILLER_66_681 VGND VGND VPWR VPWR sky130_fd_sc_hd__decap_3
XFILLER_73_629 VGND VGND VPWR VPWR sky130_fd_sc_hd__fill_1
Xhold1168 _5792_/Q VGND VGND VPWR VPWR _4754_/B2 sky130_fd_sc_hd__dlygate4sd3_1
Xhold1179 _6019_/Q VGND VGND VPWR VPWR _4993_/B2 sky130_fd_sc_hd__dlygate4sd3_1
XFILLER_38_394 VGND VGND VPWR VPWR sky130_fd_sc_hd__decap_3
XFILLER_26_589 VGND VGND VPWR VPWR sky130_fd_sc_hd__decap_3
XFILLER_81_673 VGND VGND VPWR VPWR sky130_fd_sc_hd__decap_3
XFILLER_110_44 VGND VGND VPWR VPWR sky130_fd_sc_hd__decap_3
XFILLER_110_77 VGND VGND VPWR VPWR sky130_fd_sc_hd__decap_3
XFILLER_41_559 VGND VGND VPWR VPWR sky130_fd_sc_hd__fill_1
X_5929_ _6044_/CLK _5929_/D VGND VGND VPWR VPWR _5929_/Q sky130_fd_sc_hd__dfxtp_2
XFILLER_110_88 VGND VGND VPWR VPWR sky130_fd_sc_hd__decap_3
XFILLER_21_250 VGND VGND VPWR VPWR sky130_fd_sc_hd__decap_3
XFILLER_21_294 VGND VGND VPWR VPWR sky130_fd_sc_hd__decap_3
XFILLER_5_427 VGND VGND VPWR VPWR sky130_fd_sc_hd__decap_3
XFILLER_107_388 VGND VGND VPWR VPWR sky130_fd_sc_hd__decap_3
XFILLER_1_611 VGND VGND VPWR VPWR sky130_fd_sc_hd__decap_3
XFILLER_79_57 VGND VGND VPWR VPWR sky130_fd_sc_hd__decap_3
XFILLER_1_644 VGND VGND VPWR VPWR sky130_fd_sc_hd__decap_3
XFILLER_49_615 VGND VGND VPWR VPWR sky130_fd_sc_hd__fill_1
XFILLER_95_209 VGND VGND VPWR VPWR sky130_fd_sc_hd__decap_3
XFILLER_49_637 VGND VGND VPWR VPWR sky130_fd_sc_hd__decap_3
XFILLER_17_501 VGND VGND VPWR VPWR sky130_fd_sc_hd__decap_3
XTAP_TAPCELL_ROW_47_816 VGND VPWR sky130_fd_sc_hd__tapvpwrvgnd_1
Xhold1680 _5988_/Q VGND VGND VPWR VPWR _4960_/B2 sky130_fd_sc_hd__dlygate4sd3_1
Xload_slew1132 _3645_/S VGND VGND VPWR VPWR _3644_/S sky130_fd_sc_hd__buf_2
Xhold1691 _5912_/Q VGND VGND VPWR VPWR _4880_/B2 sky130_fd_sc_hd__dlygate4sd3_1
XFILLER_32_515 VGND VGND VPWR VPWR sky130_fd_sc_hd__decap_3
XFILLER_72_651 VGND VGND VPWR VPWR sky130_fd_sc_hd__fill_1
XFILLER_72_662 VGND VGND VPWR VPWR sky130_fd_sc_hd__decap_3
XTAP_TAPCELL_ROW_63_1007 VGND VPWR sky130_fd_sc_hd__tapvpwrvgnd_1
XFILLER_44_60 VGND VGND VPWR VPWR sky130_fd_sc_hd__decap_3
XFILLER_71_161 VGND VGND VPWR VPWR sky130_fd_sc_hd__fill_1
XTAP_TAPCELL_ROW_27_573 VGND VPWR sky130_fd_sc_hd__tapvpwrvgnd_1
XFILLER_8_243 VGND VGND VPWR VPWR sky130_fd_sc_hd__fill_1
XFILLER_67_6 VGND VGND VPWR VPWR sky130_fd_sc_hd__fill_1
XFILLER_5_21 VGND VGND VPWR VPWR sky130_fd_sc_hd__decap_3
X_2590_ wire643/X _2588_/X _2589_/X _3004_/B2 VGND VGND VPWR VPWR _2590_/X sky130_fd_sc_hd__o22a_2
XFILLER_5_54 VGND VGND VPWR VPWR sky130_fd_sc_hd__fill_2
XTAP_TAPCELL_ROW_74_1136 VGND VPWR sky130_fd_sc_hd__tapvpwrvgnd_1
XFILLER_99_548 VGND VGND VPWR VPWR sky130_fd_sc_hd__decap_3
X_4260_ _4534_/A1 _4260_/A2 _4260_/B1 _4260_/B2 VGND VGND VPWR VPWR _5332_/D sky130_fd_sc_hd__a22o_2
X_4191_ _5010_/A1 wire500/A _4191_/B1 _4191_/B2 VGND VGND VPWR VPWR _5268_/D sky130_fd_sc_hd__a22o_2
X_3211_ _6071_/Q _5975_/Q _3227_/S VGND VGND VPWR VPWR _3211_/X sky130_fd_sc_hd__mux2_1
X_3142_ _3135_/X _3141_/X _2619_/A VGND VGND VPWR VPWR _3142_/X sky130_fd_sc_hd__o21a_2
XFILLER_39_136 VGND VGND VPWR VPWR sky130_fd_sc_hd__decap_3
XFILLER_94_253 VGND VGND VPWR VPWR sky130_fd_sc_hd__decap_3
XFILLER_54_106 VGND VGND VPWR VPWR sky130_fd_sc_hd__fill_2
XFILLER_55_629 VGND VGND VPWR VPWR sky130_fd_sc_hd__fill_1
X_3073_ _3073_/A1 _3056_/X _3072_/X _3196_/C1 VGND VGND VPWR VPWR _3073_/X sky130_fd_sc_hd__a22o_2
XTAP_TAPCELL_ROW_85_1265 VGND VPWR sky130_fd_sc_hd__tapvpwrvgnd_1
XFILLER_62_183 VGND VGND VPWR VPWR sky130_fd_sc_hd__fill_1
X_3975_ _4529_/A1 _3982_/A2 _3982_/B1 _3975_/B2 VGND VGND VPWR VPWR _5071_/D sky130_fd_sc_hd__a22o_2
XFILLER_10_209 VGND VGND VPWR VPWR sky130_fd_sc_hd__decap_3
X_5714_ _6013_/CLK _5714_/D VGND VGND VPWR VPWR _5714_/Q sky130_fd_sc_hd__dfxtp_2
X_2926_ _2936_/A1 _2924_/X _2925_/X _3222_/B2 VGND VGND VPWR VPWR _2926_/X sky130_fd_sc_hd__o22a_2
X_5645_ _6034_/CLK _5645_/D VGND VGND VPWR VPWR _5645_/Q sky130_fd_sc_hd__dfxtp_2
X_2857_ _5575_/Q _5543_/Q _2919_/S VGND VGND VPWR VPWR _2857_/X sky130_fd_sc_hd__mux2_1
X_5576_ _6024_/CLK _5576_/D VGND VGND VPWR VPWR _5576_/Q sky130_fd_sc_hd__dfxtp_2
X_2788_ _5188_/Q _5156_/Q _2789_/S VGND VGND VPWR VPWR _2788_/X sky130_fd_sc_hd__mux2_1
X_4527_ _4527_/A1 _4532_/A2 _4532_/B1 _4527_/B2 VGND VGND VPWR VPWR _5581_/D sky130_fd_sc_hd__a22o_2
XFILLER_49_16 VGND VGND VPWR VPWR sky130_fd_sc_hd__decap_3
X_4458_ _4526_/A1 _4469_/A2 _4469_/B1 _4458_/B2 VGND VGND VPWR VPWR _5516_/D sky130_fd_sc_hd__a22o_2
XFILLER_49_49 VGND VGND VPWR VPWR sky130_fd_sc_hd__decap_3
Xfanout701 _3496_/A VGND VGND VPWR VPWR _3335_/A1 sky130_fd_sc_hd__clkdlybuf4s25_1
X_3409_ _5823_/Q _5439_/Q _6047_/Q _5951_/Q _3397_/S _3799_/S1 VGND VGND VPWR VPWR
+ _3410_/B sky130_fd_sc_hd__mux4_2
XFILLER_98_592 VGND VGND VPWR VPWR sky130_fd_sc_hd__decap_3
Xfanout734 _3206_/A1 VGND VGND VPWR VPWR _3042_/A sky130_fd_sc_hd__clkdlybuf4s25_1
X_4389_ _5036_/A1 wire459/X _4400_/B1 _4389_/B2 VGND VGND VPWR VPWR _5452_/D sky130_fd_sc_hd__a22o_2
XFILLER_100_542 VGND VGND VPWR VPWR sky130_fd_sc_hd__fill_2
XFILLER_105_55 VGND VGND VPWR VPWR sky130_fd_sc_hd__fill_1
XFILLER_105_66 VGND VGND VPWR VPWR sky130_fd_sc_hd__decap_3
XFILLER_100_586 VGND VGND VPWR VPWR sky130_fd_sc_hd__fill_2
XFILLER_18_309 VGND VGND VPWR VPWR sky130_fd_sc_hd__decap_3
XFILLER_65_48 VGND VGND VPWR VPWR sky130_fd_sc_hd__decap_3
X_6059_ _6059_/CLK _6059_/D VGND VGND VPWR VPWR _6059_/Q sky130_fd_sc_hd__dfxtp_2
XFILLER_54_640 VGND VGND VPWR VPWR sky130_fd_sc_hd__decap_3
XFILLER_53_172 VGND VGND VPWR VPWR sky130_fd_sc_hd__fill_2
XFILLER_54_684 VGND VGND VPWR VPWR sky130_fd_sc_hd__decap_3
XFILLER_81_481 VGND VGND VPWR VPWR sky130_fd_sc_hd__decap_3
XTAP_TAPCELL_ROW_24_532 VGND VPWR sky130_fd_sc_hd__tapvpwrvgnd_1
XTAP_TAPCELL_ROW_24_543 VGND VPWR sky130_fd_sc_hd__tapvpwrvgnd_1
XFILLER_22_570 VGND VGND VPWR VPWR sky130_fd_sc_hd__decap_3
XFILLER_41_389 VGND VGND VPWR VPWR sky130_fd_sc_hd__decap_3
XTAP_TAPCELL_ROW_52_874 VGND VPWR sky130_fd_sc_hd__tapvpwrvgnd_1
XFILLER_14_85 VGND VGND VPWR VPWR sky130_fd_sc_hd__decap_3
XFILLER_107_141 VGND VGND VPWR VPWR sky130_fd_sc_hd__decap_3
XFILLER_108_675 VGND VGND VPWR VPWR sky130_fd_sc_hd__decap_3
XFILLER_1_452 VGND VGND VPWR VPWR sky130_fd_sc_hd__fill_2
XFILLER_39_60 VGND VGND VPWR VPWR sky130_fd_sc_hd__fill_2
XFILLER_49_401 VGND VGND VPWR VPWR sky130_fd_sc_hd__decap_3
XFILLER_39_93 VGND VGND VPWR VPWR sky130_fd_sc_hd__fill_1
XFILLER_76_253 VGND VGND VPWR VPWR sky130_fd_sc_hd__decap_3
XFILLER_76_264 VGND VGND VPWR VPWR sky130_fd_sc_hd__fill_2
XFILLER_29_180 VGND VGND VPWR VPWR sky130_fd_sc_hd__decap_3
XFILLER_60_643 VGND VGND VPWR VPWR sky130_fd_sc_hd__fill_1
XFILLER_32_378 VGND VGND VPWR VPWR sky130_fd_sc_hd__fill_1
X_3760_ _3918_/A _3760_/B VGND VGND VPWR VPWR _3760_/X sky130_fd_sc_hd__or2_2
XFILLER_13_592 VGND VGND VPWR VPWR sky130_fd_sc_hd__fill_2
XFILLER_71_80 VGND VGND VPWR VPWR sky130_fd_sc_hd__decap_3
XFILLER_71_91 VGND VGND VPWR VPWR sky130_fd_sc_hd__decap_3
X_2711_ _3185_/A1 _2705_/Y _2710_/Y _3017_/C1 VGND VGND VPWR VPWR _2711_/X sky130_fd_sc_hd__a22o_2
X_5430_ _5925_/CLK _5430_/D VGND VGND VPWR VPWR _5430_/Q sky130_fd_sc_hd__dfxtp_2
X_3691_ _5132_/Q _5100_/Q _6028_/Q _5996_/Q _3693_/S _3929_/S1 VGND VGND VPWR VPWR
+ _3691_/X sky130_fd_sc_hd__mux4_2
XFILLER_65_3 VGND VGND VPWR VPWR sky130_fd_sc_hd__decap_3
X_2642_ _2640_/X _2641_/X _3119_/B1 VGND VGND VPWR VPWR _2642_/X sky130_fd_sc_hd__o21a_2
XFILLER_114_601 VGND VGND VPWR VPWR sky130_fd_sc_hd__decap_3
X_5361_ _5713_/CLK _5361_/D VGND VGND VPWR VPWR _5361_/Q sky130_fd_sc_hd__dfxtp_2
X_2573_ _3118_/B2 _2555_/Y _2566_/Y _3106_/C1 VGND VGND VPWR VPWR _2573_/X sky130_fd_sc_hd__a22o_2
XFILLER_114_634 VGND VGND VPWR VPWR sky130_fd_sc_hd__decap_3
XFILLER_114_645 VGND VGND VPWR VPWR sky130_fd_sc_hd__decap_3
X_5292_ _5514_/CLK _5292_/D VGND VGND VPWR VPWR _5292_/Q sky130_fd_sc_hd__dfxtp_2
X_4312_ _4312_/A1 _4328_/A2 _4328_/B1 _4312_/B2 VGND VGND VPWR VPWR _5380_/D sky130_fd_sc_hd__a22o_2
XFILLER_114_678 VGND VGND VPWR VPWR sky130_fd_sc_hd__decap_3
X_4243_ _4517_/A1 wire482/X wire262/X _4243_/B2 VGND VGND VPWR VPWR _5315_/D sky130_fd_sc_hd__a22o_2
XFILLER_101_317 VGND VGND VPWR VPWR sky130_fd_sc_hd__decap_3
XFILLER_113_166 VGND VGND VPWR VPWR sky130_fd_sc_hd__fill_2
XFILLER_99_389 VGND VGND VPWR VPWR sky130_fd_sc_hd__decap_3
X_4174_ _4993_/A1 _4179_/A2 _4180_/B1 _4174_/B2 VGND VGND VPWR VPWR _5251_/D sky130_fd_sc_hd__a22o_2
X_3125_ _5139_/Q _5107_/Q _6035_/Q _6003_/Q _2534_/S _3180_/S1 VGND VGND VPWR VPWR
+ _3125_/X sky130_fd_sc_hd__mux4_2
XFILLER_82_223 VGND VGND VPWR VPWR sky130_fd_sc_hd__fill_1
X_3056_ _3191_/A1 _3053_/X _3055_/X VGND VGND VPWR VPWR _3056_/X sky130_fd_sc_hd__a21o_2
XFILLER_35_150 VGND VGND VPWR VPWR sky130_fd_sc_hd__fill_1
XFILLER_23_356 VGND VGND VPWR VPWR sky130_fd_sc_hd__decap_3
XFILLER_51_643 VGND VGND VPWR VPWR sky130_fd_sc_hd__fill_2
XFILLER_11_529 VGND VGND VPWR VPWR sky130_fd_sc_hd__decap_3
XFILLER_50_153 VGND VGND VPWR VPWR sky130_fd_sc_hd__decap_3
XTAP_TAPCELL_ROW_21_502 VGND VPWR sky130_fd_sc_hd__tapvpwrvgnd_1
XFILLER_50_197 VGND VGND VPWR VPWR sky130_fd_sc_hd__fill_1
X_3958_ _4752_/A1 wire546/X wire325/X _3958_/B2 VGND VGND VPWR VPWR _5054_/D sky130_fd_sc_hd__a22o_2
X_3889_ _3889_/A _3889_/B VGND VGND VPWR VPWR _3889_/X sky130_fd_sc_hd__or2_2
X_2909_ _2611_/A _2906_/X _2908_/X wire659/X VGND VGND VPWR VPWR _2909_/X sky130_fd_sc_hd__a22o_2
XTAP_TAPCELL_ROW_98_1423 VGND VPWR sky130_fd_sc_hd__tapvpwrvgnd_1
X_5628_ _5692_/CLK _5628_/D VGND VGND VPWR VPWR _5628_/Q sky130_fd_sc_hd__dfxtp_2
X_5559_ _5879_/CLK _5559_/D VGND VGND VPWR VPWR _5559_/Q sky130_fd_sc_hd__dfxtp_2
XFILLER_104_122 VGND VGND VPWR VPWR sky130_fd_sc_hd__decap_3
XFILLER_105_656 VGND VGND VPWR VPWR sky130_fd_sc_hd__decap_3
XFILLER_104_177 VGND VGND VPWR VPWR sky130_fd_sc_hd__fill_2
XFILLER_76_47 VGND VGND VPWR VPWR sky130_fd_sc_hd__fill_1
Xfanout575 _3253_/X VGND VGND VPWR VPWR _3341_/A sky130_fd_sc_hd__dlymetal6s2s_1
Xfanout564 _3207_/B2 VGND VGND VPWR VPWR _3223_/C1 sky130_fd_sc_hd__clkdlybuf4s25_1
XFILLER_46_415 VGND VGND VPWR VPWR sky130_fd_sc_hd__decap_3
XFILLER_58_253 VGND VGND VPWR VPWR sky130_fd_sc_hd__decap_3
XTAP_TAPCELL_ROW_29_602 VGND VPWR sky130_fd_sc_hd__tapvpwrvgnd_1
Xfanout586 _3823_/B2 VGND VGND VPWR VPWR _3308_/A1 sky130_fd_sc_hd__clkdlybuf4s25_1
XFILLER_18_117 VGND VGND VPWR VPWR sky130_fd_sc_hd__decap_3
XTAP_TAPCELL_ROW_57_933 VGND VPWR sky130_fd_sc_hd__tapvpwrvgnd_1
XFILLER_92_24 VGND VGND VPWR VPWR sky130_fd_sc_hd__decap_3
XTAP_TAPCELL_ROW_107_1530 VGND VPWR sky130_fd_sc_hd__tapvpwrvgnd_1
XTAP_TAPCELL_ROW_1_260 VGND VPWR sky130_fd_sc_hd__tapvpwrvgnd_1
XFILLER_14_301 VGND VGND VPWR VPWR sky130_fd_sc_hd__decap_3
XFILLER_14_312 VGND VGND VPWR VPWR sky130_fd_sc_hd__fill_1
XFILLER_27_684 VGND VGND VPWR VPWR sky130_fd_sc_hd__decap_3
XFILLER_42_643 VGND VGND VPWR VPWR sky130_fd_sc_hd__fill_1
XTAP_TAPCELL_ROW_37_690 VGND VPWR sky130_fd_sc_hd__tapvpwrvgnd_1
XFILLER_10_551 VGND VGND VPWR VPWR sky130_fd_sc_hd__decap_3
XFILLER_6_566 VGND VGND VPWR VPWR sky130_fd_sc_hd__decap_3
XPHY_EDGE_ROW_102_Left_218 VGND VGND VPWR VPWR sky130_fd_sc_hd__decap_3
XTAP_TAPCELL_ROW_71_1106 VGND VPWR sky130_fd_sc_hd__tapvpwrvgnd_1
XTAP_TAPCELL_ROW_9_360 VGND VPWR sky130_fd_sc_hd__tapvpwrvgnd_1
XFILLER_111_626 VGND VGND VPWR VPWR sky130_fd_sc_hd__decap_3
XFILLER_110_136 VGND VGND VPWR VPWR sky130_fd_sc_hd__decap_3
XFILLER_111_659 VGND VGND VPWR VPWR sky130_fd_sc_hd__decap_3
XFILLER_2_44 VGND VGND VPWR VPWR sky130_fd_sc_hd__decap_3
XFILLER_110_158 VGND VGND VPWR VPWR sky130_fd_sc_hd__decap_3
XFILLER_64_234 VGND VGND VPWR VPWR sky130_fd_sc_hd__fill_2
XFILLER_64_256 VGND VGND VPWR VPWR sky130_fd_sc_hd__fill_1
XFILLER_92_576 VGND VGND VPWR VPWR sky130_fd_sc_hd__decap_3
XTAP_TAPCELL_ROW_69_1079 VGND VPWR sky130_fd_sc_hd__tapvpwrvgnd_1
XPHY_EDGE_ROW_111_Left_227 VGND VGND VPWR VPWR sky130_fd_sc_hd__decap_3
X_4930_ _5032_/A1 wire355/A _4945_/B1 _4930_/B2 VGND VGND VPWR VPWR _5960_/D sky130_fd_sc_hd__a22o_2
XFILLER_45_492 VGND VGND VPWR VPWR sky130_fd_sc_hd__decap_3
X_4861_ _5031_/A1 wire367/X _4861_/B1 _4861_/B2 VGND VGND VPWR VPWR _5895_/D sky130_fd_sc_hd__a22o_2
XTAP_TAPCELL_ROW_82_1235 VGND VPWR sky130_fd_sc_hd__tapvpwrvgnd_1
XFILLER_32_153 VGND VGND VPWR VPWR sky130_fd_sc_hd__decap_3
X_3812_ _3800_/A _3808_/X _3811_/X _3261_/X VGND VGND VPWR VPWR _3812_/X sky130_fd_sc_hd__o211a_2
XANTENNA_16 wire283/X VGND VGND VPWR VPWR sky130_fd_sc_hd__diode_2
XANTENNA_27 fanout822/X VGND VGND VPWR VPWR sky130_fd_sc_hd__diode_2
XANTENNA_38 _4912_/Y VGND VGND VPWR VPWR sky130_fd_sc_hd__diode_2
X_4792_ _4807_/A_N _4792_/B VGND VGND VPWR VPWR _5830_/D sky130_fd_sc_hd__and2b_2
X_3743_ _5838_/Q _5454_/Q _3743_/S VGND VGND VPWR VPWR _3743_/X sky130_fd_sc_hd__mux2_1
XFILLER_9_393 VGND VGND VPWR VPWR sky130_fd_sc_hd__decap_3
X_3674_ _5931_/Q _5899_/Q _5867_/Q _5771_/Q _3676_/S _3788_/S1 VGND VGND VPWR VPWR
+ _3674_/X sky130_fd_sc_hd__mux4_2
Xoutput101 _3855_/X VGND VGND VPWR VPWR rd2[27] sky130_fd_sc_hd__buf_6
X_5413_ _5713_/CLK _5413_/D VGND VGND VPWR VPWR _5413_/Q sky130_fd_sc_hd__dfxtp_2
X_2625_ _5117_/Q _5085_/Q _6013_/Q _5981_/Q _2627_/S _2996_/S1 VGND VGND VPWR VPWR
+ _2625_/X sky130_fd_sc_hd__mux4_2
Xoutput112 _3441_/X VGND VGND VPWR VPWR rd2[8] sky130_fd_sc_hd__clkbuf_2
X_5344_ _5589_/CLK _5344_/D VGND VGND VPWR VPWR _5344_/Q sky130_fd_sc_hd__dfxtp_2
X_2556_ _5690_/Q _5658_/Q _5626_/Q _5594_/Q _2582_/S wire760/A VGND VGND VPWR VPWR
+ _2556_/X sky130_fd_sc_hd__mux4_2
XTAP_TAPCELL_ROW_93_1364 VGND VPWR sky130_fd_sc_hd__tapvpwrvgnd_1
XFILLER_102_626 VGND VGND VPWR VPWR sky130_fd_sc_hd__decap_3
X_5275_ _5658_/CLK _5275_/D VGND VGND VPWR VPWR _5275_/Q sky130_fd_sc_hd__dfxtp_2
XFILLER_87_348 VGND VGND VPWR VPWR sky130_fd_sc_hd__decap_3
X_4226_ _4534_/A1 _4226_/A2 _4226_/B1 _4226_/B2 VGND VGND VPWR VPWR _5300_/D sky130_fd_sc_hd__a22o_2
X_4157_ _5010_/A1 wire508/A _4157_/B1 _4157_/B2 VGND VGND VPWR VPWR _5236_/D sky130_fd_sc_hd__a22o_2
XFILLER_110_681 VGND VGND VPWR VPWR sky130_fd_sc_hd__decap_3
XFILLER_28_437 VGND VGND VPWR VPWR sky130_fd_sc_hd__decap_3
XFILLER_68_595 VGND VGND VPWR VPWR sky130_fd_sc_hd__decap_3
X_3108_ _3108_/A _3108_/B VGND VGND VPWR VPWR _3108_/X sky130_fd_sc_hd__or2_2
XFILLER_55_245 VGND VGND VPWR VPWR sky130_fd_sc_hd__fill_1
XTAP_TAPCELL_ROW_54_903 VGND VPWR sky130_fd_sc_hd__tapvpwrvgnd_1
X_4088_ _5010_/A1 wire524/A _4088_/B1 _4088_/B2 VGND VGND VPWR VPWR _5172_/D sky130_fd_sc_hd__a22o_2
X_3039_ wire651/X _3037_/X _3038_/X wire685/X VGND VGND VPWR VPWR _3039_/X sky130_fd_sc_hd__o22a_2
XFILLER_102_56 VGND VGND VPWR VPWR sky130_fd_sc_hd__decap_3
XFILLER_24_632 VGND VGND VPWR VPWR sky130_fd_sc_hd__decap_3
XFILLER_24_643 VGND VGND VPWR VPWR sky130_fd_sc_hd__fill_1
XFILLER_62_27 VGND VGND VPWR VPWR sky130_fd_sc_hd__fill_1
XFILLER_23_153 VGND VGND VPWR VPWR sky130_fd_sc_hd__decap_3
XFILLER_23_164 VGND VGND VPWR VPWR sky130_fd_sc_hd__decap_3
XFILLER_24_676 VGND VGND VPWR VPWR sky130_fd_sc_hd__decap_3
XTAP_TAPCELL_ROW_34_660 VGND VPWR sky130_fd_sc_hd__tapvpwrvgnd_1
XFILLER_11_337 VGND VGND VPWR VPWR sky130_fd_sc_hd__decap_3
XTAP_TAPCELL_ROW_102_1471 VGND VPWR sky130_fd_sc_hd__tapvpwrvgnd_1
XTAP_TAPCELL_ROW_62_991 VGND VPWR sky130_fd_sc_hd__tapvpwrvgnd_1
XFILLER_109_269 VGND VGND VPWR VPWR sky130_fd_sc_hd__decap_3
XFILLER_11_31 VGND VGND VPWR VPWR sky130_fd_sc_hd__fill_1
XFILLER_3_569 VGND VGND VPWR VPWR sky130_fd_sc_hd__decap_3
XFILLER_87_57 VGND VGND VPWR VPWR sky130_fd_sc_hd__decap_3
XFILLER_93_329 VGND VGND VPWR VPWR sky130_fd_sc_hd__decap_3
Xfanout383 fanout383/A VGND VGND VPWR VPWR _4777_/A2 sky130_fd_sc_hd__clkdlybuf4s25_1
Xfanout372 fanout375/A VGND VGND VPWR VPWR _4841_/A2 sky130_fd_sc_hd__clkdlybuf4s25_1
Xfanout361 _4878_/Y VGND VGND VPWR VPWR _4904_/A2 sky130_fd_sc_hd__clkdlybuf4s25_1
XFILLER_101_670 VGND VGND VPWR VPWR sky130_fd_sc_hd__fill_2
XFILLER_101_681 VGND VGND VPWR VPWR sky130_fd_sc_hd__decap_3
Xfanout394 _4675_/Y VGND VGND VPWR VPWR _4707_/A2 sky130_fd_sc_hd__clkdlybuf4s25_1
XFILLER_46_256 VGND VGND VPWR VPWR sky130_fd_sc_hd__fill_2
XFILLER_34_429 VGND VGND VPWR VPWR sky130_fd_sc_hd__fill_2
XFILLER_36_72 VGND VGND VPWR VPWR sky130_fd_sc_hd__decap_3
XFILLER_61_204 VGND VGND VPWR VPWR sky130_fd_sc_hd__decap_3
XFILLER_15_676 VGND VGND VPWR VPWR sky130_fd_sc_hd__decap_3
XFILLER_42_462 VGND VGND VPWR VPWR sky130_fd_sc_hd__decap_3
XFILLER_99_9 VGND VGND VPWR VPWR sky130_fd_sc_hd__decap_3
XFILLER_14_197 VGND VGND VPWR VPWR sky130_fd_sc_hd__decap_3
XFILLER_30_679 VGND VGND VPWR VPWR sky130_fd_sc_hd__fill_1
Xinput14 rs2[3] VGND VGND VPWR VPWR input14/X sky130_fd_sc_hd__clkdlybuf4s25_1
Xinput25 wd[17] VGND VGND VPWR VPWR input25/X sky130_fd_sc_hd__clkdlybuf4s25_1
Xinput36 wd[27] VGND VGND VPWR VPWR input36/X sky130_fd_sc_hd__clkdlybuf4s25_1
Xclkbuf_leaf_103_clk clkbuf_4_0_0_clk/X VGND VGND VPWR VPWR _6041_/CLK sky130_fd_sc_hd__clkbuf_8
XFILLER_6_341 VGND VGND VPWR VPWR sky130_fd_sc_hd__decap_3
XTAP_TAPCELL_ROW_12_398 VGND VPWR sky130_fd_sc_hd__tapvpwrvgnd_1
Xinput47 wd[8] VGND VGND VPWR VPWR input47/X sky130_fd_sc_hd__clkdlybuf4s25_1
XFILLER_6_374 VGND VGND VPWR VPWR sky130_fd_sc_hd__decap_3
X_3390_ _5406_/Q _5054_/Q _3821_/S VGND VGND VPWR VPWR _3390_/X sky130_fd_sc_hd__mux2_1
XFILLER_97_635 VGND VGND VPWR VPWR sky130_fd_sc_hd__decap_3
Xload_slew723 _3175_/A VGND VGND VPWR VPWR _3131_/A sky130_fd_sc_hd__buf_4
Xload_slew712 _3548_/A1 VGND VGND VPWR VPWR _3867_/A sky130_fd_sc_hd__clkbuf_4
Xload_slew756 _3013_/S1 VGND VGND VPWR VPWR _3024_/S1 sky130_fd_sc_hd__clkbuf_2
Xload_slew745 _2755_/A1 VGND VGND VPWR VPWR _3183_/A1 sky130_fd_sc_hd__clkbuf_4
X_5060_ _5956_/CLK _5060_/D VGND VGND VPWR VPWR _5060_/Q sky130_fd_sc_hd__dfxtp_2
XFILLER_28_3 VGND VGND VPWR VPWR sky130_fd_sc_hd__decap_3
Xhold1509 _5272_/Q VGND VGND VPWR VPWR _4198_/B2 sky130_fd_sc_hd__dlygate4sd3_1
Xload_slew789 _2534_/S VGND VGND VPWR VPWR _3122_/S sky130_fd_sc_hd__buf_4
Xload_slew778 _3091_/S1 VGND VGND VPWR VPWR _3086_/S1 sky130_fd_sc_hd__buf_4
Xload_slew767 _3057_/S1 VGND VGND VPWR VPWR _3062_/S1 sky130_fd_sc_hd__buf_4
X_4011_ _4528_/A1 _3988_/B _4017_/B1 _4011_/B2 VGND VGND VPWR VPWR _5102_/D sky130_fd_sc_hd__a22o_2
XFILLER_37_234 VGND VGND VPWR VPWR sky130_fd_sc_hd__decap_3
XFILLER_92_351 VGND VGND VPWR VPWR sky130_fd_sc_hd__decap_3
XFILLER_25_418 VGND VGND VPWR VPWR sky130_fd_sc_hd__decap_3
XFILLER_37_267 VGND VGND VPWR VPWR sky130_fd_sc_hd__decap_3
XFILLER_52_215 VGND VGND VPWR VPWR sky130_fd_sc_hd__decap_3
XFILLER_65_576 VGND VGND VPWR VPWR sky130_fd_sc_hd__fill_1
XFILLER_80_524 VGND VGND VPWR VPWR sky130_fd_sc_hd__decap_3
X_5962_ _6058_/CLK _5962_/D VGND VGND VPWR VPWR _5962_/Q sky130_fd_sc_hd__dfxtp_2
XFILLER_80_546 VGND VGND VPWR VPWR sky130_fd_sc_hd__fill_2
X_4913_ _4913_/A _4913_/B VGND VGND VPWR VPWR _4913_/Y sky130_fd_sc_hd__nor2_2
X_5893_ _6070_/CLK _5893_/D VGND VGND VPWR VPWR _5893_/Q sky130_fd_sc_hd__dfxtp_2
X_4844_ _4844_/A _4878_/B VGND VGND VPWR VPWR _4844_/Y sky130_fd_sc_hd__nor2_2
XFILLER_21_679 VGND VGND VPWR VPWR sky130_fd_sc_hd__decap_3
X_4775_ _4775_/A1 _4775_/A2 _4775_/B1 _4775_/B2 VGND VGND VPWR VPWR _5813_/D sky130_fd_sc_hd__a22o_2
X_3726_ _5390_/Q _5358_/Q _5326_/Q _5294_/Q _3727_/S _3736_/S1 VGND VGND VPWR VPWR
+ _3726_/X sky130_fd_sc_hd__mux4_2
X_3657_ _3647_/X _3651_/X _3656_/X _3946_/B1 VGND VGND VPWR VPWR _3657_/X sky130_fd_sc_hd__o31a_2
X_3588_ _5703_/Q _5671_/Q _5639_/Q _5607_/Q _3475_/S _3929_/S1 VGND VGND VPWR VPWR
+ _3588_/X sky130_fd_sc_hd__mux4_2
X_2608_ _2608_/A _2608_/B _2608_/C VGND VGND VPWR VPWR _2619_/B sky130_fd_sc_hd__or3_2
XFILLER_0_528 VGND VGND VPWR VPWR sky130_fd_sc_hd__decap_3
X_5327_ _5999_/CLK _5327_/D VGND VGND VPWR VPWR _5327_/Q sky130_fd_sc_hd__dfxtp_2
X_2539_ _3131_/A _2539_/B VGND VGND VPWR VPWR _2539_/X sky130_fd_sc_hd__or2_2
X_5258_ _5258_/CLK _5258_/D VGND VGND VPWR VPWR _5258_/Q sky130_fd_sc_hd__dfxtp_2
XFILLER_113_22 VGND VGND VPWR VPWR sky130_fd_sc_hd__decap_3
X_5189_ _5832_/CLK _5189_/D VGND VGND VPWR VPWR _5189_/Q sky130_fd_sc_hd__dfxtp_2
X_4209_ _4517_/A1 wire489/X wire269/X _4209_/B2 VGND VGND VPWR VPWR _5283_/D sky130_fd_sc_hd__a22o_2
XFILLER_113_55 VGND VGND VPWR VPWR sky130_fd_sc_hd__fill_1
XFILLER_28_256 VGND VGND VPWR VPWR sky130_fd_sc_hd__decap_3
XFILLER_113_66 VGND VGND VPWR VPWR sky130_fd_sc_hd__decap_3
XFILLER_71_524 VGND VGND VPWR VPWR sky130_fd_sc_hd__fill_1
XTAP_TAPCELL_ROW_104_1500 VGND VPWR sky130_fd_sc_hd__tapvpwrvgnd_1
XFILLER_113_99 VGND VGND VPWR VPWR sky130_fd_sc_hd__decap_3
XFILLER_51_281 VGND VGND VPWR VPWR sky130_fd_sc_hd__fill_1
XFILLER_22_85 VGND VGND VPWR VPWR sky130_fd_sc_hd__decap_3
XFILLER_98_12 VGND VGND VPWR VPWR sky130_fd_sc_hd__decap_3
XTAP_TAPCELL_ROW_115_1640 VGND VPWR sky130_fd_sc_hd__tapvpwrvgnd_1
XFILLER_3_388 VGND VGND VPWR VPWR sky130_fd_sc_hd__decap_3
Xfanout1112 _3915_/S VGND VGND VPWR VPWR _3913_/S sky130_fd_sc_hd__clkdlybuf4s25_1
XFILLER_78_156 VGND VGND VPWR VPWR sky130_fd_sc_hd__decap_3
Xfanout1123 _3689_/S VGND VGND VPWR VPWR _3943_/S sky130_fd_sc_hd__dlymetal6s2s_1
XFILLER_14_9 VGND VGND VPWR VPWR sky130_fd_sc_hd__decap_3
XFILLER_19_223 VGND VGND VPWR VPWR sky130_fd_sc_hd__fill_1
XFILLER_78_189 VGND VGND VPWR VPWR sky130_fd_sc_hd__fill_1
XFILLER_93_137 VGND VGND VPWR VPWR sky130_fd_sc_hd__decap_3
Xfanout180 fanout183/A VGND VGND VPWR VPWR _4673_/B1 sky130_fd_sc_hd__clkdlybuf4s25_1
XFILLER_93_159 VGND VGND VPWR VPWR sky130_fd_sc_hd__decap_3
XFILLER_47_93 VGND VGND VPWR VPWR sky130_fd_sc_hd__decap_3
XFILLER_74_362 VGND VGND VPWR VPWR sky130_fd_sc_hd__fill_2
XTAP_TAPCELL_ROW_66_1038 VGND VPWR sky130_fd_sc_hd__tapvpwrvgnd_1
XTAP_TAPCELL_ROW_17_457 VGND VPWR sky130_fd_sc_hd__tapvpwrvgnd_1
XTAP_TAPCELL_ROW_45_788 VGND VPWR sky130_fd_sc_hd__tapvpwrvgnd_1
XFILLER_30_421 VGND VGND VPWR VPWR sky130_fd_sc_hd__decap_3
XFILLER_97_6 VGND VGND VPWR VPWR sky130_fd_sc_hd__decap_3
X_2890_ _5192_/Q _5160_/Q _3133_/S VGND VGND VPWR VPWR _2890_/X sky130_fd_sc_hd__mux2_1
XFILLER_8_21 VGND VGND VPWR VPWR sky130_fd_sc_hd__decap_3
XFILLER_8_32 VGND VGND VPWR VPWR sky130_fd_sc_hd__decap_3
X_4560_ _4899_/A1 _4571_/A2 _4571_/B1 _4560_/B2 VGND VGND VPWR VPWR _5611_/D sky130_fd_sc_hd__a22o_2
Xwire570 wire570/A VGND VGND VPWR VPWR wire570/X sky130_fd_sc_hd__buf_4
X_4491_ _4525_/A1 _4471_/B _4496_/B1 _4491_/B2 VGND VGND VPWR VPWR _5547_/D sky130_fd_sc_hd__a22o_2
X_3511_ _5700_/Q _5668_/Q _5636_/Q _5604_/Q _3514_/S _3868_/S1 VGND VGND VPWR VPWR
+ _3512_/B sky130_fd_sc_hd__mux4_2
XTAP_TAPCELL_ROW_77_1178 VGND VPWR sky130_fd_sc_hd__tapvpwrvgnd_1
X_3442_ _5121_/Q _5089_/Q _6017_/Q _5985_/Q _3693_/S _3929_/S1 VGND VGND VPWR VPWR
+ _3442_/X sky130_fd_sc_hd__mux4_2
X_3373_ _5118_/Q _5086_/Q _6014_/Q _5982_/Q _3375_/S _3828_/S1 VGND VGND VPWR VPWR
+ _3373_/X sky130_fd_sc_hd__mux4_2
XFILLER_97_432 VGND VGND VPWR VPWR sky130_fd_sc_hd__decap_3
Xhold2007 _5363_/Q VGND VGND VPWR VPWR _4293_/B2 sky130_fd_sc_hd__dlygate4sd3_1
Xhold2018 _5495_/Q VGND VGND VPWR VPWR _4435_/B2 sky130_fd_sc_hd__dlygate4sd3_1
Xload_slew531 _4052_/A2 VGND VGND VPWR VPWR _4023_/B sky130_fd_sc_hd__buf_4
Xload_slew520 _4076_/A2 VGND VGND VPWR VPWR _4089_/A2 sky130_fd_sc_hd__clkbuf_4
X_5112_ _6027_/CLK _5112_/D VGND VGND VPWR VPWR _5112_/Q sky130_fd_sc_hd__dfxtp_2
XTAP_TAPCELL_ROW_90_1334 VGND VPWR sky130_fd_sc_hd__tapvpwrvgnd_1
XFILLER_111_253 VGND VGND VPWR VPWR sky130_fd_sc_hd__fill_1
Xhold1306 _6043_/Q VGND VGND VPWR VPWR _5019_/B2 sky130_fd_sc_hd__dlygate4sd3_1
Xhold2029 _5752_/Q VGND VGND VPWR VPWR _4712_/B2 sky130_fd_sc_hd__dlygate4sd3_1
Xload_slew542 _3974_/A2 VGND VGND VPWR VPWR _3981_/A2 sky130_fd_sc_hd__buf_4
XFILLER_38_510 VGND VGND VPWR VPWR sky130_fd_sc_hd__decap_3
XFILLER_69_189 VGND VGND VPWR VPWR sky130_fd_sc_hd__decap_3
Xhold1317 _5093_/Q VGND VGND VPWR VPWR _4002_/B2 sky130_fd_sc_hd__dlygate4sd3_1
Xhold1328 _5256_/Q VGND VGND VPWR VPWR _4179_/B2 sky130_fd_sc_hd__dlygate4sd3_1
Xhold1339 _5408_/Q VGND VGND VPWR VPWR _4342_/B2 sky130_fd_sc_hd__dlygate4sd3_1
X_5043_ _5043_/A1 _5043_/A2 wire115/X _5043_/B2 VGND VGND VPWR VPWR _6067_/D sky130_fd_sc_hd__a22o_2
XFILLER_65_362 VGND VGND VPWR VPWR sky130_fd_sc_hd__decap_3
XFILLER_65_373 VGND VGND VPWR VPWR sky130_fd_sc_hd__fill_1
XFILLER_93_671 VGND VGND VPWR VPWR sky130_fd_sc_hd__fill_1
XFILLER_80_343 VGND VGND VPWR VPWR sky130_fd_sc_hd__decap_3
XFILLER_53_568 VGND VGND VPWR VPWR sky130_fd_sc_hd__decap_3
XFILLER_80_365 VGND VGND VPWR VPWR sky130_fd_sc_hd__decap_3
X_5945_ clkload9/A _5945_/D VGND VGND VPWR VPWR _5945_/Q sky130_fd_sc_hd__dfxtp_2
XFILLER_33_270 VGND VGND VPWR VPWR sky130_fd_sc_hd__fill_2
X_5876_ _6068_/CLK _5876_/D VGND VGND VPWR VPWR _5876_/Q sky130_fd_sc_hd__dfxtp_2
X_4827_ _5031_/A1 wire376/X _4843_/B1 _4827_/B2 VGND VGND VPWR VPWR _5863_/D sky130_fd_sc_hd__a22o_2
X_4758_ _5028_/A1 _4776_/A2 _4768_/B1 _4758_/B2 VGND VGND VPWR VPWR _5796_/D sky130_fd_sc_hd__a22o_2
XFILLER_107_526 VGND VGND VPWR VPWR sky130_fd_sc_hd__decap_3
X_4689_ _5028_/A1 _4707_/A2 _4699_/B1 _4689_/B2 VGND VGND VPWR VPWR _5732_/D sky130_fd_sc_hd__a22o_2
X_3709_ _3709_/A1 _3706_/X _3708_/X VGND VGND VPWR VPWR _3709_/X sky130_fd_sc_hd__a21o_2
XFILLER_107_559 VGND VGND VPWR VPWR sky130_fd_sc_hd__fill_1
XFILLER_108_44 VGND VGND VPWR VPWR sky130_fd_sc_hd__decap_3
XFILLER_108_77 VGND VGND VPWR VPWR sky130_fd_sc_hd__decap_3
XFILLER_108_88 VGND VGND VPWR VPWR sky130_fd_sc_hd__decap_3
XFILLER_115_592 VGND VGND VPWR VPWR sky130_fd_sc_hd__decap_3
XFILLER_68_59 VGND VGND VPWR VPWR sky130_fd_sc_hd__fill_2
XFILLER_0_347 VGND VGND VPWR VPWR sky130_fd_sc_hd__decap_3
XFILLER_102_253 VGND VGND VPWR VPWR sky130_fd_sc_hd__fill_2
XFILLER_88_454 VGND VGND VPWR VPWR sky130_fd_sc_hd__decap_3
XTAP_TAPCELL_ROW_110_1570 VGND VPWR sky130_fd_sc_hd__tapvpwrvgnd_1
Xhold1840 _5965_/Q VGND VGND VPWR VPWR _4935_/B2 sky130_fd_sc_hd__dlygate4sd3_1
Xhold1851 _5886_/Q VGND VGND VPWR VPWR _4852_/B2 sky130_fd_sc_hd__dlygate4sd3_1
Xhold1862 _5953_/Q VGND VGND VPWR VPWR _4923_/B2 sky130_fd_sc_hd__dlygate4sd3_1
XFILLER_17_30 VGND VGND VPWR VPWR sky130_fd_sc_hd__fill_1
XFILLER_17_41 VGND VGND VPWR VPWR sky130_fd_sc_hd__decap_3
Xhold1873 _5492_/Q VGND VGND VPWR VPWR _4432_/B2 sky130_fd_sc_hd__dlygate4sd3_1
Xhold1884 _5941_/Q VGND VGND VPWR VPWR _4909_/B2 sky130_fd_sc_hd__dlygate4sd3_1
Xhold1895 _5079_/Q VGND VGND VPWR VPWR _3983_/B2 sky130_fd_sc_hd__dlygate4sd3_1
XFILLER_24_270 VGND VGND VPWR VPWR sky130_fd_sc_hd__fill_2
XTAP_TAPCELL_ROW_14_416 VGND VPWR sky130_fd_sc_hd__tapvpwrvgnd_1
XFILLER_33_51 VGND VGND VPWR VPWR sky130_fd_sc_hd__decap_3
XTAP_TAPCELL_ROW_42_758 VGND VPWR sky130_fd_sc_hd__tapvpwrvgnd_1
XFILLER_8_458 VGND VGND VPWR VPWR sky130_fd_sc_hd__fill_2
XFILLER_4_620 VGND VGND VPWR VPWR sky130_fd_sc_hd__decap_3
XFILLER_4_675 VGND VGND VPWR VPWR sky130_fd_sc_hd__decap_3
XFILLER_79_465 VGND VGND VPWR VPWR sky130_fd_sc_hd__decap_3
XFILLER_79_476 VGND VGND VPWR VPWR sky130_fd_sc_hd__fill_1
XFILLER_39_318 VGND VGND VPWR VPWR sky130_fd_sc_hd__fill_1
XFILLER_94_413 VGND VGND VPWR VPWR sky130_fd_sc_hd__decap_3
XFILLER_12_6 VGND VGND VPWR VPWR sky130_fd_sc_hd__decap_3
XFILLER_94_457 VGND VGND VPWR VPWR sky130_fd_sc_hd__fill_2
XFILLER_47_362 VGND VGND VPWR VPWR sky130_fd_sc_hd__decap_3
XFILLER_90_630 VGND VGND VPWR VPWR sky130_fd_sc_hd__decap_3
XFILLER_90_685 VGND VGND VPWR VPWR sky130_fd_sc_hd__decap_3
X_3991_ _5018_/A1 _4018_/A2 _4018_/B1 _3991_/B2 VGND VGND VPWR VPWR _5082_/D sky130_fd_sc_hd__a22o_2
XFILLER_50_527 VGND VGND VPWR VPWR sky130_fd_sc_hd__decap_3
XFILLER_95_3 VGND VGND VPWR VPWR sky130_fd_sc_hd__decap_3
X_5730_ _5794_/CLK _5730_/D VGND VGND VPWR VPWR _5730_/Q sky130_fd_sc_hd__dfxtp_2
X_2942_ _6059_/Q _5963_/Q _2942_/S VGND VGND VPWR VPWR _2942_/X sky130_fd_sc_hd__mux2_1
XFILLER_15_281 VGND VGND VPWR VPWR sky130_fd_sc_hd__decap_3
X_5661_ _5810_/CLK _5661_/D VGND VGND VPWR VPWR _5661_/Q sky130_fd_sc_hd__dfxtp_2
X_2873_ _5800_/Q _5736_/Q _2889_/S VGND VGND VPWR VPWR _2873_/X sky130_fd_sc_hd__mux2_1
Xclkbuf_4_4_0_clk clkbuf_0_clk/X VGND VGND VPWR VPWR clkbuf_4_4_0_clk/X sky130_fd_sc_hd__clkbuf_8
X_5592_ _5812_/CLK _5592_/D VGND VGND VPWR VPWR _5592_/Q sky130_fd_sc_hd__dfxtp_2
X_4612_ _4749_/A1 _4625_/A2 _4625_/B1 _4612_/B2 VGND VGND VPWR VPWR _5659_/D sky130_fd_sc_hd__a22o_2
X_4543_ _4645_/A1 _4557_/A2 _4557_/B1 _4543_/B2 VGND VGND VPWR VPWR _5594_/D sky130_fd_sc_hd__a22o_2
X_4474_ _4508_/A1 _4501_/A2 _4501_/B1 _4474_/B2 VGND VGND VPWR VPWR _5530_/D sky130_fd_sc_hd__a22o_2
Xfanout916 input36/X VGND VGND VPWR VPWR _4533_/A1 sky130_fd_sc_hd__clkdlybuf4s25_1
Xfanout905 _5045_/A1 VGND VGND VPWR VPWR _4943_/A1 sky130_fd_sc_hd__clkdlybuf4s25_1
X_3425_ _5120_/Q _5088_/Q _6016_/Q _5984_/Q _3427_/S _3839_/S1 VGND VGND VPWR VPWR
+ _3425_/X sky130_fd_sc_hd__mux4_2
Xfanout949 input27/X VGND VGND VPWR VPWR _4899_/A1 sky130_fd_sc_hd__clkdlybuf4s25_1
Xfanout938 input30/X VGND VGND VPWR VPWR _5003_/A1 sky130_fd_sc_hd__clkdlybuf4s25_1
Xfanout927 input33/X VGND VGND VPWR VPWR _5040_/A1 sky130_fd_sc_hd__clkdlybuf4s25_1
X_3356_ _3831_/A1 _3353_/X _3355_/X _3612_/C1 VGND VGND VPWR VPWR _3356_/X sky130_fd_sc_hd__o211a_2
XFILLER_112_584 VGND VGND VPWR VPWR sky130_fd_sc_hd__decap_3
XFILLER_112_595 VGND VGND VPWR VPWR sky130_fd_sc_hd__decap_3
XFILLER_97_284 VGND VGND VPWR VPWR sky130_fd_sc_hd__decap_3
Xload_slew350 _4936_/A2 VGND VGND VPWR VPWR _4941_/A2 sky130_fd_sc_hd__clkbuf_4
X_3287_ _3280_/X _3286_/X _3855_/B1 VGND VGND VPWR VPWR _3287_/X sky130_fd_sc_hd__o21a_2
XFILLER_57_148 VGND VGND VPWR VPWR sky130_fd_sc_hd__decap_3
XFILLER_85_457 VGND VGND VPWR VPWR sky130_fd_sc_hd__decap_3
Xhold1147 _5507_/Q VGND VGND VPWR VPWR _4449_/B2 sky130_fd_sc_hd__dlygate4sd3_1
Xhold1158 _6013_/Q VGND VGND VPWR VPWR _4987_/B2 sky130_fd_sc_hd__dlygate4sd3_1
X_5026_ _5026_/A1 _5045_/A2 _5045_/B1 _5026_/B2 VGND VGND VPWR VPWR _6050_/D sky130_fd_sc_hd__a22o_2
XFILLER_72_118 VGND VGND VPWR VPWR sky130_fd_sc_hd__decap_3
Xhold1169 _5334_/Q VGND VGND VPWR VPWR _4262_/B2 sky130_fd_sc_hd__dlygate4sd3_1
Xclkbuf_leaf_92_clk clkload1/A VGND VGND VPWR VPWR _5500_/CLK sky130_fd_sc_hd__clkbuf_8
XFILLER_80_151 VGND VGND VPWR VPWR sky130_fd_sc_hd__decap_3
XFILLER_110_12 VGND VGND VPWR VPWR sky130_fd_sc_hd__decap_3
X_5928_ _6032_/CLK _5928_/D VGND VGND VPWR VPWR _5928_/Q sky130_fd_sc_hd__dfxtp_2
XFILLER_110_56 VGND VGND VPWR VPWR sky130_fd_sc_hd__decap_3
XFILLER_21_240 VGND VGND VPWR VPWR sky130_fd_sc_hd__fill_2
XFILLER_21_262 VGND VGND VPWR VPWR sky130_fd_sc_hd__decap_3
XFILLER_21_273 VGND VGND VPWR VPWR sky130_fd_sc_hd__decap_3
XFILLER_70_27 VGND VGND VPWR VPWR sky130_fd_sc_hd__fill_1
X_5859_ _6051_/CLK _5859_/D VGND VGND VPWR VPWR _5859_/Q sky130_fd_sc_hd__dfxtp_2
XFILLER_79_69 VGND VGND VPWR VPWR sky130_fd_sc_hd__fill_2
XFILLER_0_100 VGND VGND VPWR VPWR sky130_fd_sc_hd__fill_1
XFILLER_1_623 VGND VGND VPWR VPWR sky130_fd_sc_hd__decap_3
XFILLER_1_656 VGND VGND VPWR VPWR sky130_fd_sc_hd__decap_3
XFILLER_49_605 VGND VGND VPWR VPWR sky130_fd_sc_hd__fill_2
XFILLER_76_424 VGND VGND VPWR VPWR sky130_fd_sc_hd__decap_3
XFILLER_95_57 VGND VGND VPWR VPWR sky130_fd_sc_hd__decap_3
XFILLER_29_351 VGND VGND VPWR VPWR sky130_fd_sc_hd__decap_3
XFILLER_91_416 VGND VGND VPWR VPWR sky130_fd_sc_hd__decap_3
XTAP_TAPCELL_ROW_47_817 VGND VPWR sky130_fd_sc_hd__tapvpwrvgnd_1
Xhold1670 _5956_/Q VGND VGND VPWR VPWR _4926_/B2 sky130_fd_sc_hd__dlygate4sd3_1
Xload_slew1111 _3762_/S VGND VGND VPWR VPWR _3873_/S sky130_fd_sc_hd__buf_4
Xload_slew1122 _3580_/S VGND VGND VPWR VPWR _3693_/S sky130_fd_sc_hd__clkbuf_4
XFILLER_72_641 VGND VGND VPWR VPWR sky130_fd_sc_hd__decap_3
Xhold1681 _5744_/Q VGND VGND VPWR VPWR _4701_/B2 sky130_fd_sc_hd__dlygate4sd3_1
Xhold1692 _5896_/Q VGND VGND VPWR VPWR _4862_/B2 sky130_fd_sc_hd__dlygate4sd3_1
Xclkbuf_leaf_83_clk clkbuf_4_4_0_clk/X VGND VGND VPWR VPWR _6010_/CLK sky130_fd_sc_hd__clkbuf_8
XFILLER_71_140 VGND VGND VPWR VPWR sky130_fd_sc_hd__decap_3
XTAP_TAPCELL_ROW_63_1008 VGND VPWR sky130_fd_sc_hd__tapvpwrvgnd_1
XFILLER_72_685 VGND VGND VPWR VPWR sky130_fd_sc_hd__decap_3
XTAP_TAPCELL_ROW_27_574 VGND VPWR sky130_fd_sc_hd__tapvpwrvgnd_1
XFILLER_8_211 VGND VGND VPWR VPWR sky130_fd_sc_hd__decap_3
XFILLER_12_284 VGND VGND VPWR VPWR sky130_fd_sc_hd__fill_1
XFILLER_8_266 VGND VGND VPWR VPWR sky130_fd_sc_hd__decap_3
XFILLER_5_33 VGND VGND VPWR VPWR sky130_fd_sc_hd__decap_3
XFILLER_99_505 VGND VGND VPWR VPWR sky130_fd_sc_hd__decap_3
XTAP_TAPCELL_ROW_74_1137 VGND VPWR sky130_fd_sc_hd__tapvpwrvgnd_1
X_4190_ _5043_/A1 _4192_/A2 _4192_/B1 _4190_/B2 VGND VGND VPWR VPWR _5267_/D sky130_fd_sc_hd__a22o_2
X_3210_ _5847_/Q _5463_/Q _3227_/S VGND VGND VPWR VPWR _3210_/X sky130_fd_sc_hd__mux2_1
X_3141_ _3185_/B2 _3124_/X _3140_/X _2572_/A VGND VGND VPWR VPWR _3141_/X sky130_fd_sc_hd__a22o_2
XFILLER_10_3 VGND VGND VPWR VPWR sky130_fd_sc_hd__decap_3
XFILLER_39_148 VGND VGND VPWR VPWR sky130_fd_sc_hd__fill_1
XFILLER_48_660 VGND VGND VPWR VPWR sky130_fd_sc_hd__decap_3
XFILLER_82_405 VGND VGND VPWR VPWR sky130_fd_sc_hd__decap_3
X_3072_ _3191_/A1 _3069_/X _3071_/X VGND VGND VPWR VPWR _3072_/X sky130_fd_sc_hd__a21o_2
XFILLER_47_181 VGND VGND VPWR VPWR sky130_fd_sc_hd__decap_3
XFILLER_94_298 VGND VGND VPWR VPWR sky130_fd_sc_hd__fill_1
Xclkbuf_leaf_74_clk clkload2/A VGND VGND VPWR VPWR _6034_/CLK sky130_fd_sc_hd__clkbuf_8
XTAP_TAPCELL_ROW_85_1266 VGND VPWR sky130_fd_sc_hd__tapvpwrvgnd_1
XFILLER_62_162 VGND VGND VPWR VPWR sky130_fd_sc_hd__decap_3
XFILLER_63_685 VGND VGND VPWR VPWR sky130_fd_sc_hd__decap_3
XFILLER_62_195 VGND VGND VPWR VPWR sky130_fd_sc_hd__fill_1
X_3974_ _4768_/A1 _3974_/A2 wire322/X _3974_/B2 VGND VGND VPWR VPWR _5070_/D sky130_fd_sc_hd__a22o_2
X_5713_ _5713_/CLK _5713_/D VGND VGND VPWR VPWR _5713_/Q sky130_fd_sc_hd__dfxtp_2
X_2925_ _5418_/Q _5066_/Q _2925_/S VGND VGND VPWR VPWR _2925_/X sky130_fd_sc_hd__mux2_1
XFILLER_31_593 VGND VGND VPWR VPWR sky130_fd_sc_hd__decap_3
X_5644_ _6049_/CLK _5644_/D VGND VGND VPWR VPWR _5644_/Q sky130_fd_sc_hd__dfxtp_2
X_2856_ _5511_/Q _5479_/Q _2856_/S VGND VGND VPWR VPWR _2856_/X sky130_fd_sc_hd__mux2_1
X_5575_ _5943_/CLK _5575_/D VGND VGND VPWR VPWR _5575_/Q sky130_fd_sc_hd__dfxtp_2
X_2787_ _5124_/Q _5092_/Q _6020_/Q _5988_/Q _2789_/S _3062_/S1 VGND VGND VPWR VPWR
+ _2787_/X sky130_fd_sc_hd__mux4_2
X_4526_ _4526_/A1 _4537_/A2 _4537_/B1 _4526_/B2 VGND VGND VPWR VPWR _5580_/D sky130_fd_sc_hd__a22o_2
X_4457_ _5001_/A1 _4460_/A2 _4460_/B1 _4457_/B2 VGND VGND VPWR VPWR _5515_/D sky130_fd_sc_hd__a22o_2
XFILLER_49_39 VGND VGND VPWR VPWR sky130_fd_sc_hd__fill_2
Xfanout724 fanout730/X VGND VGND VPWR VPWR wire725/A sky130_fd_sc_hd__clkdlybuf4s25_1
Xfanout713 _3906_/A VGND VGND VPWR VPWR _3918_/A sky130_fd_sc_hd__clkdlybuf4s25_1
X_3408_ _3800_/A _3408_/B VGND VGND VPWR VPWR _3408_/X sky130_fd_sc_hd__or2_2
XFILLER_105_12 VGND VGND VPWR VPWR sky130_fd_sc_hd__decap_3
Xfanout757 fanout765/X VGND VGND VPWR VPWR _3018_/S1 sky130_fd_sc_hd__clkdlybuf4s25_1
Xfanout746 input8/X VGND VGND VPWR VPWR _3027_/A1 sky130_fd_sc_hd__clkdlybuf4s25_1
X_4388_ _5035_/A1 _4368_/B wire238/A _4388_/B2 VGND VGND VPWR VPWR _5451_/D sky130_fd_sc_hd__a22o_2
XFILLER_46_608 VGND VGND VPWR VPWR sky130_fd_sc_hd__fill_1
Xfanout779 _2979_/S1 VGND VGND VPWR VPWR _2973_/S1 sky130_fd_sc_hd__clkdlybuf4s25_1
Xfanout768 wire772/A VGND VGND VPWR VPWR _3153_/S1 sky130_fd_sc_hd__clkdlybuf4s25_1
X_3339_ _5788_/Q _5724_/Q _3339_/S VGND VGND VPWR VPWR _3339_/X sky130_fd_sc_hd__mux2_1
XFILLER_105_78 VGND VGND VPWR VPWR sky130_fd_sc_hd__decap_3
X_6058_ _6058_/CLK _6058_/D VGND VGND VPWR VPWR _6058_/Q sky130_fd_sc_hd__dfxtp_2
XFILLER_39_682 VGND VGND VPWR VPWR sky130_fd_sc_hd__decap_3
XFILLER_45_129 VGND VGND VPWR VPWR sky130_fd_sc_hd__decap_3
Xclkbuf_leaf_65_clk clkbuf_4_6_0_clk/X VGND VGND VPWR VPWR _5922_/CLK sky130_fd_sc_hd__clkbuf_8
X_5009_ _5009_/A1 _5011_/A2 _5011_/B1 _5009_/B2 VGND VGND VPWR VPWR _6035_/D sky130_fd_sc_hd__a22o_2
XFILLER_26_365 VGND VGND VPWR VPWR sky130_fd_sc_hd__fill_2
XFILLER_14_527 VGND VGND VPWR VPWR sky130_fd_sc_hd__decap_3
XFILLER_81_26 VGND VGND VPWR VPWR sky130_fd_sc_hd__decap_3
XTAP_TAPCELL_ROW_24_533 VGND VPWR sky130_fd_sc_hd__tapvpwrvgnd_1
XTAP_TAPCELL_ROW_52_875 VGND VPWR sky130_fd_sc_hd__tapvpwrvgnd_1
XFILLER_14_97 VGND VGND VPWR VPWR sky130_fd_sc_hd__decap_3
XFILLER_108_643 VGND VGND VPWR VPWR sky130_fd_sc_hd__fill_1
XFILLER_108_654 VGND VGND VPWR VPWR sky130_fd_sc_hd__decap_3
XPHY_EDGE_ROW_15_Left_131 VGND VGND VPWR VPWR sky130_fd_sc_hd__decap_3
XFILLER_108_687 VGND VGND VPWR VPWR sky130_fd_sc_hd__fill_1
XFILLER_107_175 VGND VGND VPWR VPWR sky130_fd_sc_hd__decap_3
XFILLER_76_210 VGND VGND VPWR VPWR sky130_fd_sc_hd__fill_2
XFILLER_64_438 VGND VGND VPWR VPWR sky130_fd_sc_hd__fill_1
XFILLER_91_213 VGND VGND VPWR VPWR sky130_fd_sc_hd__decap_3
XPHY_EDGE_ROW_101_Right_101 VGND VGND VPWR VPWR sky130_fd_sc_hd__decap_3
XPHY_EDGE_ROW_24_Left_140 VGND VGND VPWR VPWR sky130_fd_sc_hd__decap_3
Xclkbuf_leaf_56_clk clkload6/A VGND VGND VPWR VPWR _5799_/CLK sky130_fd_sc_hd__clkbuf_8
XFILLER_17_354 VGND VGND VPWR VPWR sky130_fd_sc_hd__decap_3
XFILLER_29_192 VGND VGND VPWR VPWR sky130_fd_sc_hd__decap_3
XFILLER_55_60 VGND VGND VPWR VPWR sky130_fd_sc_hd__fill_2
XFILLER_55_71 VGND VGND VPWR VPWR sky130_fd_sc_hd__fill_1
XFILLER_44_173 VGND VGND VPWR VPWR sky130_fd_sc_hd__decap_3
XFILLER_45_685 VGND VGND VPWR VPWR sky130_fd_sc_hd__decap_3
XFILLER_55_93 VGND VGND VPWR VPWR sky130_fd_sc_hd__decap_3
XFILLER_72_471 VGND VGND VPWR VPWR sky130_fd_sc_hd__decap_3
XFILLER_32_368 VGND VGND VPWR VPWR sky130_fd_sc_hd__fill_1
X_2710_ wire676/X _2707_/X _2709_/X VGND VGND VPWR VPWR _2710_/Y sky130_fd_sc_hd__o21ai_2
XFILLER_9_586 VGND VGND VPWR VPWR sky130_fd_sc_hd__decap_3
X_3690_ _3695_/A1 _3688_/X _3689_/X _3694_/A VGND VGND VPWR VPWR _3690_/X sky130_fd_sc_hd__o22a_2
X_2641_ wire559/X _2636_/X _2639_/X _2629_/X VGND VGND VPWR VPWR _2641_/X sky130_fd_sc_hd__a31o_2
X_5360_ _6059_/CLK _5360_/D VGND VGND VPWR VPWR _5360_/Q sky130_fd_sc_hd__dfxtp_2
X_2572_ _2572_/A _2572_/B VGND VGND VPWR VPWR _2574_/B sky130_fd_sc_hd__nand2_2
XFILLER_114_613 VGND VGND VPWR VPWR sky130_fd_sc_hd__decap_3
X_5291_ _6059_/CLK _5291_/D VGND VGND VPWR VPWR _5291_/Q sky130_fd_sc_hd__dfxtp_2
X_4311_ _4517_/A1 _4327_/A2 wire248/X _4311_/B2 VGND VGND VPWR VPWR _5379_/D sky130_fd_sc_hd__a22o_2
XFILLER_114_657 VGND VGND VPWR VPWR sky130_fd_sc_hd__decap_3
XFILLER_87_508 VGND VGND VPWR VPWR sky130_fd_sc_hd__decap_3
X_4242_ _4822_/A1 _4258_/A2 _4261_/B1 _4242_/B2 VGND VGND VPWR VPWR _5314_/D sky130_fd_sc_hd__a22o_2
XFILLER_95_541 VGND VGND VPWR VPWR sky130_fd_sc_hd__decap_3
X_4173_ _4653_/A1 wire500/X wire281/X _4173_/B2 VGND VGND VPWR VPWR _5250_/D sky130_fd_sc_hd__a22o_2
X_3124_ wire693/X _3121_/X _3123_/X VGND VGND VPWR VPWR _3124_/X sky130_fd_sc_hd__a21o_2
X_3055_ _3055_/A1 _3052_/X _3054_/X _3146_/B2 VGND VGND VPWR VPWR _3055_/X sky130_fd_sc_hd__a22o_2
Xclkbuf_leaf_47_clk clkbuf_4_14_0_clk/X VGND VGND VPWR VPWR _6060_/CLK sky130_fd_sc_hd__clkbuf_8
XFILLER_63_460 VGND VGND VPWR VPWR sky130_fd_sc_hd__decap_3
XFILLER_70_419 VGND VGND VPWR VPWR sky130_fd_sc_hd__fill_1
XTAP_TAPCELL_ROW_21_503 VGND VPWR sky130_fd_sc_hd__tapvpwrvgnd_1
X_3957_ _4987_/A1 wire546/X wire325/X _3957_/B2 VGND VGND VPWR VPWR _5053_/D sky130_fd_sc_hd__a22o_2
XFILLER_50_187 VGND VGND VPWR VPWR sky130_fd_sc_hd__fill_1
X_2908_ _5801_/Q _5737_/Q _2908_/S VGND VGND VPWR VPWR _2908_/X sky130_fd_sc_hd__mux2_1
X_3888_ _5141_/Q _5109_/Q _6037_/Q _6005_/Q _3277_/S _3893_/S1 VGND VGND VPWR VPWR
+ _3889_/B sky130_fd_sc_hd__mux4_2
XTAP_TAPCELL_ROW_98_1424 VGND VPWR sky130_fd_sc_hd__tapvpwrvgnd_1
X_5627_ _5691_/CLK _5627_/D VGND VGND VPWR VPWR _5627_/Q sky130_fd_sc_hd__dfxtp_2
X_2839_ _5190_/Q _5158_/Q _3003_/S VGND VGND VPWR VPWR _2839_/X sky130_fd_sc_hd__mux2_1
XFILLER_105_602 VGND VGND VPWR VPWR sky130_fd_sc_hd__decap_3
X_5558_ _5797_/CLK _5558_/D VGND VGND VPWR VPWR _5558_/Q sky130_fd_sc_hd__dfxtp_2
X_4509_ _4509_/A1 _4532_/A2 _4532_/B1 _4509_/B2 VGND VGND VPWR VPWR _5563_/D sky130_fd_sc_hd__a22o_2
XFILLER_105_668 VGND VGND VPWR VPWR sky130_fd_sc_hd__decap_3
XFILLER_105_679 VGND VGND VPWR VPWR sky130_fd_sc_hd__decap_3
X_5489_ _5713_/CLK _5489_/D VGND VGND VPWR VPWR _5489_/Q sky130_fd_sc_hd__dfxtp_2
Xfanout532 _4022_/Y VGND VGND VPWR VPWR wire533/A sky130_fd_sc_hd__clkdlybuf4s25_1
Xfanout521 wire524/A VGND VGND VPWR VPWR _4085_/A2 sky130_fd_sc_hd__dlymetal6s4s_1
XFILLER_98_390 VGND VGND VPWR VPWR sky130_fd_sc_hd__decap_3
Xfanout565 _2500_/X VGND VGND VPWR VPWR _3207_/B2 sky130_fd_sc_hd__clkdlybuf4s25_1
Xfanout554 _3235_/X VGND VGND VPWR VPWR _3946_/B1 sky130_fd_sc_hd__clkbuf_2
Xfanout543 wire548/A VGND VGND VPWR VPWR _3951_/B sky130_fd_sc_hd__clkdlybuf4s25_1
XFILLER_100_362 VGND VGND VPWR VPWR sky130_fd_sc_hd__fill_2
XFILLER_86_563 VGND VGND VPWR VPWR sky130_fd_sc_hd__decap_3
XTAP_TAPCELL_ROW_29_603 VGND VPWR sky130_fd_sc_hd__tapvpwrvgnd_1
Xfanout598 _3791_/B2 VGND VGND VPWR VPWR _3745_/B2 sky130_fd_sc_hd__buf_2
Xfanout576 _3253_/X VGND VGND VPWR VPWR _3916_/B1 sky130_fd_sc_hd__dlymetal6s4s_1
XFILLER_100_373 VGND VGND VPWR VPWR sky130_fd_sc_hd__decap_3
XFILLER_46_427 VGND VGND VPWR VPWR sky130_fd_sc_hd__decap_3
XTAP_TAPCELL_ROW_57_934 VGND VPWR sky130_fd_sc_hd__tapvpwrvgnd_1
XTAP_TAPCELL_ROW_107_1531 VGND VPWR sky130_fd_sc_hd__tapvpwrvgnd_1
XTAP_TAPCELL_ROW_1_261 VGND VPWR sky130_fd_sc_hd__tapvpwrvgnd_1
Xclkbuf_leaf_38_clk clkbuf_4_12_0_clk/X VGND VGND VPWR VPWR _5832_/CLK sky130_fd_sc_hd__clkbuf_8
XFILLER_14_324 VGND VGND VPWR VPWR sky130_fd_sc_hd__decap_3
XTAP_TAPCELL_ROW_37_691 VGND VPWR sky130_fd_sc_hd__tapvpwrvgnd_1
XFILLER_41_95 VGND VGND VPWR VPWR sky130_fd_sc_hd__decap_3
XTAP_TAPCELL_ROW_71_1107 VGND VPWR sky130_fd_sc_hd__tapvpwrvgnd_1
XTAP_TAPCELL_ROW_9_361 VGND VPWR sky130_fd_sc_hd__tapvpwrvgnd_1
XFILLER_111_605 VGND VGND VPWR VPWR sky130_fd_sc_hd__decap_3
XFILLER_111_638 VGND VGND VPWR VPWR sky130_fd_sc_hd__decap_3
XFILLER_2_12 VGND VGND VPWR VPWR sky130_fd_sc_hd__decap_3
XFILLER_89_390 VGND VGND VPWR VPWR sky130_fd_sc_hd__fill_2
XFILLER_2_56 VGND VGND VPWR VPWR sky130_fd_sc_hd__decap_3
XFILLER_37_405 VGND VGND VPWR VPWR sky130_fd_sc_hd__decap_3
XFILLER_92_500 VGND VGND VPWR VPWR sky130_fd_sc_hd__decap_3
XFILLER_66_81 VGND VGND VPWR VPWR sky130_fd_sc_hd__decap_3
XFILLER_18_663 VGND VGND VPWR VPWR sky130_fd_sc_hd__decap_3
Xclkbuf_leaf_29_clk clkload5/A VGND VGND VPWR VPWR _6063_/CLK sky130_fd_sc_hd__clkbuf_8
XFILLER_64_279 VGND VGND VPWR VPWR sky130_fd_sc_hd__decap_3
X_4860_ _4894_/A1 _4875_/A2 _4875_/B1 _4860_/B2 VGND VGND VPWR VPWR _5894_/D sky130_fd_sc_hd__a22o_2
XTAP_TAPCELL_ROW_82_1236 VGND VPWR sky130_fd_sc_hd__tapvpwrvgnd_1
XFILLER_20_305 VGND VGND VPWR VPWR sky130_fd_sc_hd__decap_3
X_3811_ _3842_/A1 _3809_/X _3810_/X _3239_/Y VGND VGND VPWR VPWR _3811_/X sky130_fd_sc_hd__o22a_2
XANTENNA_17 _4811_/B VGND VGND VPWR VPWR sky130_fd_sc_hd__diode_2
XANTENNA_28 fanout822/X VGND VGND VPWR VPWR sky130_fd_sc_hd__diode_2
XANTENNA_39 _4912_/Y VGND VGND VPWR VPWR sky130_fd_sc_hd__diode_2
X_4791_ wire1003/X _4791_/B VGND VGND VPWR VPWR _5829_/D sky130_fd_sc_hd__and2b_2
X_3742_ _5934_/Q _5902_/Q _5870_/Q _5774_/Q _3744_/S _3742_/S1 VGND VGND VPWR VPWR
+ _3742_/X sky130_fd_sc_hd__mux4_2
XFILLER_9_372 VGND VGND VPWR VPWR sky130_fd_sc_hd__decap_3
X_3673_ _3670_/X _3672_/X _3916_/B1 VGND VGND VPWR VPWR _3673_/X sky130_fd_sc_hd__o21a_2
X_5412_ _5956_/CLK _5412_/D VGND VGND VPWR VPWR _5412_/Q sky130_fd_sc_hd__dfxtp_2
X_2624_ _2649_/A _2620_/X _2623_/X _3118_/B2 VGND VGND VPWR VPWR _2624_/X sky130_fd_sc_hd__o211a_2
Xoutput113 _3464_/X VGND VGND VPWR VPWR rd2[9] sky130_fd_sc_hd__clkbuf_2
Xoutput102 _3877_/X VGND VGND VPWR VPWR rd2[28] sky130_fd_sc_hd__buf_2
X_5343_ _5578_/CLK _5343_/D VGND VGND VPWR VPWR _5343_/Q sky130_fd_sc_hd__dfxtp_2
XFILLER_114_454 VGND VGND VPWR VPWR sky130_fd_sc_hd__decap_3
X_2555_ _3004_/B2 _2552_/X _2554_/X VGND VGND VPWR VPWR _2555_/Y sky130_fd_sc_hd__o21ai_2
XTAP_TAPCELL_ROW_93_1365 VGND VPWR sky130_fd_sc_hd__tapvpwrvgnd_1
X_5274_ _5658_/CLK _5274_/D VGND VGND VPWR VPWR _5274_/Q sky130_fd_sc_hd__dfxtp_2
X_4225_ _4773_/A1 wire489/X wire269/X _4225_/B2 VGND VGND VPWR VPWR _5299_/D sky130_fd_sc_hd__a22o_2
XFILLER_110_660 VGND VGND VPWR VPWR sky130_fd_sc_hd__decap_3
X_4156_ _5043_/A1 _4158_/A2 _4158_/B1 _4156_/B2 VGND VGND VPWR VPWR _5235_/D sky130_fd_sc_hd__a22o_2
X_3107_ _5714_/Q _5682_/Q _5650_/Q _5618_/Q _3110_/S _3107_/S1 VGND VGND VPWR VPWR
+ _3108_/B sky130_fd_sc_hd__mux4_2
X_4087_ _5009_/A1 _4089_/A2 _4089_/B1 _4087_/B2 VGND VGND VPWR VPWR _5171_/D sky130_fd_sc_hd__a22o_2
XFILLER_102_13 VGND VGND VPWR VPWR sky130_fd_sc_hd__decap_3
XFILLER_83_588 VGND VGND VPWR VPWR sky130_fd_sc_hd__decap_3
X_3038_ _5423_/Q _5071_/Q _3038_/S VGND VGND VPWR VPWR _3038_/X sky130_fd_sc_hd__mux2_1
XFILLER_24_622 VGND VGND VPWR VPWR sky130_fd_sc_hd__fill_2
XFILLER_51_430 VGND VGND VPWR VPWR sky130_fd_sc_hd__fill_1
XFILLER_62_17 VGND VGND VPWR VPWR sky130_fd_sc_hd__fill_2
XTAP_TAPCELL_ROW_34_661 VGND VPWR sky130_fd_sc_hd__tapvpwrvgnd_1
XTAP_TAPCELL_ROW_102_1472 VGND VPWR sky130_fd_sc_hd__tapvpwrvgnd_1
XTAP_TAPCELL_ROW_62_992 VGND VPWR sky130_fd_sc_hd__tapvpwrvgnd_1
X_4989_ _4989_/A1 _5013_/A2 _5013_/B1 _4989_/B2 VGND VGND VPWR VPWR _6015_/D sky130_fd_sc_hd__a22o_2
XFILLER_105_421 VGND VGND VPWR VPWR sky130_fd_sc_hd__decap_3
XFILLER_105_465 VGND VGND VPWR VPWR sky130_fd_sc_hd__decap_3
XTAP_TAPCELL_ROW_6_320 VGND VPWR sky130_fd_sc_hd__tapvpwrvgnd_1
Xfanout340 _4980_/Y VGND VGND VPWR VPWR _5012_/A2 sky130_fd_sc_hd__clkdlybuf4s25_1
Xfanout373 _4810_/Y VGND VGND VPWR VPWR _4811_/B sky130_fd_sc_hd__clkdlybuf4s25_1
Xfanout351 _4912_/Y VGND VGND VPWR VPWR _4943_/A2 sky130_fd_sc_hd__clkdlybuf4s25_1
XFILLER_100_170 VGND VGND VPWR VPWR sky130_fd_sc_hd__decap_3
XFILLER_46_224 VGND VGND VPWR VPWR sky130_fd_sc_hd__decap_3
XFILLER_74_533 VGND VGND VPWR VPWR sky130_fd_sc_hd__decap_3
XFILLER_86_393 VGND VGND VPWR VPWR sky130_fd_sc_hd__fill_1
Xfanout395 fanout397/A VGND VGND VPWR VPWR _4693_/A2 sky130_fd_sc_hd__clkdlybuf4s25_1
XFILLER_100_192 VGND VGND VPWR VPWR sky130_fd_sc_hd__decap_3
XFILLER_15_600 VGND VGND VPWR VPWR sky130_fd_sc_hd__decap_3
XFILLER_14_121 VGND VGND VPWR VPWR sky130_fd_sc_hd__decap_3
XFILLER_15_633 VGND VGND VPWR VPWR sky130_fd_sc_hd__decap_3
XFILLER_10_371 VGND VGND VPWR VPWR sky130_fd_sc_hd__fill_2
Xinput15 rs2[4] VGND VGND VPWR VPWR input15/X sky130_fd_sc_hd__clkdlybuf4s25_1
Xinput26 wd[18] VGND VGND VPWR VPWR input26/X sky130_fd_sc_hd__clkdlybuf4s25_1
Xinput37 wd[28] VGND VGND VPWR VPWR input37/X sky130_fd_sc_hd__clkdlybuf4s25_1
XFILLER_6_353 VGND VGND VPWR VPWR sky130_fd_sc_hd__decap_3
XTAP_TAPCELL_ROW_12_388 VGND VPWR sky130_fd_sc_hd__tapvpwrvgnd_1
XTAP_TAPCELL_ROW_12_399 VGND VPWR sky130_fd_sc_hd__tapvpwrvgnd_1
Xinput48 wd[9] VGND VGND VPWR VPWR input48/X sky130_fd_sc_hd__clkdlybuf4s25_1
XFILLER_6_397 VGND VGND VPWR VPWR sky130_fd_sc_hd__decap_3
Xload_slew702 _3335_/A1 VGND VGND VPWR VPWR _3626_/A sky130_fd_sc_hd__clkbuf_4
XFILLER_2_570 VGND VGND VPWR VPWR sky130_fd_sc_hd__decap_3
XFILLER_2_592 VGND VGND VPWR VPWR sky130_fd_sc_hd__decap_3
Xload_slew735 _3042_/A VGND VGND VPWR VPWR _3198_/A sky130_fd_sc_hd__clkbuf_4
XFILLER_111_468 VGND VGND VPWR VPWR sky130_fd_sc_hd__fill_1
X_4010_ _5037_/A1 _4015_/A2 _4015_/B1 _4010_/B2 VGND VGND VPWR VPWR _5101_/D sky130_fd_sc_hd__a22o_2
XFILLER_65_511 VGND VGND VPWR VPWR sky130_fd_sc_hd__decap_3
XFILLER_65_522 VGND VGND VPWR VPWR sky130_fd_sc_hd__decap_3
XFILLER_37_279 VGND VGND VPWR VPWR sky130_fd_sc_hd__fill_1
XFILLER_65_588 VGND VGND VPWR VPWR sky130_fd_sc_hd__decap_3
XFILLER_92_363 VGND VGND VPWR VPWR sky130_fd_sc_hd__fill_1
X_5961_ clkload9/A _5961_/D VGND VGND VPWR VPWR _5961_/Q sky130_fd_sc_hd__dfxtp_2
XFILLER_18_493 VGND VGND VPWR VPWR sky130_fd_sc_hd__fill_1
XFILLER_80_536 VGND VGND VPWR VPWR sky130_fd_sc_hd__fill_2
X_4912_ _4946_/B _5014_/B VGND VGND VPWR VPWR _4912_/Y sky130_fd_sc_hd__nor2_2
XFILLER_80_569 VGND VGND VPWR VPWR sky130_fd_sc_hd__decap_3
X_5892_ _6052_/CLK _5892_/D VGND VGND VPWR VPWR _5892_/Q sky130_fd_sc_hd__dfxtp_2
XFILLER_21_636 VGND VGND VPWR VPWR sky130_fd_sc_hd__decap_3
XFILLER_33_485 VGND VGND VPWR VPWR sky130_fd_sc_hd__decap_3
XTAP_TAPCELL_ROW_31_620 VGND VPWR sky130_fd_sc_hd__tapvpwrvgnd_1
X_4843_ _4843_/A1 wire376/X _4843_/B1 _4843_/B2 VGND VGND VPWR VPWR _5879_/D sky130_fd_sc_hd__a22o_2
X_4774_ _4908_/A1 _4776_/A2 _4776_/B1 _4774_/B2 VGND VGND VPWR VPWR _5812_/D sky130_fd_sc_hd__a22o_2
X_3725_ _3714_/X _3723_/X _3724_/X _3614_/A VGND VGND VPWR VPWR _3725_/X sky130_fd_sc_hd__o31a_2
XFILLER_9_180 VGND VGND VPWR VPWR sky130_fd_sc_hd__fill_1
Xclkbuf_leaf_9_clk clkload1/A VGND VGND VPWR VPWR _5513_/CLK sky130_fd_sc_hd__clkbuf_8
X_3656_ _3454_/A _3652_/X _3655_/X _3939_/A1 VGND VGND VPWR VPWR _3656_/X sky130_fd_sc_hd__o211a_2
X_3587_ _3694_/A _3585_/X _3586_/X _3695_/A1 VGND VGND VPWR VPWR _3587_/X sky130_fd_sc_hd__o22a_2
X_2607_ _2904_/A1 _2605_/X _2606_/X _2516_/B VGND VGND VPWR VPWR _2608_/C sky130_fd_sc_hd__o211a_2
X_5326_ _6062_/CLK _5326_/D VGND VGND VPWR VPWR _5326_/Q sky130_fd_sc_hd__dfxtp_2
X_2538_ _5689_/Q _5657_/Q _5625_/Q _5593_/Q _2908_/S _2911_/S1 VGND VGND VPWR VPWR
+ _2539_/B sky130_fd_sc_hd__mux4_2
XFILLER_102_446 VGND VGND VPWR VPWR sky130_fd_sc_hd__decap_3
XFILLER_87_113 VGND VGND VPWR VPWR sky130_fd_sc_hd__decap_3
X_5257_ _6012_/CLK _5257_/D VGND VGND VPWR VPWR _5257_/Q sky130_fd_sc_hd__dfxtp_2
XFILLER_75_308 VGND VGND VPWR VPWR sky130_fd_sc_hd__fill_2
X_4208_ _4822_/A1 _4224_/A2 _4227_/B1 _4208_/B2 VGND VGND VPWR VPWR _5282_/D sky130_fd_sc_hd__a22o_2
XFILLER_68_382 VGND VGND VPWR VPWR sky130_fd_sc_hd__decap_3
XTAP_TAPCELL_ROW_39_720 VGND VPWR sky130_fd_sc_hd__tapvpwrvgnd_1
X_5188_ _6038_/CLK _5188_/D VGND VGND VPWR VPWR _5188_/Q sky130_fd_sc_hd__dfxtp_2
XFILLER_113_34 VGND VGND VPWR VPWR sky130_fd_sc_hd__decap_3
XFILLER_56_533 VGND VGND VPWR VPWR sky130_fd_sc_hd__fill_2
XFILLER_56_544 VGND VGND VPWR VPWR sky130_fd_sc_hd__fill_2
X_4139_ _4653_/A1 wire508/X wire290/X _4139_/B2 VGND VGND VPWR VPWR _5218_/D sky130_fd_sc_hd__a22o_2
XFILLER_113_78 VGND VGND VPWR VPWR sky130_fd_sc_hd__decap_3
XFILLER_16_419 VGND VGND VPWR VPWR sky130_fd_sc_hd__fill_1
XFILLER_56_577 VGND VGND VPWR VPWR sky130_fd_sc_hd__decap_3
XFILLER_71_503 VGND VGND VPWR VPWR sky130_fd_sc_hd__fill_1
XFILLER_71_558 VGND VGND VPWR VPWR sky130_fd_sc_hd__fill_2
XTAP_TAPCELL_ROW_104_1501 VGND VPWR sky130_fd_sc_hd__tapvpwrvgnd_1
XFILLER_24_441 VGND VGND VPWR VPWR sky130_fd_sc_hd__fill_1
XFILLER_8_629 VGND VGND VPWR VPWR sky130_fd_sc_hd__decap_3
XFILLER_22_97 VGND VGND VPWR VPWR sky130_fd_sc_hd__decap_3
XFILLER_98_24 VGND VGND VPWR VPWR sky130_fd_sc_hd__decap_3
XTAP_TAPCELL_ROW_115_1630 VGND VPWR sky130_fd_sc_hd__tapvpwrvgnd_1
XTAP_TAPCELL_ROW_115_1641 VGND VPWR sky130_fd_sc_hd__tapvpwrvgnd_1
XFILLER_105_295 VGND VGND VPWR VPWR sky130_fd_sc_hd__decap_3
XFILLER_78_113 VGND VGND VPWR VPWR sky130_fd_sc_hd__decap_3
XFILLER_78_124 VGND VGND VPWR VPWR sky130_fd_sc_hd__fill_2
XFILLER_78_135 VGND VGND VPWR VPWR sky130_fd_sc_hd__decap_3
Xfanout1102 _3908_/S VGND VGND VPWR VPWR _3779_/S sky130_fd_sc_hd__clkdlybuf4s25_1
XFILLER_78_168 VGND VGND VPWR VPWR sky130_fd_sc_hd__decap_3
Xfanout1135 input11/X VGND VGND VPWR VPWR _3689_/S sky130_fd_sc_hd__buf_4
Xfanout1124 _3683_/S VGND VGND VPWR VPWR _3398_/S sky130_fd_sc_hd__clkbuf_2
XFILLER_93_116 VGND VGND VPWR VPWR sky130_fd_sc_hd__fill_2
Xfanout192 _4574_/Y VGND VGND VPWR VPWR wire193/A sky130_fd_sc_hd__clkdlybuf4s25_1
Xfanout181 _4642_/Y VGND VGND VPWR VPWR _4659_/B1 sky130_fd_sc_hd__clkdlybuf4s25_1
Xfanout170 _4711_/Y VGND VGND VPWR VPWR wire171/A sky130_fd_sc_hd__clkdlybuf4s25_1
XFILLER_19_268 VGND VGND VPWR VPWR sky130_fd_sc_hd__decap_3
XFILLER_74_352 VGND VGND VPWR VPWR sky130_fd_sc_hd__fill_1
XFILLER_74_374 VGND VGND VPWR VPWR sky130_fd_sc_hd__decap_3
XTAP_TAPCELL_ROW_66_1039 VGND VPWR sky130_fd_sc_hd__tapvpwrvgnd_1
XFILLER_15_452 VGND VGND VPWR VPWR sky130_fd_sc_hd__decap_3
XFILLER_63_60 VGND VGND VPWR VPWR sky130_fd_sc_hd__fill_2
XTAP_TAPCELL_ROW_17_458 VGND VPWR sky130_fd_sc_hd__tapvpwrvgnd_1
XFILLER_30_400 VGND VGND VPWR VPWR sky130_fd_sc_hd__decap_3
XTAP_TAPCELL_ROW_45_789 VGND VPWR sky130_fd_sc_hd__tapvpwrvgnd_1
XFILLER_30_433 VGND VGND VPWR VPWR sky130_fd_sc_hd__decap_3
XFILLER_8_44 VGND VGND VPWR VPWR sky130_fd_sc_hd__decap_3
XPHY_EDGE_ROW_7_Left_123 VGND VGND VPWR VPWR sky130_fd_sc_hd__decap_3
XFILLER_8_99 VGND VGND VPWR VPWR sky130_fd_sc_hd__decap_3
X_3510_ _3791_/B2 _3507_/X _3509_/X VGND VGND VPWR VPWR _3510_/X sky130_fd_sc_hd__a21o_2
XFILLER_7_673 VGND VGND VPWR VPWR sky130_fd_sc_hd__decap_3
X_4490_ _4830_/A1 _4503_/A2 _4503_/B1 _4490_/B2 VGND VGND VPWR VPWR _5546_/D sky130_fd_sc_hd__a22o_2
XTAP_TAPCELL_ROW_77_1168 VGND VPWR sky130_fd_sc_hd__tapvpwrvgnd_1
XTAP_TAPCELL_ROW_77_1179 VGND VPWR sky130_fd_sc_hd__tapvpwrvgnd_1
X_3441_ _3430_/X _3440_/X _3855_/B1 VGND VGND VPWR VPWR _3441_/X sky130_fd_sc_hd__o21a_2
XFILLER_40_3 VGND VGND VPWR VPWR sky130_fd_sc_hd__decap_3
X_3372_ _3614_/A _3372_/B _3372_/C VGND VGND VPWR VPWR _3372_/X sky130_fd_sc_hd__and3_2
XTAP_TAPCELL_ROW_90_1324 VGND VPWR sky130_fd_sc_hd__tapvpwrvgnd_1
XFILLER_97_444 VGND VGND VPWR VPWR sky130_fd_sc_hd__decap_3
Xhold2008 _5438_/Q VGND VGND VPWR VPWR _4375_/B2 sky130_fd_sc_hd__dlygate4sd3_1
Xload_slew510 fanout509/X VGND VGND VPWR VPWR _4155_/A2 sky130_fd_sc_hd__clkbuf_4
X_5111_ _6055_/CLK _5111_/D VGND VGND VPWR VPWR _5111_/Q sky130_fd_sc_hd__dfxtp_2
XTAP_TAPCELL_ROW_90_1335 VGND VPWR sky130_fd_sc_hd__tapvpwrvgnd_1
Xhold1307 _5624_/Q VGND VGND VPWR VPWR _4575_/B2 sky130_fd_sc_hd__dlygate4sd3_1
Xhold2019 _5384_/Q VGND VGND VPWR VPWR _4316_/B2 sky130_fd_sc_hd__dlygate4sd3_1
XFILLER_38_522 VGND VGND VPWR VPWR sky130_fd_sc_hd__fill_1
XFILLER_84_105 VGND VGND VPWR VPWR sky130_fd_sc_hd__decap_3
XFILLER_85_628 VGND VGND VPWR VPWR sky130_fd_sc_hd__decap_3
XFILLER_97_488 VGND VGND VPWR VPWR sky130_fd_sc_hd__decap_3
Xhold1318 _5097_/Q VGND VGND VPWR VPWR _4006_/B2 sky130_fd_sc_hd__dlygate4sd3_1
Xhold1329 _5587_/Q VGND VGND VPWR VPWR _4533_/B2 sky130_fd_sc_hd__dlygate4sd3_1
Xload_slew587 _3308_/A1 VGND VGND VPWR VPWR _3713_/B2 sky130_fd_sc_hd__buf_4
X_5042_ _5042_/A1 _5045_/A2 _5045_/B1 _5042_/B2 VGND VGND VPWR VPWR _6066_/D sky130_fd_sc_hd__a22o_2
XFILLER_92_171 VGND VGND VPWR VPWR sky130_fd_sc_hd__decap_3
X_5944_ _6040_/CLK _5944_/D VGND VGND VPWR VPWR _5944_/Q sky130_fd_sc_hd__dfxtp_2
XFILLER_80_399 VGND VGND VPWR VPWR sky130_fd_sc_hd__decap_3
X_5875_ _6067_/CLK _5875_/D VGND VGND VPWR VPWR _5875_/Q sky130_fd_sc_hd__dfxtp_2
XFILLER_21_433 VGND VGND VPWR VPWR sky130_fd_sc_hd__decap_3
X_4826_ _4894_/A1 _4841_/A2 _4841_/B1 _4826_/B2 VGND VGND VPWR VPWR _5862_/D sky130_fd_sc_hd__a22o_2
X_4757_ _4891_/A1 _4775_/A2 _4768_/B1 _4757_/B2 VGND VGND VPWR VPWR _5795_/D sky130_fd_sc_hd__a22o_2
XFILLER_107_505 VGND VGND VPWR VPWR sky130_fd_sc_hd__decap_3
XFILLER_111_9 VGND VGND VPWR VPWR sky130_fd_sc_hd__decap_3
X_4688_ _4891_/A1 _4706_/A2 _4699_/B1 _4688_/B2 VGND VGND VPWR VPWR _5731_/D sky130_fd_sc_hd__a22o_2
X_3708_ _3708_/A1 _3705_/X _3707_/X _3881_/B2 VGND VGND VPWR VPWR _3708_/X sky130_fd_sc_hd__a22o_2
XFILLER_108_12 VGND VGND VPWR VPWR sky130_fd_sc_hd__decap_3
X_3639_ _5194_/Q _5162_/Q _3943_/S VGND VGND VPWR VPWR _3639_/X sky130_fd_sc_hd__mux2_1
XFILLER_108_56 VGND VGND VPWR VPWR sky130_fd_sc_hd__decap_3
XFILLER_115_571 VGND VGND VPWR VPWR sky130_fd_sc_hd__decap_3
X_5309_ _5922_/CLK _5309_/D VGND VGND VPWR VPWR _5309_/Q sky130_fd_sc_hd__dfxtp_2
XFILLER_102_243 VGND VGND VPWR VPWR sky130_fd_sc_hd__fill_1
XFILLER_88_477 VGND VGND VPWR VPWR sky130_fd_sc_hd__fill_1
XFILLER_76_639 VGND VGND VPWR VPWR sky130_fd_sc_hd__decap_3
XTAP_TAPCELL_ROW_110_1571 VGND VPWR sky130_fd_sc_hd__tapvpwrvgnd_1
XFILLER_29_533 VGND VGND VPWR VPWR sky130_fd_sc_hd__decap_3
XFILLER_91_609 VGND VGND VPWR VPWR sky130_fd_sc_hd__decap_3
Xhold1830 _5558_/Q VGND VGND VPWR VPWR _4502_/B2 sky130_fd_sc_hd__dlygate4sd3_1
Xhold1841 _6058_/Q VGND VGND VPWR VPWR _5034_/B2 sky130_fd_sc_hd__dlygate4sd3_1
Xhold1852 _5145_/Q VGND VGND VPWR VPWR _4061_/B2 sky130_fd_sc_hd__dlygate4sd3_1
Xhold1863 _5442_/Q VGND VGND VPWR VPWR _4379_/B2 sky130_fd_sc_hd__dlygate4sd3_1
XFILLER_56_374 VGND VGND VPWR VPWR sky130_fd_sc_hd__decap_3
Xhold1874 _5165_/Q VGND VGND VPWR VPWR _4081_/B2 sky130_fd_sc_hd__dlygate4sd3_1
Xhold1885 _5458_/Q VGND VGND VPWR VPWR _4395_/B2 sky130_fd_sc_hd__dlygate4sd3_1
Xhold1896 _5091_/Q VGND VGND VPWR VPWR _4000_/B2 sky130_fd_sc_hd__dlygate4sd3_1
XFILLER_17_53 VGND VGND VPWR VPWR sky130_fd_sc_hd__decap_3
XFILLER_29_599 VGND VGND VPWR VPWR sky130_fd_sc_hd__fill_1
XFILLER_44_547 VGND VGND VPWR VPWR sky130_fd_sc_hd__decap_3
XTAP_TAPCELL_ROW_14_417 VGND VPWR sky130_fd_sc_hd__tapvpwrvgnd_1
XFILLER_8_404 VGND VGND VPWR VPWR sky130_fd_sc_hd__decap_3
XTAP_TAPCELL_ROW_42_748 VGND VPWR sky130_fd_sc_hd__tapvpwrvgnd_1
XTAP_TAPCELL_ROW_42_759 VGND VPWR sky130_fd_sc_hd__tapvpwrvgnd_1
XFILLER_4_632 VGND VGND VPWR VPWR sky130_fd_sc_hd__decap_3
XFILLER_4_654 VGND VGND VPWR VPWR sky130_fd_sc_hd__decap_3
XFILLER_58_82 VGND VGND VPWR VPWR sky130_fd_sc_hd__fill_2
XFILLER_81_119 VGND VGND VPWR VPWR sky130_fd_sc_hd__fill_1
XFILLER_74_193 VGND VGND VPWR VPWR sky130_fd_sc_hd__decap_3
XFILLER_90_620 VGND VGND VPWR VPWR sky130_fd_sc_hd__fill_2
XFILLER_35_558 VGND VGND VPWR VPWR sky130_fd_sc_hd__fill_2
XFILLER_74_81 VGND VGND VPWR VPWR sky130_fd_sc_hd__decap_3
X_3990_ _4507_/A1 _4018_/A2 _4018_/B1 _3990_/B2 VGND VGND VPWR VPWR _5081_/D sky130_fd_sc_hd__a22o_2
X_2941_ _5835_/Q _5451_/Q _3060_/S VGND VGND VPWR VPWR _2941_/X sky130_fd_sc_hd__mux2_1
X_5660_ _5692_/CLK _5660_/D VGND VGND VPWR VPWR _5660_/Q sky130_fd_sc_hd__dfxtp_2
XFILLER_30_241 VGND VGND VPWR VPWR sky130_fd_sc_hd__decap_3
X_4611_ _4645_/A1 _4625_/A2 _4625_/B1 _4611_/B2 VGND VGND VPWR VPWR _5658_/D sky130_fd_sc_hd__a22o_2
X_2872_ _5704_/Q _5672_/Q _5640_/Q _5608_/Q _2889_/S _3113_/S1 VGND VGND VPWR VPWR
+ _2872_/X sky130_fd_sc_hd__mux4_2
X_5591_ _5879_/CLK _5591_/D VGND VGND VPWR VPWR _5591_/Q sky130_fd_sc_hd__dfxtp_2
X_4542_ _5017_/A1 wire421/X _4570_/B1 _4542_/B2 VGND VGND VPWR VPWR _5593_/D sky130_fd_sc_hd__a22o_2
X_4473_ _4507_/A1 _4501_/A2 _4501_/B1 _4473_/B2 VGND VGND VPWR VPWR _5529_/D sky130_fd_sc_hd__a22o_2
XFILLER_89_219 VGND VGND VPWR VPWR sky130_fd_sc_hd__decap_3
X_3424_ _3502_/A1 _3422_/X _3423_/X _3611_/B2 _3421_/X VGND VGND VPWR VPWR _3424_/X
+ sky130_fd_sc_hd__o221a_2
XPHY_EDGE_ROW_115_Right_115 VGND VGND VPWR VPWR sky130_fd_sc_hd__decap_3
Xfanout906 input38/X VGND VGND VPWR VPWR _5045_/A1 sky130_fd_sc_hd__clkdlybuf4s25_1
Xfanout939 input30/X VGND VGND VPWR VPWR _4527_/A1 sky130_fd_sc_hd__clkdlybuf4s25_1
Xfanout928 input33/X VGND VGND VPWR VPWR _4530_/A1 sky130_fd_sc_hd__clkdlybuf4s25_1
Xfanout917 _4601_/A1 VGND VGND VPWR VPWR _4738_/A1 sky130_fd_sc_hd__clkdlybuf4s25_1
X_3355_ _3470_/S _3352_/X _3354_/X _3831_/B2 VGND VGND VPWR VPWR _3355_/X sky130_fd_sc_hd__o22a_2
Xload_slew362 _4904_/A2 VGND VGND VPWR VPWR _4910_/A2 sky130_fd_sc_hd__buf_4
X_3286_ wire628/X _3282_/X _3285_/X _3843_/C1 _3269_/X VGND VGND VPWR VPWR _3286_/X
+ sky130_fd_sc_hd__a32o_2
Xhold1148 _5597_/Q VGND VGND VPWR VPWR _4546_/B2 sky130_fd_sc_hd__dlygate4sd3_1
X_5025_ _5025_/A1 wire332/X wire118/A _5025_/B2 VGND VGND VPWR VPWR _6049_/D sky130_fd_sc_hd__a22o_2
XFILLER_66_672 VGND VGND VPWR VPWR sky130_fd_sc_hd__decap_3
Xhold1159 _6029_/Q VGND VGND VPWR VPWR _5003_/B2 sky130_fd_sc_hd__dlygate4sd3_1
XFILLER_26_547 VGND VGND VPWR VPWR sky130_fd_sc_hd__fill_1
XFILLER_81_642 VGND VGND VPWR VPWR sky130_fd_sc_hd__fill_2
XFILLER_80_141 VGND VGND VPWR VPWR sky130_fd_sc_hd__fill_2
XFILLER_110_24 VGND VGND VPWR VPWR sky130_fd_sc_hd__decap_3
XFILLER_110_35 VGND VGND VPWR VPWR sky130_fd_sc_hd__decap_3
X_5927_ _6055_/CLK _5927_/D VGND VGND VPWR VPWR _5927_/Q sky130_fd_sc_hd__dfxtp_2
XFILLER_110_68 VGND VGND VPWR VPWR sky130_fd_sc_hd__decap_3
X_5858_ _5922_/CLK _5858_/D VGND VGND VPWR VPWR _5858_/Q sky130_fd_sc_hd__dfxtp_2
XPHY_EDGE_ROW_17_Right_17 VGND VGND VPWR VPWR sky130_fd_sc_hd__decap_3
X_5789_ _5794_/CLK _5789_/D VGND VGND VPWR VPWR _5789_/Q sky130_fd_sc_hd__dfxtp_2
X_4809_ wire1003/X _4809_/B VGND VGND VPWR VPWR _5847_/D sky130_fd_sc_hd__and2b_2
XFILLER_107_324 VGND VGND VPWR VPWR sky130_fd_sc_hd__decap_3
XFILLER_1_602 VGND VGND VPWR VPWR sky130_fd_sc_hd__decap_3
XFILLER_79_48 VGND VGND VPWR VPWR sky130_fd_sc_hd__decap_3
XFILLER_1_635 VGND VGND VPWR VPWR sky130_fd_sc_hd__decap_3
XFILLER_1_668 VGND VGND VPWR VPWR sky130_fd_sc_hd__decap_3
XFILLER_0_178 VGND VGND VPWR VPWR sky130_fd_sc_hd__fill_2
XFILLER_1_679 VGND VGND VPWR VPWR sky130_fd_sc_hd__decap_3
XFILLER_48_116 VGND VGND VPWR VPWR sky130_fd_sc_hd__decap_3
XFILLER_49_628 VGND VGND VPWR VPWR sky130_fd_sc_hd__decap_3
XPHY_EDGE_ROW_26_Right_26 VGND VGND VPWR VPWR sky130_fd_sc_hd__decap_3
XFILLER_103_596 VGND VGND VPWR VPWR sky130_fd_sc_hd__decap_3
XFILLER_48_149 VGND VGND VPWR VPWR sky130_fd_sc_hd__decap_3
XFILLER_28_63 VGND VGND VPWR VPWR sky130_fd_sc_hd__decap_3
XTAP_TAPCELL_ROW_47_818 VGND VPWR sky130_fd_sc_hd__tapvpwrvgnd_1
Xhold1660 _5527_/Q VGND VGND VPWR VPWR _4469_/B2 sky130_fd_sc_hd__dlygate4sd3_1
Xhold1671 _6030_/Q VGND VGND VPWR VPWR _5004_/B2 sky130_fd_sc_hd__dlygate4sd3_1
XFILLER_28_85 VGND VGND VPWR VPWR sky130_fd_sc_hd__decap_3
XFILLER_57_683 VGND VGND VPWR VPWR sky130_fd_sc_hd__decap_3
XFILLER_84_480 VGND VGND VPWR VPWR sky130_fd_sc_hd__decap_3
Xhold1682 _5387_/Q VGND VGND VPWR VPWR _4319_/B2 sky130_fd_sc_hd__dlygate4sd3_1
Xhold1693 _5111_/Q VGND VGND VPWR VPWR _4020_/B2 sky130_fd_sc_hd__dlygate4sd3_1
XFILLER_17_558 VGND VGND VPWR VPWR sky130_fd_sc_hd__fill_2
XFILLER_32_506 VGND VGND VPWR VPWR sky130_fd_sc_hd__decap_3
XPHY_EDGE_ROW_88_Left_204 VGND VGND VPWR VPWR sky130_fd_sc_hd__decap_3
XFILLER_44_51 VGND VGND VPWR VPWR sky130_fd_sc_hd__decap_3
XFILLER_71_152 VGND VGND VPWR VPWR sky130_fd_sc_hd__decap_3
XTAP_TAPCELL_ROW_27_575 VGND VPWR sky130_fd_sc_hd__tapvpwrvgnd_1
XTAP_TAPCELL_ROW_63_1009 VGND VPWR sky130_fd_sc_hd__tapvpwrvgnd_1
XFILLER_40_561 VGND VGND VPWR VPWR sky130_fd_sc_hd__fill_1
XPHY_EDGE_ROW_35_Right_35 VGND VGND VPWR VPWR sky130_fd_sc_hd__decap_3
XFILLER_40_594 VGND VGND VPWR VPWR sky130_fd_sc_hd__decap_3
XFILLER_8_234 VGND VGND VPWR VPWR sky130_fd_sc_hd__decap_3
XFILLER_5_12 VGND VGND VPWR VPWR sky130_fd_sc_hd__decap_3
XPHY_EDGE_ROW_97_Left_213 VGND VGND VPWR VPWR sky130_fd_sc_hd__decap_3
XFILLER_5_45 VGND VGND VPWR VPWR sky130_fd_sc_hd__decap_3
XTAP_TAPCELL_ROW_74_1138 VGND VPWR sky130_fd_sc_hd__tapvpwrvgnd_1
XPHY_EDGE_ROW_44_Right_44 VGND VGND VPWR VPWR sky130_fd_sc_hd__decap_3
XFILLER_39_116 VGND VGND VPWR VPWR sky130_fd_sc_hd__decap_3
XFILLER_67_403 VGND VGND VPWR VPWR sky130_fd_sc_hd__fill_1
XFILLER_94_200 VGND VGND VPWR VPWR sky130_fd_sc_hd__decap_3
X_3140_ wire693/X _3137_/X _3139_/X VGND VGND VPWR VPWR _3140_/X sky130_fd_sc_hd__a21o_2
X_3071_ _3044_/A _3068_/X _3070_/X _3071_/B2 VGND VGND VPWR VPWR _3071_/X sky130_fd_sc_hd__a22o_2
XFILLER_75_491 VGND VGND VPWR VPWR sky130_fd_sc_hd__decap_3
XFILLER_62_130 VGND VGND VPWR VPWR sky130_fd_sc_hd__decap_3
XFILLER_63_642 VGND VGND VPWR VPWR sky130_fd_sc_hd__decap_3
XFILLER_23_539 VGND VGND VPWR VPWR sky130_fd_sc_hd__decap_3
XFILLER_62_152 VGND VGND VPWR VPWR sky130_fd_sc_hd__fill_1
XTAP_TAPCELL_ROW_85_1267 VGND VPWR sky130_fd_sc_hd__tapvpwrvgnd_1
XPHY_EDGE_ROW_53_Right_53 VGND VGND VPWR VPWR sky130_fd_sc_hd__decap_3
X_5712_ _6064_/CLK _5712_/D VGND VGND VPWR VPWR _5712_/Q sky130_fd_sc_hd__dfxtp_2
X_3973_ _4527_/A1 wire546/X wire325/X _3973_/B2 VGND VGND VPWR VPWR _5069_/D sky130_fd_sc_hd__a22o_2
XFILLER_31_561 VGND VGND VPWR VPWR sky130_fd_sc_hd__decap_3
X_2924_ _5802_/Q _5738_/Q _2924_/S VGND VGND VPWR VPWR _2924_/X sky130_fd_sc_hd__mux2_1
X_5643_ _5867_/CLK _5643_/D VGND VGND VPWR VPWR _5643_/Q sky130_fd_sc_hd__dfxtp_2
X_2855_ _5383_/Q _5351_/Q _5319_/Q _5287_/Q _2856_/S _2503_/B VGND VGND VPWR VPWR
+ _2855_/X sky130_fd_sc_hd__mux4_2
X_5574_ _5790_/CLK _5574_/D VGND VGND VPWR VPWR _5574_/Q sky130_fd_sc_hd__dfxtp_2
X_4525_ _4525_/A1 _4505_/B _4530_/B1 _4525_/B2 VGND VGND VPWR VPWR _5579_/D sky130_fd_sc_hd__a22o_2
X_2786_ _3147_/A1 _2783_/X _2785_/X VGND VGND VPWR VPWR _2786_/X sky130_fd_sc_hd__a21o_2
XPHY_EDGE_ROW_62_Right_62 VGND VGND VPWR VPWR sky130_fd_sc_hd__decap_3
X_4456_ _4830_/A1 _4469_/A2 _4469_/B1 _4456_/B2 VGND VGND VPWR VPWR _5514_/D sky130_fd_sc_hd__a22o_2
XTAP_TAPCELL_ROW_96_1396 VGND VPWR sky130_fd_sc_hd__tapvpwrvgnd_1
Xfanout714 _2494_/Y VGND VGND VPWR VPWR _3906_/A sky130_fd_sc_hd__clkdlybuf4s25_1
Xfanout703 _3496_/A VGND VGND VPWR VPWR _3889_/A sky130_fd_sc_hd__clkdlybuf4s25_1
X_4387_ _5034_/A1 wire459/X _4400_/B1 _4387_/B2 VGND VGND VPWR VPWR _5450_/D sky130_fd_sc_hd__a22o_2
X_3407_ _5919_/Q _5887_/Q _5855_/Q _5759_/Q _3397_/S _3799_/S1 VGND VGND VPWR VPWR
+ _3408_/B sky130_fd_sc_hd__mux4_2
XFILLER_105_24 VGND VGND VPWR VPWR sky130_fd_sc_hd__decap_3
XFILLER_98_583 VGND VGND VPWR VPWR sky130_fd_sc_hd__decap_3
Xfanout747 input8/X VGND VGND VPWR VPWR _3044_/A sky130_fd_sc_hd__clkdlybuf4s25_1
X_3338_ _5404_/Q _5052_/Q _3339_/S VGND VGND VPWR VPWR _3338_/X sky130_fd_sc_hd__mux2_1
XFILLER_100_533 VGND VGND VPWR VPWR sky130_fd_sc_hd__decap_3
XFILLER_105_57 VGND VGND VPWR VPWR sky130_fd_sc_hd__decap_3
XFILLER_112_382 VGND VGND VPWR VPWR sky130_fd_sc_hd__decap_3
XFILLER_100_577 VGND VGND VPWR VPWR sky130_fd_sc_hd__decap_3
X_6057_ clkload9/A _6057_/D VGND VGND VPWR VPWR _6057_/Q sky130_fd_sc_hd__dfxtp_2
X_3269_ _3745_/B2 _3266_/X _3268_/X VGND VGND VPWR VPWR _3269_/X sky130_fd_sc_hd__a21o_2
X_5008_ _5008_/A1 _5008_/A2 _5008_/B1 _5008_/B2 VGND VGND VPWR VPWR _6034_/D sky130_fd_sc_hd__a22o_2
XFILLER_53_141 VGND VGND VPWR VPWR sky130_fd_sc_hd__fill_1
XFILLER_14_539 VGND VGND VPWR VPWR sky130_fd_sc_hd__decap_3
XPHY_EDGE_ROW_71_Right_71 VGND VGND VPWR VPWR sky130_fd_sc_hd__decap_3
XTAP_TAPCELL_ROW_24_534 VGND VPWR sky130_fd_sc_hd__tapvpwrvgnd_1
XFILLER_14_32 VGND VGND VPWR VPWR sky130_fd_sc_hd__fill_1
XFILLER_22_561 VGND VGND VPWR VPWR sky130_fd_sc_hd__decap_3
XTAP_TAPCELL_ROW_52_876 VGND VPWR sky130_fd_sc_hd__tapvpwrvgnd_1
XFILLER_108_600 VGND VGND VPWR VPWR sky130_fd_sc_hd__decap_3
XFILLER_5_204 VGND VGND VPWR VPWR sky130_fd_sc_hd__decap_3
XFILLER_107_132 VGND VGND VPWR VPWR sky130_fd_sc_hd__decap_3
XFILLER_108_666 VGND VGND VPWR VPWR sky130_fd_sc_hd__decap_3
XPHY_EDGE_ROW_80_Right_80 VGND VGND VPWR VPWR sky130_fd_sc_hd__decap_3
XFILLER_107_165 VGND VGND VPWR VPWR sky130_fd_sc_hd__decap_3
XFILLER_39_40 VGND VGND VPWR VPWR sky130_fd_sc_hd__decap_3
XFILLER_103_393 VGND VGND VPWR VPWR sky130_fd_sc_hd__fill_1
XFILLER_89_594 VGND VGND VPWR VPWR sky130_fd_sc_hd__decap_3
Xclkbuf_4_3_0_clk clkbuf_0_clk/X VGND VGND VPWR VPWR clkload1/A sky130_fd_sc_hd__clkbuf_8
XFILLER_91_225 VGND VGND VPWR VPWR sky130_fd_sc_hd__decap_3
XTAP_TAPCELL_ROW_4_292 VGND VPWR sky130_fd_sc_hd__tapvpwrvgnd_1
Xhold1490 _5446_/Q VGND VGND VPWR VPWR _4383_/B2 sky130_fd_sc_hd__dlygate4sd3_1
XFILLER_44_152 VGND VGND VPWR VPWR sky130_fd_sc_hd__decap_3
XFILLER_60_601 VGND VGND VPWR VPWR sky130_fd_sc_hd__decap_3
XFILLER_32_347 VGND VGND VPWR VPWR sky130_fd_sc_hd__decap_3
XFILLER_60_634 VGND VGND VPWR VPWR sky130_fd_sc_hd__decap_3
XFILLER_60_645 VGND VGND VPWR VPWR sky130_fd_sc_hd__decap_3
XFILLER_71_60 VGND VGND VPWR VPWR sky130_fd_sc_hd__decap_3
XFILLER_72_6 VGND VGND VPWR VPWR sky130_fd_sc_hd__decap_3
XFILLER_9_554 VGND VGND VPWR VPWR sky130_fd_sc_hd__decap_3
X_2640_ _3118_/A1 _2631_/X _2634_/X _2624_/X VGND VGND VPWR VPWR _2640_/X sky130_fd_sc_hd__a31o_2
X_2571_ _2990_/A1 _2569_/X _2570_/X VGND VGND VPWR VPWR _2572_/B sky130_fd_sc_hd__o21ai_2
XFILLER_113_102 VGND VGND VPWR VPWR sky130_fd_sc_hd__fill_2
XFILLER_113_113 VGND VGND VPWR VPWR sky130_fd_sc_hd__fill_2
XFILLER_114_625 VGND VGND VPWR VPWR sky130_fd_sc_hd__decap_3
XFILLER_99_314 VGND VGND VPWR VPWR sky130_fd_sc_hd__decap_3
X_5290_ _6033_/CLK _5290_/D VGND VGND VPWR VPWR _5290_/Q sky130_fd_sc_hd__dfxtp_2
X_4310_ _4822_/A1 _4329_/A2 _4329_/B1 _4310_/B2 VGND VGND VPWR VPWR _5378_/D sky130_fd_sc_hd__a22o_2
XFILLER_114_669 VGND VGND VPWR VPWR sky130_fd_sc_hd__decap_3
X_4241_ _4515_/A1 _4231_/B _4250_/B1 _4241_/B2 VGND VGND VPWR VPWR _5313_/D sky130_fd_sc_hd__a22o_2
XFILLER_113_179 VGND VGND VPWR VPWR sky130_fd_sc_hd__fill_2
X_4172_ _4991_/A1 wire500/X wire281/X _4172_/B2 VGND VGND VPWR VPWR _5249_/D sky130_fd_sc_hd__a22o_2
X_3123_ _2611_/A _3120_/X _3122_/X wire659/X VGND VGND VPWR VPWR _3123_/X sky130_fd_sc_hd__a22o_2
XFILLER_95_586 VGND VGND VPWR VPWR sky130_fd_sc_hd__fill_1
X_3054_ _6064_/Q _5968_/Q _3070_/S VGND VGND VPWR VPWR _3054_/X sky130_fd_sc_hd__mux2_1
XFILLER_36_653 VGND VGND VPWR VPWR sky130_fd_sc_hd__decap_3
XFILLER_23_347 VGND VGND VPWR VPWR sky130_fd_sc_hd__decap_3
XFILLER_51_634 VGND VGND VPWR VPWR sky130_fd_sc_hd__decap_3
X_3956_ _4750_/A1 _3981_/A2 wire322/X _3956_/B2 VGND VGND VPWR VPWR _5052_/D sky130_fd_sc_hd__a22o_2
XFILLER_50_177 VGND VGND VPWR VPWR sky130_fd_sc_hd__fill_2
XTAP_TAPCELL_ROW_21_504 VGND VPWR sky130_fd_sc_hd__tapvpwrvgnd_1
X_2907_ _5417_/Q _5065_/Q _2908_/S VGND VGND VPWR VPWR _2907_/X sky130_fd_sc_hd__mux2_1
XFILLER_31_391 VGND VGND VPWR VPWR sky130_fd_sc_hd__fill_1
X_5626_ _5691_/CLK _5626_/D VGND VGND VPWR VPWR _5626_/Q sky130_fd_sc_hd__dfxtp_2
X_3887_ _3889_/A _3883_/X _3886_/X wire628/X VGND VGND VPWR VPWR _3887_/X sky130_fd_sc_hd__o211a_2
XTAP_TAPCELL_ROW_98_1425 VGND VPWR sky130_fd_sc_hd__tapvpwrvgnd_1
X_2838_ _5126_/Q _5094_/Q _6022_/Q _5990_/Q _2988_/S wire760/X VGND VGND VPWR VPWR
+ _2838_/X sky130_fd_sc_hd__mux4_2
X_5557_ _5589_/CLK _5557_/D VGND VGND VPWR VPWR _5557_/Q sky130_fd_sc_hd__dfxtp_2
X_2769_ _5123_/Q _5091_/Q _6019_/Q _5987_/Q _3021_/S _3018_/S1 VGND VGND VPWR VPWR
+ _2770_/B sky130_fd_sc_hd__mux4_2
X_5488_ _6027_/CLK _5488_/D VGND VGND VPWR VPWR _5488_/Q sky130_fd_sc_hd__dfxtp_2
X_4508_ _4508_/A1 _4535_/A2 _4535_/B1 _4508_/B2 VGND VGND VPWR VPWR _5562_/D sky130_fd_sc_hd__a22o_2
XFILLER_105_647 VGND VGND VPWR VPWR sky130_fd_sc_hd__decap_3
XFILLER_4_9 VGND VGND VPWR VPWR sky130_fd_sc_hd__decap_3
X_4439_ _4507_/A1 _4460_/A2 _4460_/B1 _4439_/B2 VGND VGND VPWR VPWR _5497_/D sky130_fd_sc_hd__a22o_2
XFILLER_104_168 VGND VGND VPWR VPWR sky130_fd_sc_hd__decap_3
Xfanout511 wire518/A VGND VGND VPWR VPWR _4111_/A2 sky130_fd_sc_hd__clkdlybuf4s25_1
XFILLER_58_200 VGND VGND VPWR VPWR sky130_fd_sc_hd__decap_3
XFILLER_86_520 VGND VGND VPWR VPWR sky130_fd_sc_hd__decap_3
Xfanout566 _2499_/X VGND VGND VPWR VPWR _2712_/D sky130_fd_sc_hd__buf_6
Xfanout555 _2516_/Y VGND VGND VPWR VPWR _3185_/B2 sky130_fd_sc_hd__clkdlybuf4s25_1
XFILLER_100_330 VGND VGND VPWR VPWR sky130_fd_sc_hd__decap_3
XFILLER_58_266 VGND VGND VPWR VPWR sky130_fd_sc_hd__fill_1
Xfanout599 _3238_/X VGND VGND VPWR VPWR _3791_/B2 sky130_fd_sc_hd__dlymetal6s2s_1
Xfanout588 _3239_/Y VGND VGND VPWR VPWR _3823_/B2 sky130_fd_sc_hd__dlymetal6s2s_1
Xfanout577 _3253_/X VGND VGND VPWR VPWR _3832_/C1 sky130_fd_sc_hd__clkdlybuf4s15_2
XFILLER_100_396 VGND VGND VPWR VPWR sky130_fd_sc_hd__decap_3
XFILLER_73_225 VGND VGND VPWR VPWR sky130_fd_sc_hd__decap_3
XFILLER_86_586 VGND VGND VPWR VPWR sky130_fd_sc_hd__fill_2
XTAP_TAPCELL_ROW_57_935 VGND VPWR sky130_fd_sc_hd__tapvpwrvgnd_1
XFILLER_92_15 VGND VGND VPWR VPWR sky130_fd_sc_hd__decap_3
XTAP_TAPCELL_ROW_107_1532 VGND VPWR sky130_fd_sc_hd__tapvpwrvgnd_1
XFILLER_42_601 VGND VGND VPWR VPWR sky130_fd_sc_hd__decap_3
XFILLER_92_48 VGND VGND VPWR VPWR sky130_fd_sc_hd__decap_3
XTAP_TAPCELL_ROW_1_262 VGND VPWR sky130_fd_sc_hd__tapvpwrvgnd_1
XFILLER_14_347 VGND VGND VPWR VPWR sky130_fd_sc_hd__decap_3
XFILLER_25_53 VGND VGND VPWR VPWR sky130_fd_sc_hd__decap_3
XFILLER_26_185 VGND VGND VPWR VPWR sky130_fd_sc_hd__decap_3
XFILLER_42_634 VGND VGND VPWR VPWR sky130_fd_sc_hd__decap_3
XFILLER_42_645 VGND VGND VPWR VPWR sky130_fd_sc_hd__decap_3
XTAP_TAPCELL_ROW_37_692 VGND VPWR sky130_fd_sc_hd__tapvpwrvgnd_1
XFILLER_10_531 VGND VGND VPWR VPWR sky130_fd_sc_hd__fill_1
XFILLER_10_542 VGND VGND VPWR VPWR sky130_fd_sc_hd__decap_3
XFILLER_41_41 VGND VGND VPWR VPWR sky130_fd_sc_hd__decap_3
XFILLER_10_586 VGND VGND VPWR VPWR sky130_fd_sc_hd__fill_2
XFILLER_41_74 VGND VGND VPWR VPWR sky130_fd_sc_hd__decap_3
XFILLER_108_441 VGND VGND VPWR VPWR sky130_fd_sc_hd__fill_1
XFILLER_111_617 VGND VGND VPWR VPWR sky130_fd_sc_hd__decap_3
XFILLER_96_306 VGND VGND VPWR VPWR sky130_fd_sc_hd__fill_2
XTAP_TAPCELL_ROW_9_362 VGND VPWR sky130_fd_sc_hd__tapvpwrvgnd_1
XFILLER_2_24 VGND VGND VPWR VPWR sky130_fd_sc_hd__decap_3
XFILLER_2_35 VGND VGND VPWR VPWR sky130_fd_sc_hd__decap_3
XFILLER_2_68 VGND VGND VPWR VPWR sky130_fd_sc_hd__decap_3
XFILLER_64_214 VGND VGND VPWR VPWR sky130_fd_sc_hd__fill_2
XFILLER_18_686 VGND VGND VPWR VPWR sky130_fd_sc_hd__fill_2
XFILLER_92_589 VGND VGND VPWR VPWR sky130_fd_sc_hd__decap_3
XTAP_TAPCELL_ROW_82_1237 VGND VPWR sky130_fd_sc_hd__tapvpwrvgnd_1
XFILLER_32_144 VGND VGND VPWR VPWR sky130_fd_sc_hd__decap_3
X_4790_ _3948_/B _4790_/B VGND VGND VPWR VPWR _5828_/D sky130_fd_sc_hd__and2b_2
X_3810_ _5201_/Q _5169_/Q _3810_/S VGND VGND VPWR VPWR _3810_/X sky130_fd_sc_hd__mux2_1
XANTENNA_18 _4811_/B VGND VGND VPWR VPWR sky130_fd_sc_hd__diode_2
XANTENNA_29 _3718_/A VGND VGND VPWR VPWR sky130_fd_sc_hd__diode_2
XFILLER_20_317 VGND VGND VPWR VPWR sky130_fd_sc_hd__decap_3
X_3741_ _3738_/X _3740_/X _3341_/A VGND VGND VPWR VPWR _3741_/X sky130_fd_sc_hd__o21a_2
XFILLER_9_340 VGND VGND VPWR VPWR sky130_fd_sc_hd__fill_1
XFILLER_70_3 VGND VGND VPWR VPWR sky130_fd_sc_hd__decap_3
X_3672_ _3791_/A1 _3668_/X _3671_/X _3791_/B2 VGND VGND VPWR VPWR _3672_/X sky130_fd_sc_hd__a22o_2
X_5411_ _5824_/CLK _5411_/D VGND VGND VPWR VPWR _5411_/Q sky130_fd_sc_hd__dfxtp_2
X_2623_ _3105_/A1 _2621_/X _2622_/X _3105_/B2 VGND VGND VPWR VPWR _2623_/X sky130_fd_sc_hd__o22a_2
XFILLER_99_111 VGND VGND VPWR VPWR sky130_fd_sc_hd__fill_1
Xoutput103 _3899_/X VGND VGND VPWR VPWR rd2[29] sky130_fd_sc_hd__dlygate4sd1_1
X_5342_ _5800_/CLK _5342_/D VGND VGND VPWR VPWR _5342_/Q sky130_fd_sc_hd__dfxtp_2
X_2554_ _3005_/A1 _2551_/X _2553_/X _3004_/A1 VGND VGND VPWR VPWR _2554_/X sky130_fd_sc_hd__o22a_2
XFILLER_114_433 VGND VGND VPWR VPWR sky130_fd_sc_hd__fill_1
XTAP_TAPCELL_ROW_93_1366 VGND VPWR sky130_fd_sc_hd__tapvpwrvgnd_1
X_5273_ _5824_/CLK _5273_/D VGND VGND VPWR VPWR _5273_/Q sky130_fd_sc_hd__dfxtp_2
XFILLER_99_199 VGND VGND VPWR VPWR sky130_fd_sc_hd__decap_3
X_4224_ _4738_/A1 _4224_/A2 _4227_/B1 _4224_/B2 VGND VGND VPWR VPWR _5298_/D sky130_fd_sc_hd__a22o_2
X_4155_ _5008_/A1 _4155_/A2 wire292/X _4155_/B2 VGND VGND VPWR VPWR _5234_/D sky130_fd_sc_hd__a22o_2
XFILLER_110_672 VGND VGND VPWR VPWR sky130_fd_sc_hd__decap_3
XFILLER_55_214 VGND VGND VPWR VPWR sky130_fd_sc_hd__fill_2
X_3106_ _2649_/A _3102_/X _3105_/X _3106_/C1 VGND VGND VPWR VPWR _3106_/X sky130_fd_sc_hd__o211a_2
X_4086_ _5008_/A1 wire526/X _4086_/B1 _4086_/B2 VGND VGND VPWR VPWR _5170_/D sky130_fd_sc_hd__a22o_2
XFILLER_102_25 VGND VGND VPWR VPWR sky130_fd_sc_hd__decap_3
X_3037_ _5807_/Q _5743_/Q _3038_/S VGND VGND VPWR VPWR _3037_/X sky130_fd_sc_hd__mux2_1
XFILLER_23_100 VGND VGND VPWR VPWR sky130_fd_sc_hd__decap_3
XFILLER_23_144 VGND VGND VPWR VPWR sky130_fd_sc_hd__decap_3
XPHY_EDGE_ROW_43_Left_159 VGND VGND VPWR VPWR sky130_fd_sc_hd__decap_3
XFILLER_23_177 VGND VGND VPWR VPWR sky130_fd_sc_hd__decap_3
XFILLER_51_486 VGND VGND VPWR VPWR sky130_fd_sc_hd__decap_3
XTAP_TAPCELL_ROW_102_1473 VGND VPWR sky130_fd_sc_hd__tapvpwrvgnd_1
XTAP_TAPCELL_ROW_34_662 VGND VPWR sky130_fd_sc_hd__tapvpwrvgnd_1
XTAP_TAPCELL_ROW_62_993 VGND VPWR sky130_fd_sc_hd__tapvpwrvgnd_1
X_4988_ _4988_/A1 _5008_/A2 _5008_/B1 _4988_/B2 VGND VGND VPWR VPWR _6014_/D sky130_fd_sc_hd__a22o_2
X_3939_ _3939_/A1 _3930_/X _3933_/X _3938_/X VGND VGND VPWR VPWR _3939_/X sky130_fd_sc_hd__a31o_2
X_5609_ _6041_/CLK _5609_/D VGND VGND VPWR VPWR _5609_/Q sky130_fd_sc_hd__dfxtp_2
XFILLER_11_55 VGND VGND VPWR VPWR sky130_fd_sc_hd__fill_1
XFILLER_105_433 VGND VGND VPWR VPWR sky130_fd_sc_hd__decap_3
XFILLER_2_6 VGND VGND VPWR VPWR sky130_fd_sc_hd__decap_3
XPHY_EDGE_ROW_52_Left_168 VGND VGND VPWR VPWR sky130_fd_sc_hd__decap_3
XFILLER_59_520 VGND VGND VPWR VPWR sky130_fd_sc_hd__decap_3
XFILLER_59_531 VGND VGND VPWR VPWR sky130_fd_sc_hd__decap_3
XTAP_TAPCELL_ROW_6_321 VGND VPWR sky130_fd_sc_hd__tapvpwrvgnd_1
Xfanout330 _5014_/Y VGND VGND VPWR VPWR _5045_/A2 sky130_fd_sc_hd__clkdlybuf4s25_1
XFILLER_59_564 VGND VGND VPWR VPWR sky130_fd_sc_hd__fill_2
Xfanout363 _4844_/Y VGND VGND VPWR VPWR _4868_/A2 sky130_fd_sc_hd__clkdlybuf4s25_1
Xfanout352 _4912_/Y VGND VGND VPWR VPWR _4913_/B sky130_fd_sc_hd__clkdlybuf4s25_1
Xfanout385 _4710_/Y VGND VGND VPWR VPWR wire386/A sky130_fd_sc_hd__clkdlybuf4s25_1
XFILLER_100_182 VGND VGND VPWR VPWR sky130_fd_sc_hd__fill_1
XFILLER_14_100 VGND VGND VPWR VPWR sky130_fd_sc_hd__decap_3
XPHY_EDGE_ROW_61_Left_177 VGND VGND VPWR VPWR sky130_fd_sc_hd__decap_3
XTAP_TAPCELL_ROW_68_1070 VGND VPWR sky130_fd_sc_hd__tapvpwrvgnd_1
XFILLER_14_133 VGND VGND VPWR VPWR sky130_fd_sc_hd__decap_3
XFILLER_14_144 VGND VGND VPWR VPWR sky130_fd_sc_hd__decap_3
XFILLER_10_361 VGND VGND VPWR VPWR sky130_fd_sc_hd__decap_3
Xinput16 rst VGND VGND VPWR VPWR input16/X sky130_fd_sc_hd__clkdlybuf4s15_2
Xinput27 wd[19] VGND VGND VPWR VPWR input27/X sky130_fd_sc_hd__clkdlybuf4s25_1
XTAP_TAPCELL_ROW_12_389 VGND VPWR sky130_fd_sc_hd__tapvpwrvgnd_1
Xinput38 wd[29] VGND VGND VPWR VPWR input38/X sky130_fd_sc_hd__clkdlybuf4s25_1
Xinput49 we VGND VGND VPWR VPWR _3984_/B sky130_fd_sc_hd__clkdlybuf4s25_1
XFILLER_108_271 VGND VGND VPWR VPWR sky130_fd_sc_hd__decap_3
XFILLER_6_365 VGND VGND VPWR VPWR sky130_fd_sc_hd__decap_3
XPHY_EDGE_ROW_70_Left_186 VGND VGND VPWR VPWR sky130_fd_sc_hd__decap_3
XFILLER_97_615 VGND VGND VPWR VPWR sky130_fd_sc_hd__fill_1
XFILLER_97_626 VGND VGND VPWR VPWR sky130_fd_sc_hd__decap_3
XFILLER_111_447 VGND VGND VPWR VPWR sky130_fd_sc_hd__fill_1
Xload_slew769 _3153_/S1 VGND VGND VPWR VPWR _3157_/S1 sky130_fd_sc_hd__buf_4
Xload_slew758 _3018_/S1 VGND VGND VPWR VPWR _3164_/S1 sky130_fd_sc_hd__buf_2
XFILLER_37_225 VGND VGND VPWR VPWR sky130_fd_sc_hd__decap_3
XFILLER_92_342 VGND VGND VPWR VPWR sky130_fd_sc_hd__decap_3
XFILLER_37_258 VGND VGND VPWR VPWR sky130_fd_sc_hd__fill_1
XFILLER_65_567 VGND VGND VPWR VPWR sky130_fd_sc_hd__fill_1
XFILLER_80_515 VGND VGND VPWR VPWR sky130_fd_sc_hd__decap_3
X_5960_ _6032_/CLK _5960_/D VGND VGND VPWR VPWR _5960_/Q sky130_fd_sc_hd__dfxtp_2
XFILLER_80_559 VGND VGND VPWR VPWR sky130_fd_sc_hd__fill_2
X_5891_ _6051_/CLK _5891_/D VGND VGND VPWR VPWR _5891_/Q sky130_fd_sc_hd__dfxtp_2
X_4911_ _5047_/A1 wire360/X wire144/X _4911_/B2 VGND VGND VPWR VPWR _5943_/D sky130_fd_sc_hd__a22o_2
X_4842_ _5046_/A1 wire374/X wire156/X _4842_/B2 VGND VGND VPWR VPWR _5878_/D sky130_fd_sc_hd__a22o_2
XFILLER_21_648 VGND VGND VPWR VPWR sky130_fd_sc_hd__decap_3
XTAP_TAPCELL_ROW_31_621 VGND VPWR sky130_fd_sc_hd__tapvpwrvgnd_1
X_4773_ _4773_/A1 _4775_/A2 _4775_/B1 _4773_/B2 VGND VGND VPWR VPWR _5811_/D sky130_fd_sc_hd__a22o_2
X_3724_ _3833_/B2 _3716_/X _3718_/X _3843_/C1 _3709_/X VGND VGND VPWR VPWR _3724_/X
+ sky130_fd_sc_hd__a32o_2
XFILLER_9_192 VGND VGND VPWR VPWR sky130_fd_sc_hd__decap_3
X_3655_ _3404_/A _3653_/X _3654_/X _3414_/A VGND VGND VPWR VPWR _3655_/X sky130_fd_sc_hd__o22a_2
X_2606_ _3131_/A _2603_/X _2604_/X _3134_/A1 VGND VGND VPWR VPWR _2606_/X sky130_fd_sc_hd__o22a_2
X_3586_ _5831_/Q _5447_/Q _3693_/S VGND VGND VPWR VPWR _3586_/X sky130_fd_sc_hd__mux2_1
X_5325_ _5885_/CLK _5325_/D VGND VGND VPWR VPWR _5325_/Q sky130_fd_sc_hd__dfxtp_2
X_2537_ input9/X _2531_/X _2536_/X _2608_/A VGND VGND VPWR VPWR _2537_/X sky130_fd_sc_hd__o211a_2
X_5256_ _5800_/CLK _5256_/D VGND VGND VPWR VPWR _5256_/Q sky130_fd_sc_hd__dfxtp_2
XFILLER_102_458 VGND VGND VPWR VPWR sky130_fd_sc_hd__fill_1
XFILLER_87_169 VGND VGND VPWR VPWR sky130_fd_sc_hd__decap_3
X_4207_ _4515_/A1 _4197_/B _4216_/B1 _4207_/B2 VGND VGND VPWR VPWR _5281_/D sky130_fd_sc_hd__a22o_2
XFILLER_113_13 VGND VGND VPWR VPWR sky130_fd_sc_hd__decap_3
X_5187_ _5513_/CLK _5187_/D VGND VGND VPWR VPWR _5187_/Q sky130_fd_sc_hd__dfxtp_2
XFILLER_113_46 VGND VGND VPWR VPWR sky130_fd_sc_hd__decap_3
XTAP_TAPCELL_ROW_39_721 VGND VPWR sky130_fd_sc_hd__tapvpwrvgnd_1
X_4138_ _4991_/A1 wire508/X wire290/X _4138_/B2 VGND VGND VPWR VPWR _5217_/D sky130_fd_sc_hd__a22o_2
XFILLER_113_57 VGND VGND VPWR VPWR sky130_fd_sc_hd__decap_3
XFILLER_56_589 VGND VGND VPWR VPWR sky130_fd_sc_hd__decap_3
X_4069_ _4991_/A1 wire524/X wire306/X _4069_/B2 VGND VGND VPWR VPWR _5153_/D sky130_fd_sc_hd__a22o_2
XFILLER_43_228 VGND VGND VPWR VPWR sky130_fd_sc_hd__decap_3
XTAP_TAPCELL_ROW_104_1502 VGND VPWR sky130_fd_sc_hd__tapvpwrvgnd_1
XFILLER_24_475 VGND VGND VPWR VPWR sky130_fd_sc_hd__fill_1
XFILLER_11_169 VGND VGND VPWR VPWR sky130_fd_sc_hd__decap_3
XFILLER_7_129 VGND VGND VPWR VPWR sky130_fd_sc_hd__decap_3
XFILLER_22_65 VGND VGND VPWR VPWR sky130_fd_sc_hd__decap_3
XFILLER_3_313 VGND VGND VPWR VPWR sky130_fd_sc_hd__decap_3
XFILLER_98_58 VGND VGND VPWR VPWR sky130_fd_sc_hd__decap_3
XTAP_TAPCELL_ROW_115_1631 VGND VPWR sky130_fd_sc_hd__tapvpwrvgnd_1
XTAP_TAPCELL_ROW_115_1642 VGND VPWR sky130_fd_sc_hd__tapvpwrvgnd_1
XFILLER_0_3 VGND VGND VPWR VPWR sky130_fd_sc_hd__decap_3
XFILLER_105_241 VGND VGND VPWR VPWR sky130_fd_sc_hd__decap_3
XFILLER_79_637 VGND VGND VPWR VPWR sky130_fd_sc_hd__decap_3
XFILLER_78_147 VGND VGND VPWR VPWR sky130_fd_sc_hd__decap_3
Xfanout1114 input11/X VGND VGND VPWR VPWR _3915_/S sky130_fd_sc_hd__dlymetal6s4s_1
XFILLER_19_225 VGND VGND VPWR VPWR sky130_fd_sc_hd__decap_3
XFILLER_47_534 VGND VGND VPWR VPWR sky130_fd_sc_hd__decap_3
XFILLER_103_90 VGND VGND VPWR VPWR sky130_fd_sc_hd__fill_2
XTAP_TAPCELL_ROW_17_448 VGND VPWR sky130_fd_sc_hd__tapvpwrvgnd_1
XTAP_TAPCELL_ROW_17_459 VGND VPWR sky130_fd_sc_hd__tapvpwrvgnd_1
XFILLER_15_464 VGND VGND VPWR VPWR sky130_fd_sc_hd__decap_3
XFILLER_70_592 VGND VGND VPWR VPWR sky130_fd_sc_hd__decap_3
XFILLER_8_12 VGND VGND VPWR VPWR sky130_fd_sc_hd__decap_3
XFILLER_8_56 VGND VGND VPWR VPWR sky130_fd_sc_hd__decap_3
XFILLER_10_191 VGND VGND VPWR VPWR sky130_fd_sc_hd__decap_3
XFILLER_6_151 VGND VGND VPWR VPWR sky130_fd_sc_hd__decap_3
XFILLER_7_685 VGND VGND VPWR VPWR sky130_fd_sc_hd__decap_3
Xwire583 wire583/A VGND VGND VPWR VPWR _3632_/A sky130_fd_sc_hd__clkbuf_4
XTAP_TAPCELL_ROW_77_1169 VGND VPWR sky130_fd_sc_hd__tapvpwrvgnd_1
X_3440_ _3341_/A _3436_/X _3439_/X _3434_/X VGND VGND VPWR VPWR _3440_/X sky130_fd_sc_hd__a31o_2
X_3371_ _3371_/A _3371_/B _3471_/B1 VGND VGND VPWR VPWR _3372_/C sky130_fd_sc_hd__or3b_2
XFILLER_33_3 VGND VGND VPWR VPWR sky130_fd_sc_hd__decap_3
XFILLER_97_412 VGND VGND VPWR VPWR sky130_fd_sc_hd__decap_3
XFILLER_97_423 VGND VGND VPWR VPWR sky130_fd_sc_hd__decap_3
Xhold2009 _5318_/Q VGND VGND VPWR VPWR _4246_/B2 sky130_fd_sc_hd__dlygate4sd3_1
Xload_slew522 _4085_/A2 VGND VGND VPWR VPWR _4059_/B sky130_fd_sc_hd__buf_2
X_5110_ _6000_/CLK _5110_/D VGND VGND VPWR VPWR _5110_/Q sky130_fd_sc_hd__dfxtp_2
XTAP_TAPCELL_ROW_90_1325 VGND VPWR sky130_fd_sc_hd__tapvpwrvgnd_1
XFILLER_2_390 VGND VGND VPWR VPWR sky130_fd_sc_hd__fill_2
XFILLER_69_158 VGND VGND VPWR VPWR sky130_fd_sc_hd__fill_1
Xload_slew544 _3951_/B VGND VGND VPWR VPWR _3982_/A2 sky130_fd_sc_hd__buf_4
X_5041_ _5041_/A1 wire334/X _5047_/B1 _5041_/B2 VGND VGND VPWR VPWR _6065_/D sky130_fd_sc_hd__a22o_2
XPHY_EDGE_ROW_108_Left_224 VGND VGND VPWR VPWR sky130_fd_sc_hd__decap_3
Xhold1308 _5612_/Q VGND VGND VPWR VPWR _4561_/B2 sky130_fd_sc_hd__dlygate4sd3_1
Xhold1319 _5919_/Q VGND VGND VPWR VPWR _4887_/B2 sky130_fd_sc_hd__dlygate4sd3_1
XFILLER_77_180 VGND VGND VPWR VPWR sky130_fd_sc_hd__fill_1
XFILLER_38_589 VGND VGND VPWR VPWR sky130_fd_sc_hd__fill_2
XFILLER_93_684 VGND VGND VPWR VPWR sky130_fd_sc_hd__decap_3
XFILLER_53_559 VGND VGND VPWR VPWR sky130_fd_sc_hd__fill_1
XFILLER_80_356 VGND VGND VPWR VPWR sky130_fd_sc_hd__decap_3
X_5943_ _5943_/CLK _5943_/D VGND VGND VPWR VPWR _5943_/Q sky130_fd_sc_hd__dfxtp_2
X_5874_ _5938_/CLK _5874_/D VGND VGND VPWR VPWR _5874_/Q sky130_fd_sc_hd__dfxtp_2
X_4825_ _4927_/A1 wire376/X wire156/A _4825_/B2 VGND VGND VPWR VPWR _5861_/D sky130_fd_sc_hd__a22o_2
X_4756_ _4992_/A1 _4772_/A2 _4772_/B1 _4756_/B2 VGND VGND VPWR VPWR _5794_/D sky130_fd_sc_hd__a22o_2
XFILLER_107_517 VGND VGND VPWR VPWR sky130_fd_sc_hd__decap_3
X_4687_ _4992_/A1 _4703_/A2 _4703_/B1 _4687_/B2 VGND VGND VPWR VPWR _5730_/D sky130_fd_sc_hd__a22o_2
X_3707_ _5517_/Q _5485_/Q _3707_/S VGND VGND VPWR VPWR _3707_/X sky130_fd_sc_hd__mux2_1
XFILLER_104_9 VGND VGND VPWR VPWR sky130_fd_sc_hd__decap_3
XFILLER_108_24 VGND VGND VPWR VPWR sky130_fd_sc_hd__decap_3
XFILLER_108_35 VGND VGND VPWR VPWR sky130_fd_sc_hd__decap_3
X_3638_ _5258_/Q _5226_/Q _3943_/S VGND VGND VPWR VPWR _3638_/X sky130_fd_sc_hd__mux2_1
XFILLER_108_68 VGND VGND VPWR VPWR sky130_fd_sc_hd__decap_3
X_3569_ _3713_/B2 _3567_/X _3568_/X _3713_/A1 VGND VGND VPWR VPWR _3569_/X sky130_fd_sc_hd__o22a_2
XFILLER_102_200 VGND VGND VPWR VPWR sky130_fd_sc_hd__decap_3
X_5308_ _5513_/CLK _5308_/D VGND VGND VPWR VPWR _5308_/Q sky130_fd_sc_hd__dfxtp_2
XFILLER_102_288 VGND VGND VPWR VPWR sky130_fd_sc_hd__fill_2
XFILLER_29_501 VGND VGND VPWR VPWR sky130_fd_sc_hd__decap_3
XFILLER_48_309 VGND VGND VPWR VPWR sky130_fd_sc_hd__decap_3
XFILLER_69_681 VGND VGND VPWR VPWR sky130_fd_sc_hd__decap_3
XFILLER_75_106 VGND VGND VPWR VPWR sky130_fd_sc_hd__fill_1
XTAP_TAPCELL_ROW_110_1572 VGND VPWR sky130_fd_sc_hd__tapvpwrvgnd_1
Xhold1820 _5400_/Q VGND VGND VPWR VPWR _4334_/B2 sky130_fd_sc_hd__dlygate4sd3_1
X_5239_ _6055_/CLK _5239_/D VGND VGND VPWR VPWR _5239_/Q sky130_fd_sc_hd__dfxtp_2
XFILLER_29_545 VGND VGND VPWR VPWR sky130_fd_sc_hd__decap_3
XFILLER_84_640 VGND VGND VPWR VPWR sky130_fd_sc_hd__decap_3
Xhold1831 _5538_/Q VGND VGND VPWR VPWR _4482_/B2 sky130_fd_sc_hd__dlygate4sd3_1
Xhold1842 _5520_/Q VGND VGND VPWR VPWR _4462_/B2 sky130_fd_sc_hd__dlygate4sd3_1
Xhold1853 _5957_/Q VGND VGND VPWR VPWR _4927_/B2 sky130_fd_sc_hd__dlygate4sd3_1
XFILLER_17_21 VGND VGND VPWR VPWR sky130_fd_sc_hd__decap_3
XFILLER_29_556 VGND VGND VPWR VPWR sky130_fd_sc_hd__decap_3
XFILLER_84_673 VGND VGND VPWR VPWR sky130_fd_sc_hd__decap_3
Xhold1864 _5068_/Q VGND VGND VPWR VPWR _3972_/B2 sky130_fd_sc_hd__dlygate4sd3_1
Xhold1875 _5608_/Q VGND VGND VPWR VPWR _4557_/B2 sky130_fd_sc_hd__dlygate4sd3_1
Xhold1886 _5366_/Q VGND VGND VPWR VPWR _4296_/B2 sky130_fd_sc_hd__dlygate4sd3_1
XFILLER_16_217 VGND VGND VPWR VPWR sky130_fd_sc_hd__fill_2
XFILLER_83_172 VGND VGND VPWR VPWR sky130_fd_sc_hd__fill_1
Xhold1897 _5263_/Q VGND VGND VPWR VPWR _4186_/B2 sky130_fd_sc_hd__dlygate4sd3_1
XTAP_TAPCELL_ROW_14_418 VGND VPWR sky130_fd_sc_hd__tapvpwrvgnd_1
XTAP_TAPCELL_ROW_42_749 VGND VPWR sky130_fd_sc_hd__tapvpwrvgnd_1
XFILLER_8_416 VGND VGND VPWR VPWR sky130_fd_sc_hd__decap_3
XFILLER_4_611 VGND VGND VPWR VPWR sky130_fd_sc_hd__decap_3
XFILLER_106_561 VGND VGND VPWR VPWR sky130_fd_sc_hd__fill_1
XFILLER_4_666 VGND VGND VPWR VPWR sky130_fd_sc_hd__decap_3
XFILLER_66_139 VGND VGND VPWR VPWR sky130_fd_sc_hd__fill_1
XFILLER_81_109 VGND VGND VPWR VPWR sky130_fd_sc_hd__decap_3
Xwire1061 _3851_/S VGND VGND VPWR VPWR _3622_/S sky130_fd_sc_hd__clkbuf_4
XFILLER_75_684 VGND VGND VPWR VPWR sky130_fd_sc_hd__decap_3
X_2940_ _5931_/Q _5899_/Q _5867_/Q _5771_/Q _2942_/S _3057_/S1 VGND VGND VPWR VPWR
+ _2940_/X sky130_fd_sc_hd__mux4_2
X_2871_ _2859_/X _2869_/X _2870_/X _3231_/B1 VGND VGND VPWR VPWR _2871_/X sky130_fd_sc_hd__o31a_2
XFILLER_30_253 VGND VGND VPWR VPWR sky130_fd_sc_hd__fill_2
X_4610_ _4747_/A1 wire407/X wire186/X _4610_/B2 VGND VGND VPWR VPWR _5657_/D sky130_fd_sc_hd__a22o_2
X_5590_ _5797_/CLK _5590_/D VGND VGND VPWR VPWR _5590_/Q sky130_fd_sc_hd__dfxtp_2
X_4541_ _4880_/A1 wire421/A _4563_/B1 _4541_/B2 VGND VGND VPWR VPWR _5592_/D sky130_fd_sc_hd__a22o_2
X_4472_ _4506_/A1 wire437/X _4496_/B1 _4472_/B2 VGND VGND VPWR VPWR _5528_/D sky130_fd_sc_hd__a22o_2
X_3423_ _5504_/Q _5472_/Q _3427_/S VGND VGND VPWR VPWR _3423_/X sky130_fd_sc_hd__mux2_1
Xfanout907 input38/X VGND VGND VPWR VPWR _4775_/A1 sky130_fd_sc_hd__clkdlybuf4s25_1
XFILLER_97_220 VGND VGND VPWR VPWR sky130_fd_sc_hd__decap_3
XFILLER_97_242 VGND VGND VPWR VPWR sky130_fd_sc_hd__fill_1
Xfanout929 _4529_/A1 VGND VGND VPWR VPWR _5005_/A1 sky130_fd_sc_hd__clkdlybuf4s25_1
Xfanout918 _4601_/A1 VGND VGND VPWR VPWR _5042_/A1 sky130_fd_sc_hd__clkdlybuf4s25_1
X_3354_ _5789_/Q _5725_/Q _3375_/S VGND VGND VPWR VPWR _3354_/X sky130_fd_sc_hd__mux2_1
Xload_slew341 _5012_/A2 VGND VGND VPWR VPWR _5013_/A2 sky130_fd_sc_hd__clkbuf_4
X_3285_ _3632_/A _3283_/X _3284_/X _3347_/A VGND VGND VPWR VPWR _3285_/X sky130_fd_sc_hd__o22a_2
XFILLER_57_139 VGND VGND VPWR VPWR sky130_fd_sc_hd__decap_3
XFILLER_85_437 VGND VGND VPWR VPWR sky130_fd_sc_hd__decap_3
Xhold1138 _5812_/Q VGND VGND VPWR VPWR _4774_/B2 sky130_fd_sc_hd__dlygate4sd3_1
Xhold1149 _5638_/Q VGND VGND VPWR VPWR _4589_/B2 sky130_fd_sc_hd__dlygate4sd3_1
Xload_slew396 _4693_/A2 VGND VGND VPWR VPWR _4703_/A2 sky130_fd_sc_hd__clkbuf_4
X_5024_ _5024_/A1 _5038_/A2 wire115/X _5024_/B2 VGND VGND VPWR VPWR _6048_/D sky130_fd_sc_hd__a22o_2
XFILLER_66_662 VGND VGND VPWR VPWR sky130_fd_sc_hd__fill_2
XFILLER_38_397 VGND VGND VPWR VPWR sky130_fd_sc_hd__decap_3
XFILLER_65_183 VGND VGND VPWR VPWR sky130_fd_sc_hd__decap_3
XFILLER_66_684 VGND VGND VPWR VPWR sky130_fd_sc_hd__decap_3
XFILLER_80_120 VGND VGND VPWR VPWR sky130_fd_sc_hd__decap_3
XFILLER_81_676 VGND VGND VPWR VPWR sky130_fd_sc_hd__fill_2
X_5926_ _6061_/CLK _5926_/D VGND VGND VPWR VPWR _5926_/Q sky130_fd_sc_hd__dfxtp_2
XFILLER_110_47 VGND VGND VPWR VPWR sky130_fd_sc_hd__decap_3
XFILLER_34_592 VGND VGND VPWR VPWR sky130_fd_sc_hd__decap_3
XFILLER_21_253 VGND VGND VPWR VPWR sky130_fd_sc_hd__decap_3
X_5857_ _5932_/CLK _5857_/D VGND VGND VPWR VPWR _5857_/Q sky130_fd_sc_hd__dfxtp_2
XFILLER_21_297 VGND VGND VPWR VPWR sky130_fd_sc_hd__decap_3
X_5788_ clkload8/A _5788_/D VGND VGND VPWR VPWR _5788_/Q sky130_fd_sc_hd__dfxtp_2
X_4808_ input16/X _4808_/B VGND VGND VPWR VPWR _5846_/D sky130_fd_sc_hd__and2b_2
X_4739_ _5043_/A1 wire386/X wire166/X _4739_/B2 VGND VGND VPWR VPWR _5779_/D sky130_fd_sc_hd__a22o_2
XFILLER_1_614 VGND VGND VPWR VPWR sky130_fd_sc_hd__fill_2
XFILLER_0_113 VGND VGND VPWR VPWR sky130_fd_sc_hd__decap_3
XFILLER_1_647 VGND VGND VPWR VPWR sky130_fd_sc_hd__decap_3
XFILLER_88_253 VGND VGND VPWR VPWR sky130_fd_sc_hd__decap_3
XTAP_TAPCELL_ROW_47_808 VGND VPWR sky130_fd_sc_hd__tapvpwrvgnd_1
XTAP_TAPCELL_ROW_47_819 VGND VPWR sky130_fd_sc_hd__tapvpwrvgnd_1
Xhold1650 _5588_/Q VGND VGND VPWR VPWR _4534_/B2 sky130_fd_sc_hd__dlygate4sd3_1
Xhold1661 _5735_/Q VGND VGND VPWR VPWR _4692_/B2 sky130_fd_sc_hd__dlygate4sd3_1
Xload_slew1113 _3913_/S VGND VGND VPWR VPWR _3767_/S sky130_fd_sc_hd__buf_2
XFILLER_72_610 VGND VGND VPWR VPWR sky130_fd_sc_hd__fill_1
XFILLER_72_632 VGND VGND VPWR VPWR sky130_fd_sc_hd__decap_3
XFILLER_84_492 VGND VGND VPWR VPWR sky130_fd_sc_hd__fill_2
Xhold1672 _5573_/Q VGND VGND VPWR VPWR _4519_/B2 sky130_fd_sc_hd__dlygate4sd3_1
Xhold1683 _6059_/Q VGND VGND VPWR VPWR _5035_/B2 sky130_fd_sc_hd__dlygate4sd3_1
Xhold1694 _5333_/Q VGND VGND VPWR VPWR _4261_/B2 sky130_fd_sc_hd__dlygate4sd3_1
XFILLER_56_194 VGND VGND VPWR VPWR sky130_fd_sc_hd__fill_2
XFILLER_72_665 VGND VGND VPWR VPWR sky130_fd_sc_hd__decap_3
XFILLER_32_518 VGND VGND VPWR VPWR sky130_fd_sc_hd__decap_3
XTAP_TAPCELL_ROW_27_576 VGND VPWR sky130_fd_sc_hd__tapvpwrvgnd_1
XFILLER_44_63 VGND VGND VPWR VPWR sky130_fd_sc_hd__decap_3
XFILLER_12_231 VGND VGND VPWR VPWR sky130_fd_sc_hd__decap_3
XFILLER_8_279 VGND VGND VPWR VPWR sky130_fd_sc_hd__decap_3
XFILLER_4_430 VGND VGND VPWR VPWR sky130_fd_sc_hd__decap_3
XFILLER_5_24 VGND VGND VPWR VPWR sky130_fd_sc_hd__decap_3
XFILLER_5_57 VGND VGND VPWR VPWR sky130_fd_sc_hd__decap_3
XTAP_TAPCELL_ROW_74_1139 VGND VPWR sky130_fd_sc_hd__tapvpwrvgnd_1
XFILLER_69_60 VGND VGND VPWR VPWR sky130_fd_sc_hd__fill_1
XFILLER_39_139 VGND VGND VPWR VPWR sky130_fd_sc_hd__decap_3
XFILLER_94_212 VGND VGND VPWR VPWR sky130_fd_sc_hd__decap_3
X_3070_ _5200_/Q _5168_/Q _3070_/S VGND VGND VPWR VPWR _3070_/X sky130_fd_sc_hd__mux2_1
XFILLER_94_256 VGND VGND VPWR VPWR sky130_fd_sc_hd__decap_3
XFILLER_35_312 VGND VGND VPWR VPWR sky130_fd_sc_hd__decap_3
XFILLER_47_172 VGND VGND VPWR VPWR sky130_fd_sc_hd__decap_3
XFILLER_63_621 VGND VGND VPWR VPWR sky130_fd_sc_hd__fill_1
XFILLER_82_429 VGND VGND VPWR VPWR sky130_fd_sc_hd__decap_3
XFILLER_85_81 VGND VGND VPWR VPWR sky130_fd_sc_hd__fill_2
XFILLER_85_92 VGND VGND VPWR VPWR sky130_fd_sc_hd__decap_3
XTAP_TAPCELL_ROW_85_1268 VGND VPWR sky130_fd_sc_hd__tapvpwrvgnd_1
XFILLER_16_592 VGND VGND VPWR VPWR sky130_fd_sc_hd__decap_3
XFILLER_90_495 VGND VGND VPWR VPWR sky130_fd_sc_hd__decap_3
X_5711_ _5871_/CLK _5711_/D VGND VGND VPWR VPWR _5711_/Q sky130_fd_sc_hd__dfxtp_2
X_3972_ _5036_/A1 wire548/X wire327/X _3972_/B2 VGND VGND VPWR VPWR _5068_/D sky130_fd_sc_hd__a22o_2
X_2923_ _5706_/Q _5674_/Q _5642_/Q _5610_/Q _2925_/S _2973_/S1 VGND VGND VPWR VPWR
+ _2923_/X sky130_fd_sc_hd__mux4_2
X_5642_ _5804_/CLK _5642_/D VGND VGND VPWR VPWR _5642_/Q sky130_fd_sc_hd__dfxtp_2
X_2854_ _3228_/B2 _2851_/X _2853_/X VGND VGND VPWR VPWR _2854_/X sky130_fd_sc_hd__a21o_2
X_5573_ _5832_/CLK _5573_/D VGND VGND VPWR VPWR _5573_/Q sky130_fd_sc_hd__dfxtp_2
X_2785_ _3044_/A _2782_/X _2784_/X _3146_/B2 VGND VGND VPWR VPWR _2785_/X sky130_fd_sc_hd__a22o_2
X_4524_ _4830_/A1 _4537_/A2 _4537_/B1 _4524_/B2 VGND VGND VPWR VPWR _5578_/D sky130_fd_sc_hd__a22o_2
X_4455_ _4660_/A1 _4460_/A2 _4460_/B1 _4455_/B2 VGND VGND VPWR VPWR _5513_/D sky130_fd_sc_hd__a22o_2
XTAP_TAPCELL_ROW_96_1397 VGND VPWR sky130_fd_sc_hd__tapvpwrvgnd_1
Xfanout715 fanout719/X VGND VGND VPWR VPWR _3600_/S sky130_fd_sc_hd__clkdlybuf4s25_1
Xfanout704 _2494_/Y VGND VGND VPWR VPWR _3611_/A1 sky130_fd_sc_hd__clkdlybuf4s25_1
X_4386_ _5033_/A1 _4396_/A2 _4396_/B1 _4386_/B2 VGND VGND VPWR VPWR _5449_/D sky130_fd_sc_hd__a22o_2
X_3406_ _3454_/A _3401_/X _3404_/X _3405_/X VGND VGND VPWR VPWR _3406_/X sky130_fd_sc_hd__o211a_2
Xfanout726 _3005_/A1 VGND VGND VPWR VPWR _2837_/A1 sky130_fd_sc_hd__clkdlybuf4s25_1
X_3337_ _3626_/A _3337_/B VGND VGND VPWR VPWR _3341_/B sky130_fd_sc_hd__or2_2
XFILLER_98_595 VGND VGND VPWR VPWR sky130_fd_sc_hd__decap_3
Xload_slew182 _4659_/B1 VGND VGND VPWR VPWR _4674_/B1 sky130_fd_sc_hd__buf_4
Xload_slew160 _4775_/B1 VGND VGND VPWR VPWR _4768_/B1 sky130_fd_sc_hd__clkbuf_4
Xfanout759 fanout765/X VGND VGND VPWR VPWR wire760/A sky130_fd_sc_hd__clkdlybuf4s25_1
XFILLER_105_69 VGND VGND VPWR VPWR sky130_fd_sc_hd__decap_3
X_6056_ _6056_/CLK _6056_/D VGND VGND VPWR VPWR _6056_/Q sky130_fd_sc_hd__dfxtp_2
X_3268_ _3837_/A _3265_/X _3267_/X _3619_/A1 VGND VGND VPWR VPWR _3268_/X sky130_fd_sc_hd__a22o_2
XFILLER_100_589 VGND VGND VPWR VPWR sky130_fd_sc_hd__decap_3
X_5007_ _5007_/A1 _4981_/B _5012_/B1 _5007_/B2 VGND VGND VPWR VPWR _6033_/D sky130_fd_sc_hd__a22o_2
X_3199_ _5814_/Q _5750_/Q _3199_/S VGND VGND VPWR VPWR _3199_/X sky130_fd_sc_hd__mux2_1
XFILLER_26_356 VGND VGND VPWR VPWR sky130_fd_sc_hd__decap_3
XFILLER_54_643 VGND VGND VPWR VPWR sky130_fd_sc_hd__fill_1
XFILLER_53_153 VGND VGND VPWR VPWR sky130_fd_sc_hd__decap_3
XFILLER_54_687 VGND VGND VPWR VPWR sky130_fd_sc_hd__fill_1
XFILLER_41_337 VGND VGND VPWR VPWR sky130_fd_sc_hd__fill_2
XTAP_TAPCELL_ROW_24_535 VGND VPWR sky130_fd_sc_hd__tapvpwrvgnd_1
XTAP_TAPCELL_ROW_52_877 VGND VPWR sky130_fd_sc_hd__tapvpwrvgnd_1
X_5909_ _6069_/CLK _5909_/D VGND VGND VPWR VPWR _5909_/Q sky130_fd_sc_hd__dfxtp_2
XFILLER_22_595 VGND VGND VPWR VPWR sky130_fd_sc_hd__fill_1
XFILLER_14_88 VGND VGND VPWR VPWR sky130_fd_sc_hd__decap_3
XFILLER_108_645 VGND VGND VPWR VPWR sky130_fd_sc_hd__decap_3
XFILLER_107_144 VGND VGND VPWR VPWR sky130_fd_sc_hd__decap_3
XFILLER_108_678 VGND VGND VPWR VPWR sky130_fd_sc_hd__decap_3
XFILLER_100_3 VGND VGND VPWR VPWR sky130_fd_sc_hd__decap_3
XFILLER_89_540 VGND VGND VPWR VPWR sky130_fd_sc_hd__decap_3
XFILLER_39_30 VGND VGND VPWR VPWR sky130_fd_sc_hd__fill_2
XFILLER_39_52 VGND VGND VPWR VPWR sky130_fd_sc_hd__decap_3
XTAP_TAPCELL_ROW_4_293 VGND VPWR sky130_fd_sc_hd__tapvpwrvgnd_1
XFILLER_17_345 VGND VGND VPWR VPWR sky130_fd_sc_hd__decap_3
XFILLER_29_183 VGND VGND VPWR VPWR sky130_fd_sc_hd__decap_3
Xhold1480 _5207_/Q VGND VGND VPWR VPWR _4126_/B2 sky130_fd_sc_hd__dlygate4sd3_1
Xhold1491 _5943_/Q VGND VGND VPWR VPWR _4911_/B2 sky130_fd_sc_hd__dlygate4sd3_1
XFILLER_44_197 VGND VGND VPWR VPWR sky130_fd_sc_hd__decap_3
XFILLER_111_90 VGND VGND VPWR VPWR sky130_fd_sc_hd__decap_3
XFILLER_13_540 VGND VGND VPWR VPWR sky130_fd_sc_hd__fill_1
XFILLER_71_50 VGND VGND VPWR VPWR sky130_fd_sc_hd__decap_3
XFILLER_71_94 VGND VGND VPWR VPWR sky130_fd_sc_hd__fill_1
XFILLER_9_577 VGND VGND VPWR VPWR sky130_fd_sc_hd__decap_3
XFILLER_65_6 VGND VGND VPWR VPWR sky130_fd_sc_hd__fill_1
X_2570_ wire643/X _2567_/X _2568_/X _2987_/A VGND VGND VPWR VPWR _2570_/X sky130_fd_sc_hd__o22a_2
XFILLER_114_604 VGND VGND VPWR VPWR sky130_fd_sc_hd__decap_3
XFILLER_114_637 VGND VGND VPWR VPWR sky130_fd_sc_hd__decap_3
XFILLER_114_648 VGND VGND VPWR VPWR sky130_fd_sc_hd__decap_3
XFILLER_4_271 VGND VGND VPWR VPWR sky130_fd_sc_hd__decap_3
XFILLER_99_337 VGND VGND VPWR VPWR sky130_fd_sc_hd__fill_1
X_4240_ _4514_/A1 wire482/X wire262/X _4240_/B2 VGND VGND VPWR VPWR _5312_/D sky130_fd_sc_hd__a22o_2
X_4171_ _4990_/A1 _4162_/B _4185_/B1 _4171_/B2 VGND VGND VPWR VPWR _5248_/D sky130_fd_sc_hd__a22o_2
XFILLER_96_80 VGND VGND VPWR VPWR sky130_fd_sc_hd__decap_3
X_3122_ _5811_/Q _5747_/Q _3122_/S VGND VGND VPWR VPWR _3122_/X sky130_fd_sc_hd__mux2_1
XFILLER_67_267 VGND VGND VPWR VPWR sky130_fd_sc_hd__decap_3
X_3053_ _5840_/Q _5456_/Q _3070_/S VGND VGND VPWR VPWR _3053_/X sky130_fd_sc_hd__mux2_1
XFILLER_36_632 VGND VGND VPWR VPWR sky130_fd_sc_hd__decap_3
XFILLER_51_613 VGND VGND VPWR VPWR sky130_fd_sc_hd__decap_3
XFILLER_23_337 VGND VGND VPWR VPWR sky130_fd_sc_hd__fill_1
XFILLER_90_270 VGND VGND VPWR VPWR sky130_fd_sc_hd__fill_1
XFILLER_23_359 VGND VGND VPWR VPWR sky130_fd_sc_hd__decap_3
XFILLER_50_156 VGND VGND VPWR VPWR sky130_fd_sc_hd__fill_1
X_3955_ _4749_/A1 wire546/X wire325/X _3955_/B2 VGND VGND VPWR VPWR _5051_/D sky130_fd_sc_hd__a22o_2
XTAP_TAPCELL_ROW_21_505 VGND VPWR sky130_fd_sc_hd__tapvpwrvgnd_1
X_2906_ _5705_/Q _5673_/Q _5641_/Q _5609_/Q _2908_/S _2911_/S1 VGND VGND VPWR VPWR
+ _2906_/X sky130_fd_sc_hd__mux4_2
X_5625_ _5785_/CLK _5625_/D VGND VGND VPWR VPWR _5625_/Q sky130_fd_sc_hd__dfxtp_2
X_3886_ _3896_/A1 _3884_/X _3885_/X _3896_/B2 VGND VGND VPWR VPWR _3886_/X sky130_fd_sc_hd__o22a_2
XTAP_TAPCELL_ROW_98_1426 VGND VPWR sky130_fd_sc_hd__tapvpwrvgnd_1
X_2837_ _2837_/A1 _2833_/X _2836_/X _3118_/B2 VGND VGND VPWR VPWR _2837_/X sky130_fd_sc_hd__o211a_2
X_5556_ _5572_/CLK _5556_/D VGND VGND VPWR VPWR _5556_/Q sky130_fd_sc_hd__dfxtp_2
X_2768_ _3019_/A _2764_/X _2767_/X _3185_/A1 VGND VGND VPWR VPWR _2768_/X sky130_fd_sc_hd__o211a_2
X_5487_ _5999_/CLK _5487_/D VGND VGND VPWR VPWR _5487_/Q sky130_fd_sc_hd__dfxtp_2
X_4507_ _4507_/A1 _4535_/A2 _4535_/B1 _4507_/B2 VGND VGND VPWR VPWR _5561_/D sky130_fd_sc_hd__a22o_2
X_2699_ wire676/X _2696_/X _2698_/X VGND VGND VPWR VPWR _2700_/B sky130_fd_sc_hd__o21ai_2
XFILLER_104_125 VGND VGND VPWR VPWR sky130_fd_sc_hd__decap_3
XFILLER_105_659 VGND VGND VPWR VPWR sky130_fd_sc_hd__decap_3
X_4438_ _4506_/A1 _4437_/B _4468_/B1 _4438_/B2 VGND VGND VPWR VPWR _5496_/D sky130_fd_sc_hd__a22o_2
Xfanout523 wire526/A VGND VGND VPWR VPWR wire524/A sky130_fd_sc_hd__clkdlybuf4s25_1
Xfanout501 _4161_/Y VGND VGND VPWR VPWR fanout501/X sky130_fd_sc_hd__clkdlybuf4s25_1
XFILLER_98_381 VGND VGND VPWR VPWR sky130_fd_sc_hd__decap_3
Xfanout545 wire548/X VGND VGND VPWR VPWR wire546/A sky130_fd_sc_hd__clkdlybuf4s25_1
Xfanout534 _3987_/Y VGND VGND VPWR VPWR _4005_/A2 sky130_fd_sc_hd__clkdlybuf4s25_1
X_4369_ _5016_/A1 _4399_/A2 wire238/A _4369_/B2 VGND VGND VPWR VPWR _5432_/D sky130_fd_sc_hd__a22o_2
XFILLER_58_245 VGND VGND VPWR VPWR sky130_fd_sc_hd__decap_3
XFILLER_58_256 VGND VGND VPWR VPWR sky130_fd_sc_hd__fill_2
XFILLER_46_418 VGND VGND VPWR VPWR sky130_fd_sc_hd__fill_2
XTAP_TAPCELL_ROW_57_936 VGND VPWR sky130_fd_sc_hd__tapvpwrvgnd_1
X_6039_ _6055_/CLK _6039_/D VGND VGND VPWR VPWR _6039_/Q sky130_fd_sc_hd__dfxtp_2
XFILLER_92_27 VGND VGND VPWR VPWR sky130_fd_sc_hd__fill_1
XTAP_TAPCELL_ROW_107_1533 VGND VPWR sky130_fd_sc_hd__tapvpwrvgnd_1
XFILLER_14_304 VGND VGND VPWR VPWR sky130_fd_sc_hd__decap_3
XFILLER_26_131 VGND VGND VPWR VPWR sky130_fd_sc_hd__decap_3
XFILLER_27_687 VGND VGND VPWR VPWR sky130_fd_sc_hd__fill_1
XFILLER_92_38 VGND VGND VPWR VPWR sky130_fd_sc_hd__fill_2
XTAP_TAPCELL_ROW_1_263 VGND VPWR sky130_fd_sc_hd__tapvpwrvgnd_1
XFILLER_26_197 VGND VGND VPWR VPWR sky130_fd_sc_hd__fill_2
XTAP_TAPCELL_ROW_37_693 VGND VPWR sky130_fd_sc_hd__tapvpwrvgnd_1
XFILLER_10_554 VGND VGND VPWR VPWR sky130_fd_sc_hd__decap_3
XFILLER_6_569 VGND VGND VPWR VPWR sky130_fd_sc_hd__fill_1
XTAP_TAPCELL_ROW_9_352 VGND VPWR sky130_fd_sc_hd__tapvpwrvgnd_1
XFILLER_111_629 VGND VGND VPWR VPWR sky130_fd_sc_hd__decap_3
XTAP_TAPCELL_ROW_9_363 VGND VPWR sky130_fd_sc_hd__tapvpwrvgnd_1
XFILLER_104_681 VGND VGND VPWR VPWR sky130_fd_sc_hd__decap_3
XFILLER_110_139 VGND VGND VPWR VPWR sky130_fd_sc_hd__fill_1
XFILLER_49_212 VGND VGND VPWR VPWR sky130_fd_sc_hd__decap_3
XFILLER_2_47 VGND VGND VPWR VPWR sky130_fd_sc_hd__decap_3
XFILLER_66_61 VGND VGND VPWR VPWR sky130_fd_sc_hd__fill_2
XFILLER_92_579 VGND VGND VPWR VPWR sky130_fd_sc_hd__decap_3
XFILLER_45_495 VGND VGND VPWR VPWR sky130_fd_sc_hd__decap_3
XTAP_TAPCELL_ROW_82_1238 VGND VPWR sky130_fd_sc_hd__tapvpwrvgnd_1
XFILLER_32_156 VGND VGND VPWR VPWR sky130_fd_sc_hd__decap_3
XFILLER_33_679 VGND VGND VPWR VPWR sky130_fd_sc_hd__fill_1
XFILLER_60_465 VGND VGND VPWR VPWR sky130_fd_sc_hd__fill_1
XANTENNA_19 fanout383/A VGND VGND VPWR VPWR sky130_fd_sc_hd__diode_2
XFILLER_32_178 VGND VGND VPWR VPWR sky130_fd_sc_hd__fill_1
X_3740_ _3745_/A1 _3736_/X _3739_/X _3745_/B2 VGND VGND VPWR VPWR _3740_/X sky130_fd_sc_hd__a22o_2
X_3671_ _5803_/Q _5739_/Q _3790_/S VGND VGND VPWR VPWR _3671_/X sky130_fd_sc_hd__mux2_1
XFILLER_63_3 VGND VGND VPWR VPWR sky130_fd_sc_hd__fill_2
XFILLER_9_396 VGND VGND VPWR VPWR sky130_fd_sc_hd__fill_1
X_5410_ _5794_/CLK _5410_/D VGND VGND VPWR VPWR _5410_/Q sky130_fd_sc_hd__dfxtp_2
X_2622_ _5565_/Q _5533_/Q _2738_/S VGND VGND VPWR VPWR _2622_/X sky130_fd_sc_hd__mux2_1
Xoutput104 _3310_/X VGND VGND VPWR VPWR rd2[2] sky130_fd_sc_hd__dlymetal6s4s_1
X_5341_ _5922_/CLK _5341_/D VGND VGND VPWR VPWR _5341_/Q sky130_fd_sc_hd__dfxtp_2
X_2553_ _5498_/Q _5466_/Q _3115_/S VGND VGND VPWR VPWR _2553_/X sky130_fd_sc_hd__mux2_1
XFILLER_99_134 VGND VGND VPWR VPWR sky130_fd_sc_hd__decap_3
XTAP_TAPCELL_ROW_93_1367 VGND VPWR sky130_fd_sc_hd__tapvpwrvgnd_1
X_5272_ _5400_/CLK _5272_/D VGND VGND VPWR VPWR _5272_/Q sky130_fd_sc_hd__dfxtp_2
XFILLER_101_106 VGND VGND VPWR VPWR sky130_fd_sc_hd__decap_3
XFILLER_68_521 VGND VGND VPWR VPWR sky130_fd_sc_hd__decap_3
X_4223_ _5007_/A1 _4229_/A2 _4229_/B1 _4223_/B2 VGND VGND VPWR VPWR _5297_/D sky130_fd_sc_hd__a22o_2
XFILLER_110_651 VGND VGND VPWR VPWR sky130_fd_sc_hd__decap_3
X_4154_ _4531_/A1 _4154_/A2 _4157_/B1 _4154_/B2 VGND VGND VPWR VPWR _5233_/D sky130_fd_sc_hd__a22o_2
XFILLER_110_684 VGND VGND VPWR VPWR sky130_fd_sc_hd__decap_3
XFILLER_68_598 VGND VGND VPWR VPWR sky130_fd_sc_hd__fill_1
X_4085_ _5007_/A1 _4085_/A2 _4085_/B1 _4085_/B2 VGND VGND VPWR VPWR _5169_/D sky130_fd_sc_hd__a22o_2
X_3105_ _3105_/A1 _3103_/X _3104_/X _3105_/B2 VGND VGND VPWR VPWR _3105_/X sky130_fd_sc_hd__o22a_2
X_3036_ _5711_/Q _5679_/Q _5647_/Q _5615_/Q _3038_/S _3157_/S1 VGND VGND VPWR VPWR
+ _3036_/X sky130_fd_sc_hd__mux4_2
XFILLER_36_451 VGND VGND VPWR VPWR sky130_fd_sc_hd__fill_2
XFILLER_63_281 VGND VGND VPWR VPWR sky130_fd_sc_hd__decap_3
XFILLER_91_590 VGND VGND VPWR VPWR sky130_fd_sc_hd__decap_3
XFILLER_24_679 VGND VGND VPWR VPWR sky130_fd_sc_hd__decap_3
XTAP_TAPCELL_ROW_34_652 VGND VPWR sky130_fd_sc_hd__tapvpwrvgnd_1
XFILLER_11_318 VGND VGND VPWR VPWR sky130_fd_sc_hd__decap_3
XFILLER_23_167 VGND VGND VPWR VPWR sky130_fd_sc_hd__fill_1
XTAP_TAPCELL_ROW_34_663 VGND VPWR sky130_fd_sc_hd__tapvpwrvgnd_1
XTAP_TAPCELL_ROW_62_994 VGND VPWR sky130_fd_sc_hd__tapvpwrvgnd_1
X_4987_ _4987_/A1 _5008_/A2 _5008_/B1 _4987_/B2 VGND VGND VPWR VPWR _6013_/D sky130_fd_sc_hd__a22o_2
XTAP_TAPCELL_ROW_102_1474 VGND VPWR sky130_fd_sc_hd__tapvpwrvgnd_1
X_3938_ _3941_/A _3934_/X _3937_/X _3261_/X VGND VGND VPWR VPWR _3938_/X sky130_fd_sc_hd__o211a_2
X_3869_ _3920_/A _3869_/B VGND VGND VPWR VPWR _3869_/X sky130_fd_sc_hd__or2_2
XFILLER_11_12 VGND VGND VPWR VPWR sky130_fd_sc_hd__decap_3
Xclkbuf_4_2_0_clk clkbuf_0_clk/X VGND VGND VPWR VPWR clkbuf_4_2_0_clk/X sky130_fd_sc_hd__clkbuf_8
X_5608_ _5704_/CLK _5608_/D VGND VGND VPWR VPWR _5608_/Q sky130_fd_sc_hd__dfxtp_2
X_5539_ _5571_/CLK _5539_/D VGND VGND VPWR VPWR _5539_/Q sky130_fd_sc_hd__dfxtp_2
XFILLER_78_307 VGND VGND VPWR VPWR sky130_fd_sc_hd__fill_1
XTAP_TAPCELL_ROW_6_322 VGND VPWR sky130_fd_sc_hd__tapvpwrvgnd_1
Xfanout331 _5014_/Y VGND VGND VPWR VPWR _5015_/B sky130_fd_sc_hd__clkdlybuf4s25_1
Xfanout320 _3988_/Y VGND VGND VPWR VPWR _4020_/B1 sky130_fd_sc_hd__clkdlybuf4s25_1
XFILLER_86_340 VGND VGND VPWR VPWR sky130_fd_sc_hd__decap_3
Xfanout375 fanout375/A VGND VGND VPWR VPWR wire376/A sky130_fd_sc_hd__clkdlybuf4s25_1
Xfanout342 _4946_/Y VGND VGND VPWR VPWR _4964_/A2 sky130_fd_sc_hd__clkdlybuf4s25_1
XFILLER_101_684 VGND VGND VPWR VPWR sky130_fd_sc_hd__decap_3
XFILLER_74_524 VGND VGND VPWR VPWR sky130_fd_sc_hd__decap_3
Xfanout397 fanout397/A VGND VGND VPWR VPWR _4708_/A2 sky130_fd_sc_hd__clkdlybuf4s25_1
XFILLER_61_207 VGND VGND VPWR VPWR sky130_fd_sc_hd__decap_3
XFILLER_36_75 VGND VGND VPWR VPWR sky130_fd_sc_hd__fill_1
XFILLER_42_421 VGND VGND VPWR VPWR sky130_fd_sc_hd__decap_3
XFILLER_61_229 VGND VGND VPWR VPWR sky130_fd_sc_hd__decap_3
XTAP_TAPCELL_ROW_68_1060 VGND VPWR sky130_fd_sc_hd__tapvpwrvgnd_1
XTAP_TAPCELL_ROW_68_1071 VGND VPWR sky130_fd_sc_hd__tapvpwrvgnd_1
XFILLER_15_679 VGND VGND VPWR VPWR sky130_fd_sc_hd__decap_3
XFILLER_42_465 VGND VGND VPWR VPWR sky130_fd_sc_hd__decap_3
XFILLER_52_85 VGND VGND VPWR VPWR sky130_fd_sc_hd__fill_2
Xinput17 wd[0] VGND VGND VPWR VPWR input17/X sky130_fd_sc_hd__clkdlybuf4s25_1
Xinput28 wd[1] VGND VGND VPWR VPWR input28/X sky130_fd_sc_hd__clkdlybuf4s25_1
XFILLER_6_344 VGND VGND VPWR VPWR sky130_fd_sc_hd__decap_3
Xinput39 wd[2] VGND VGND VPWR VPWR input39/X sky130_fd_sc_hd__clkdlybuf4s25_1
XFILLER_108_250 VGND VGND VPWR VPWR sky130_fd_sc_hd__fill_2
XFILLER_6_377 VGND VGND VPWR VPWR sky130_fd_sc_hd__decap_3
XFILLER_97_638 VGND VGND VPWR VPWR sky130_fd_sc_hd__decap_3
Xload_slew748 _3044_/A VGND VGND VPWR VPWR _3055_/A1 sky130_fd_sc_hd__buf_2
Xload_slew737 _3081_/A VGND VGND VPWR VPWR _2730_/A sky130_fd_sc_hd__clkbuf_4
XFILLER_28_6 VGND VGND VPWR VPWR sky130_fd_sc_hd__decap_3
XFILLER_77_60 VGND VGND VPWR VPWR sky130_fd_sc_hd__decap_3
XFILLER_77_71 VGND VGND VPWR VPWR sky130_fd_sc_hd__decap_3
XFILLER_65_502 VGND VGND VPWR VPWR sky130_fd_sc_hd__fill_2
XFILLER_77_351 VGND VGND VPWR VPWR sky130_fd_sc_hd__decap_3
XFILLER_37_237 VGND VGND VPWR VPWR sky130_fd_sc_hd__decap_3
XFILLER_65_557 VGND VGND VPWR VPWR sky130_fd_sc_hd__decap_3
XFILLER_92_354 VGND VGND VPWR VPWR sky130_fd_sc_hd__fill_1
XFILLER_18_473 VGND VGND VPWR VPWR sky130_fd_sc_hd__decap_3
XFILLER_52_218 VGND VGND VPWR VPWR sky130_fd_sc_hd__fill_2
XFILLER_80_527 VGND VGND VPWR VPWR sky130_fd_sc_hd__decap_3
XFILLER_93_92 VGND VGND VPWR VPWR sky130_fd_sc_hd__decap_3
X_5890_ _5922_/CLK _5890_/D VGND VGND VPWR VPWR _5890_/Q sky130_fd_sc_hd__dfxtp_2
X_4910_ _5046_/A1 _4910_/A2 wire144/X _4910_/B2 VGND VGND VPWR VPWR _5942_/D sky130_fd_sc_hd__a22o_2
XFILLER_33_432 VGND VGND VPWR VPWR sky130_fd_sc_hd__decap_3
X_4841_ _4943_/A1 _4841_/A2 _4841_/B1 _4841_/B2 VGND VGND VPWR VPWR _5877_/D sky130_fd_sc_hd__a22o_2
XFILLER_21_627 VGND VGND VPWR VPWR sky130_fd_sc_hd__decap_3
XFILLER_33_476 VGND VGND VPWR VPWR sky130_fd_sc_hd__decap_3
XFILLER_20_137 VGND VGND VPWR VPWR sky130_fd_sc_hd__decap_3
XTAP_TAPCELL_ROW_31_622 VGND VPWR sky130_fd_sc_hd__tapvpwrvgnd_1
X_4772_ _4772_/A1 _4772_/A2 _4772_/B1 _4772_/B2 VGND VGND VPWR VPWR _5810_/D sky130_fd_sc_hd__a22o_2
X_3723_ _3827_/S _3719_/X _3722_/X _3832_/C1 VGND VGND VPWR VPWR _3723_/X sky130_fd_sc_hd__o211a_2
X_3654_ _5834_/Q _5450_/Q _3700_/S VGND VGND VPWR VPWR _3654_/X sky130_fd_sc_hd__mux2_1
X_2605_ _5820_/Q _5436_/Q _2896_/S VGND VGND VPWR VPWR _2605_/X sky130_fd_sc_hd__mux2_1
X_3585_ _6055_/Q _5959_/Q _3585_/S VGND VGND VPWR VPWR _3585_/X sky130_fd_sc_hd__mux2_1
XFILLER_114_253 VGND VGND VPWR VPWR sky130_fd_sc_hd__fill_1
X_5324_ _5943_/CLK _5324_/D VGND VGND VPWR VPWR _5324_/Q sky130_fd_sc_hd__dfxtp_2
X_2536_ wire659/X _2533_/X _2535_/X _2516_/B VGND VGND VPWR VPWR _2536_/X sky130_fd_sc_hd__a211o_2
X_5255_ _5258_/CLK _5255_/D VGND VGND VPWR VPWR _5255_/Q sky130_fd_sc_hd__dfxtp_2
X_4206_ _4514_/A1 wire489/X wire269/X _4206_/B2 VGND VGND VPWR VPWR _5280_/D sky130_fd_sc_hd__a22o_2
XFILLER_96_671 VGND VGND VPWR VPWR sky130_fd_sc_hd__decap_3
XFILLER_96_682 VGND VGND VPWR VPWR sky130_fd_sc_hd__decap_3
X_5186_ _5799_/CLK _5186_/D VGND VGND VPWR VPWR _5186_/Q sky130_fd_sc_hd__dfxtp_2
XFILLER_113_25 VGND VGND VPWR VPWR sky130_fd_sc_hd__decap_3
XFILLER_83_332 VGND VGND VPWR VPWR sky130_fd_sc_hd__decap_3
XFILLER_95_181 VGND VGND VPWR VPWR sky130_fd_sc_hd__decap_3
XTAP_TAPCELL_ROW_39_722 VGND VPWR sky130_fd_sc_hd__tapvpwrvgnd_1
X_4137_ _4990_/A1 _4128_/B _4151_/B1 _4137_/B2 VGND VGND VPWR VPWR _5216_/D sky130_fd_sc_hd__a22o_2
XFILLER_113_69 VGND VGND VPWR VPWR sky130_fd_sc_hd__decap_3
XFILLER_28_259 VGND VGND VPWR VPWR sky130_fd_sc_hd__decap_3
XFILLER_43_207 VGND VGND VPWR VPWR sky130_fd_sc_hd__decap_3
X_4068_ _4990_/A1 _4059_/B _4088_/B1 _4068_/B2 VGND VGND VPWR VPWR _5152_/D sky130_fd_sc_hd__a22o_2
XFILLER_36_270 VGND VGND VPWR VPWR sky130_fd_sc_hd__decap_3
XTAP_TAPCELL_ROW_104_1503 VGND VPWR sky130_fd_sc_hd__tapvpwrvgnd_1
X_3019_ _3019_/A _3019_/B VGND VGND VPWR VPWR _3019_/X sky130_fd_sc_hd__or2_2
XFILLER_24_432 VGND VGND VPWR VPWR sky130_fd_sc_hd__decap_3
XFILLER_24_487 VGND VGND VPWR VPWR sky130_fd_sc_hd__decap_3
XFILLER_22_88 VGND VGND VPWR VPWR sky130_fd_sc_hd__decap_3
XFILLER_98_15 VGND VGND VPWR VPWR sky130_fd_sc_hd__decap_3
XTAP_TAPCELL_ROW_115_1632 VGND VPWR sky130_fd_sc_hd__tapvpwrvgnd_1
XTAP_TAPCELL_ROW_115_1643 VGND VPWR sky130_fd_sc_hd__tapvpwrvgnd_1
XFILLER_78_104 VGND VGND VPWR VPWR sky130_fd_sc_hd__decap_3
Xfanout1104 input11/X VGND VGND VPWR VPWR _3908_/S sky130_fd_sc_hd__clkbuf_2
XFILLER_78_159 VGND VGND VPWR VPWR sky130_fd_sc_hd__decap_3
Xfanout1126 _3683_/S VGND VGND VPWR VPWR _3397_/S sky130_fd_sc_hd__clkbuf_2
Xfanout1115 _3929_/S0 VGND VGND VPWR VPWR _3585_/S sky130_fd_sc_hd__clkbuf_2
XFILLER_47_502 VGND VGND VPWR VPWR sky130_fd_sc_hd__fill_2
Xfanout183 fanout183/A VGND VGND VPWR VPWR _4668_/B1 sky130_fd_sc_hd__clkdlybuf4s25_1
Xfanout172 _4676_/Y VGND VGND VPWR VPWR _4706_/B1 sky130_fd_sc_hd__clkdlybuf4s25_1
Xfanout161 _4745_/Y VGND VGND VPWR VPWR _4776_/B1 sky130_fd_sc_hd__clkdlybuf4s25_1
Xfanout150 _4845_/Y VGND VGND VPWR VPWR wire151/A sky130_fd_sc_hd__clkdlybuf4s25_1
XFILLER_101_481 VGND VGND VPWR VPWR sky130_fd_sc_hd__decap_3
XFILLER_47_52 VGND VGND VPWR VPWR sky130_fd_sc_hd__decap_3
Xfanout194 fanout197/A VGND VGND VPWR VPWR _4605_/B1 sky130_fd_sc_hd__clkdlybuf4s25_1
XFILLER_74_343 VGND VGND VPWR VPWR sky130_fd_sc_hd__decap_3
XFILLER_15_421 VGND VGND VPWR VPWR sky130_fd_sc_hd__decap_3
XFILLER_27_281 VGND VGND VPWR VPWR sky130_fd_sc_hd__decap_3
XFILLER_55_590 VGND VGND VPWR VPWR sky130_fd_sc_hd__decap_3
XTAP_TAPCELL_ROW_17_449 VGND VPWR sky130_fd_sc_hd__tapvpwrvgnd_1
XFILLER_97_9 VGND VGND VPWR VPWR sky130_fd_sc_hd__decap_3
XFILLER_30_424 VGND VGND VPWR VPWR sky130_fd_sc_hd__decap_3
XFILLER_8_24 VGND VGND VPWR VPWR sky130_fd_sc_hd__decap_3
XFILLER_8_35 VGND VGND VPWR VPWR sky130_fd_sc_hd__decap_3
XFILLER_11_671 VGND VGND VPWR VPWR sky130_fd_sc_hd__fill_1
XFILLER_11_682 VGND VGND VPWR VPWR sky130_fd_sc_hd__decap_3
XFILLER_7_620 VGND VGND VPWR VPWR sky130_fd_sc_hd__decap_3
XFILLER_7_642 VGND VGND VPWR VPWR sky130_fd_sc_hd__fill_2
Xwire540 wire540/A VGND VGND VPWR VPWR wire540/X sky130_fd_sc_hd__clkbuf_4
XFILLER_6_130 VGND VGND VPWR VPWR sky130_fd_sc_hd__fill_2
XFILLER_6_141 VGND VGND VPWR VPWR sky130_fd_sc_hd__fill_2
X_3370_ _3370_/A1 _3367_/X _3369_/X _3781_/C1 VGND VGND VPWR VPWR _3371_/B sky130_fd_sc_hd__o211a_2
XFILLER_88_81 VGND VGND VPWR VPWR sky130_fd_sc_hd__decap_3
XFILLER_97_435 VGND VGND VPWR VPWR sky130_fd_sc_hd__decap_3
Xload_slew512 _4111_/A2 VGND VGND VPWR VPWR _4124_/A2 sky130_fd_sc_hd__clkbuf_4
XTAP_TAPCELL_ROW_90_1326 VGND VPWR sky130_fd_sc_hd__tapvpwrvgnd_1
Xload_slew556 _3185_/B2 VGND VGND VPWR VPWR _3017_/C1 sky130_fd_sc_hd__clkbuf_4
X_5040_ _5040_/A1 _5015_/B wire118/X _5040_/B2 VGND VGND VPWR VPWR _6064_/D sky130_fd_sc_hd__a22o_2
XFILLER_26_3 VGND VGND VPWR VPWR sky130_fd_sc_hd__decap_3
XFILLER_38_513 VGND VGND VPWR VPWR sky130_fd_sc_hd__decap_3
Xhold1309 _5412_/Q VGND VGND VPWR VPWR _4346_/B2 sky130_fd_sc_hd__dlygate4sd3_1
Xload_slew589 _3823_/B2 VGND VGND VPWR VPWR _3831_/B2 sky130_fd_sc_hd__buf_2
Xload_slew567 _2712_/D VGND VGND VPWR VPWR _2619_/A sky130_fd_sc_hd__buf_4
XFILLER_65_398 VGND VGND VPWR VPWR sky130_fd_sc_hd__fill_1
X_5942_ _6070_/CLK _5942_/D VGND VGND VPWR VPWR _5942_/Q sky130_fd_sc_hd__dfxtp_2
XFILLER_80_346 VGND VGND VPWR VPWR sky130_fd_sc_hd__fill_1
XFILLER_80_368 VGND VGND VPWR VPWR sky130_fd_sc_hd__fill_2
X_5873_ _6053_/CLK _5873_/D VGND VGND VPWR VPWR _5873_/Q sky130_fd_sc_hd__dfxtp_2
XTAP_TAPCELL_ROW_44_780 VGND VPWR sky130_fd_sc_hd__tapvpwrvgnd_1
X_4824_ _4926_/A1 wire374/X wire156/X _4824_/B2 VGND VGND VPWR VPWR _5860_/D sky130_fd_sc_hd__a22o_2
XFILLER_21_457 VGND VGND VPWR VPWR sky130_fd_sc_hd__decap_3
X_4755_ _4755_/A1 _4777_/A2 _4777_/B1 _4755_/B2 VGND VGND VPWR VPWR _5793_/D sky130_fd_sc_hd__a22o_2
X_3706_ _5581_/Q _5549_/Q _3821_/S VGND VGND VPWR VPWR _3706_/X sky130_fd_sc_hd__mux2_1
XFILLER_107_529 VGND VGND VPWR VPWR sky130_fd_sc_hd__decap_3
X_4686_ _4755_/A1 _4708_/A2 _4708_/B1 _4686_/B2 VGND VGND VPWR VPWR _5729_/D sky130_fd_sc_hd__a22o_2
X_3637_ _5130_/Q _5098_/Q _6026_/Q _5994_/Q _3580_/S _3929_/S1 VGND VGND VPWR VPWR
+ _3637_/X sky130_fd_sc_hd__mux4_2
XFILLER_108_47 VGND VGND VPWR VPWR sky130_fd_sc_hd__decap_3
X_3568_ _5830_/Q _5446_/Q _3568_/S VGND VGND VPWR VPWR _3568_/X sky130_fd_sc_hd__mux2_1
XFILLER_115_595 VGND VGND VPWR VPWR sky130_fd_sc_hd__decap_3
XFILLER_68_29 VGND VGND VPWR VPWR sky130_fd_sc_hd__fill_2
X_5307_ _5691_/CLK _5307_/D VGND VGND VPWR VPWR _5307_/Q sky130_fd_sc_hd__dfxtp_2
X_2519_ _5112_/Q _5080_/Q _6008_/Q _5976_/Q _2789_/S _3062_/S1 VGND VGND VPWR VPWR
+ _2519_/X sky130_fd_sc_hd__mux4_2
XFILLER_102_234 VGND VGND VPWR VPWR sky130_fd_sc_hd__decap_3
XFILLER_88_435 VGND VGND VPWR VPWR sky130_fd_sc_hd__fill_1
XFILLER_88_457 VGND VGND VPWR VPWR sky130_fd_sc_hd__fill_2
X_3499_ _5699_/Q _5667_/Q _5635_/Q _5603_/Q _3499_/S0 _3615_/S1 VGND VGND VPWR VPWR
+ _3499_/X sky130_fd_sc_hd__mux4_2
XFILLER_69_671 VGND VGND VPWR VPWR sky130_fd_sc_hd__fill_1
XTAP_TAPCELL_ROW_110_1573 VGND VPWR sky130_fd_sc_hd__tapvpwrvgnd_1
Xhold1810 _5959_/Q VGND VGND VPWR VPWR _4929_/B2 sky130_fd_sc_hd__dlygate4sd3_1
X_5238_ _6021_/CLK _5238_/D VGND VGND VPWR VPWR _5238_/Q sky130_fd_sc_hd__dfxtp_2
Xhold1821 _5964_/Q VGND VGND VPWR VPWR _4934_/B2 sky130_fd_sc_hd__dlygate4sd3_1
Xhold1832 _5870_/Q VGND VGND VPWR VPWR _4834_/B2 sky130_fd_sc_hd__dlygate4sd3_1
Xhold1843 _5453_/Q VGND VGND VPWR VPWR _4390_/B2 sky130_fd_sc_hd__dlygate4sd3_1
Xhold1854 _5601_/Q VGND VGND VPWR VPWR _4550_/B2 sky130_fd_sc_hd__dlygate4sd3_1
Xclkbuf_leaf_95_clk clkload0/A VGND VGND VPWR VPWR _6037_/CLK sky130_fd_sc_hd__clkbuf_8
X_5169_ _6033_/CLK _5169_/D VGND VGND VPWR VPWR _5169_/Q sky130_fd_sc_hd__dfxtp_2
XFILLER_56_354 VGND VGND VPWR VPWR sky130_fd_sc_hd__decap_3
XFILLER_56_365 VGND VGND VPWR VPWR sky130_fd_sc_hd__fill_1
XFILLER_84_663 VGND VGND VPWR VPWR sky130_fd_sc_hd__fill_1
Xhold1865 _5731_/Q VGND VGND VPWR VPWR _4688_/B2 sky130_fd_sc_hd__dlygate4sd3_1
Xhold1876 _5745_/Q VGND VGND VPWR VPWR _4702_/B2 sky130_fd_sc_hd__dlygate4sd3_1
Xhold1887 _5537_/Q VGND VGND VPWR VPWR _4481_/B2 sky130_fd_sc_hd__dlygate4sd3_1
XFILLER_17_44 VGND VGND VPWR VPWR sky130_fd_sc_hd__decap_3
Xhold1898 _5593_/Q VGND VGND VPWR VPWR _4542_/B2 sky130_fd_sc_hd__dlygate4sd3_1
XTAP_TAPCELL_ROW_65_1030 VGND VPWR sky130_fd_sc_hd__tapvpwrvgnd_1
XTAP_TAPCELL_ROW_14_419 VGND VPWR sky130_fd_sc_hd__tapvpwrvgnd_1
XFILLER_33_54 VGND VGND VPWR VPWR sky130_fd_sc_hd__fill_2
XFILLER_33_65 VGND VGND VPWR VPWR sky130_fd_sc_hd__fill_1
XFILLER_4_623 VGND VGND VPWR VPWR sky130_fd_sc_hd__decap_3
XFILLER_4_645 VGND VGND VPWR VPWR sky130_fd_sc_hd__decap_3
XFILLER_3_177 VGND VGND VPWR VPWR sky130_fd_sc_hd__fill_1
XFILLER_4_678 VGND VGND VPWR VPWR sky130_fd_sc_hd__decap_3
XFILLER_94_416 VGND VGND VPWR VPWR sky130_fd_sc_hd__decap_3
XFILLER_12_9 VGND VGND VPWR VPWR sky130_fd_sc_hd__decap_3
Xclkbuf_leaf_86_clk clkbuf_4_6_0_clk/X VGND VGND VPWR VPWR _5502_/CLK sky130_fd_sc_hd__clkbuf_8
XFILLER_90_633 VGND VGND VPWR VPWR sky130_fd_sc_hd__decap_3
XFILLER_35_549 VGND VGND VPWR VPWR sky130_fd_sc_hd__decap_3
XFILLER_15_240 VGND VGND VPWR VPWR sky130_fd_sc_hd__decap_3
XFILLER_15_284 VGND VGND VPWR VPWR sky130_fd_sc_hd__decap_3
XFILLER_15_295 VGND VGND VPWR VPWR sky130_fd_sc_hd__decap_3
XFILLER_95_6 VGND VGND VPWR VPWR sky130_fd_sc_hd__decap_3
X_2870_ _3230_/B2 _2861_/X _2864_/X _2854_/X _3230_/A1 VGND VGND VPWR VPWR _2870_/X
+ sky130_fd_sc_hd__a32o_2
XFILLER_90_82 VGND VGND VPWR VPWR sky130_fd_sc_hd__fill_2
Xclkbuf_leaf_10_clk clkload1/A VGND VGND VPWR VPWR _6019_/CLK sky130_fd_sc_hd__clkbuf_8
X_4540_ _4913_/A _4540_/B VGND VGND VPWR VPWR _4540_/Y sky130_fd_sc_hd__nor2_2
XFILLER_7_472 VGND VGND VPWR VPWR sky130_fd_sc_hd__decap_3
X_4471_ _4879_/A _4471_/B VGND VGND VPWR VPWR _4471_/Y sky130_fd_sc_hd__nor2_2
Xmax_cap158 _4811_/Y VGND VGND VPWR VPWR fanout157/A sky130_fd_sc_hd__clkbuf_2
X_3422_ _5568_/Q _5536_/Q _3733_/S VGND VGND VPWR VPWR _3422_/X sky130_fd_sc_hd__mux2_1
Xfanout919 _4601_/A1 VGND VGND VPWR VPWR _5008_/A1 sky130_fd_sc_hd__clkdlybuf4s25_1
Xfanout908 input38/X VGND VGND VPWR VPWR _4535_/A1 sky130_fd_sc_hd__clkdlybuf4s25_1
X_3353_ _5405_/Q _5053_/Q _3375_/S VGND VGND VPWR VPWR _3353_/X sky130_fd_sc_hd__mux2_1
XFILLER_112_587 VGND VGND VPWR VPWR sky130_fd_sc_hd__fill_1
Xload_slew364 _4868_/A2 VGND VGND VPWR VPWR _4873_/A2 sky130_fd_sc_hd__clkbuf_4
X_3284_ _5817_/Q _5433_/Q _3284_/S VGND VGND VPWR VPWR _3284_/X sky130_fd_sc_hd__mux2_1
XFILLER_112_598 VGND VGND VPWR VPWR sky130_fd_sc_hd__decap_3
XFILLER_97_287 VGND VGND VPWR VPWR sky130_fd_sc_hd__fill_1
Xhold1139 _5570_/Q VGND VGND VPWR VPWR _4516_/B2 sky130_fd_sc_hd__dlygate4sd3_1
Xclkbuf_leaf_77_clk clkload2/A VGND VGND VPWR VPWR _6061_/CLK sky130_fd_sc_hd__clkbuf_8
X_5023_ _5023_/A1 wire332/X wire118/A _5023_/B2 VGND VGND VPWR VPWR _6047_/D sky130_fd_sc_hd__a22o_2
XFILLER_0_91 VGND VGND VPWR VPWR sky130_fd_sc_hd__decap_3
XFILLER_110_15 VGND VGND VPWR VPWR sky130_fd_sc_hd__decap_3
X_5925_ _5925_/CLK _5925_/D VGND VGND VPWR VPWR _5925_/Q sky130_fd_sc_hd__dfxtp_2
XFILLER_110_59 VGND VGND VPWR VPWR sky130_fd_sc_hd__decap_3
X_5856_ _6048_/CLK _5856_/D VGND VGND VPWR VPWR _5856_/Q sky130_fd_sc_hd__dfxtp_2
XPHY_EDGE_ROW_3_Right_3 VGND VGND VPWR VPWR sky130_fd_sc_hd__decap_3
X_4807_ _4807_/A_N _4807_/B VGND VGND VPWR VPWR _5845_/D sky130_fd_sc_hd__and2b_2
XFILLER_21_276 VGND VGND VPWR VPWR sky130_fd_sc_hd__decap_3
X_5787_ _5938_/CLK _5787_/D VGND VGND VPWR VPWR _5787_/Q sky130_fd_sc_hd__dfxtp_2
X_2999_ _3111_/B2 _2997_/X _2998_/X wire647/X VGND VGND VPWR VPWR _2999_/X sky130_fd_sc_hd__o22a_2
X_4738_ _4738_/A1 _4741_/A2 _4741_/B1 _4738_/B2 VGND VGND VPWR VPWR _5778_/D sky130_fd_sc_hd__a22o_2
XFILLER_107_315 VGND VGND VPWR VPWR sky130_fd_sc_hd__decap_3
XFILLER_107_337 VGND VGND VPWR VPWR sky130_fd_sc_hd__decap_3
X_4669_ _4772_/A1 _4674_/A2 _4674_/B1 _4669_/B2 VGND VGND VPWR VPWR _5714_/D sky130_fd_sc_hd__a22o_2
XFILLER_102_7 VGND VGND VPWR VPWR sky130_fd_sc_hd__decap_3
XFILLER_1_626 VGND VGND VPWR VPWR sky130_fd_sc_hd__decap_3
XFILLER_115_381 VGND VGND VPWR VPWR sky130_fd_sc_hd__decap_3
XFILLER_1_659 VGND VGND VPWR VPWR sky130_fd_sc_hd__decap_3
XFILLER_103_554 VGND VGND VPWR VPWR sky130_fd_sc_hd__decap_3
XFILLER_28_21 VGND VGND VPWR VPWR sky130_fd_sc_hd__decap_3
XFILLER_28_32 VGND VGND VPWR VPWR sky130_fd_sc_hd__decap_3
XFILLER_29_310 VGND VGND VPWR VPWR sky130_fd_sc_hd__decap_3
XFILLER_76_427 VGND VGND VPWR VPWR sky130_fd_sc_hd__fill_1
XFILLER_88_298 VGND VGND VPWR VPWR sky130_fd_sc_hd__fill_2
XFILLER_28_54 VGND VGND VPWR VPWR sky130_fd_sc_hd__decap_3
XFILLER_29_354 VGND VGND VPWR VPWR sky130_fd_sc_hd__decap_3
XFILLER_57_641 VGND VGND VPWR VPWR sky130_fd_sc_hd__decap_3
XTAP_TAPCELL_ROW_47_809 VGND VPWR sky130_fd_sc_hd__tapvpwrvgnd_1
Xhold1640 _5641_/Q VGND VGND VPWR VPWR _4592_/B2 sky130_fd_sc_hd__dlygate4sd3_1
Xhold1651 _5373_/Q VGND VGND VPWR VPWR _4305_/B2 sky130_fd_sc_hd__dlygate4sd3_1
Xhold1662 _5734_/Q VGND VGND VPWR VPWR _4691_/B2 sky130_fd_sc_hd__dlygate4sd3_1
Xload_slew1103 _3779_/S VGND VGND VPWR VPWR _3665_/S sky130_fd_sc_hd__buf_2
Xload_slew1125 _3398_/S VGND VGND VPWR VPWR _3810_/S sky130_fd_sc_hd__buf_4
Xclkbuf_leaf_68_clk clkload3/A VGND VGND VPWR VPWR _6050_/CLK sky130_fd_sc_hd__clkbuf_8
XFILLER_17_505 VGND VGND VPWR VPWR sky130_fd_sc_hd__decap_3
XFILLER_29_387 VGND VGND VPWR VPWR sky130_fd_sc_hd__decap_3
XFILLER_91_419 VGND VGND VPWR VPWR sky130_fd_sc_hd__decap_3
Xhold1673 _5084_/Q VGND VGND VPWR VPWR _3993_/B2 sky130_fd_sc_hd__dlygate4sd3_1
Xhold1684 _5123_/Q VGND VGND VPWR VPWR _4035_/B2 sky130_fd_sc_hd__dlygate4sd3_1
Xhold1695 _5616_/Q VGND VGND VPWR VPWR _4565_/B2 sky130_fd_sc_hd__dlygate4sd3_1
XFILLER_56_184 VGND VGND VPWR VPWR sky130_fd_sc_hd__decap_3
XFILLER_71_143 VGND VGND VPWR VPWR sky130_fd_sc_hd__decap_3
XTAP_TAPCELL_ROW_27_577 VGND VPWR sky130_fd_sc_hd__tapvpwrvgnd_1
XFILLER_71_187 VGND VGND VPWR VPWR sky130_fd_sc_hd__fill_2
XFILLER_8_214 VGND VGND VPWR VPWR sky130_fd_sc_hd__fill_2
XFILLER_8_225 VGND VGND VPWR VPWR sky130_fd_sc_hd__decap_3
XFILLER_8_269 VGND VGND VPWR VPWR sky130_fd_sc_hd__fill_2
XFILLER_60_85 VGND VGND VPWR VPWR sky130_fd_sc_hd__decap_3
XFILLER_5_36 VGND VGND VPWR VPWR sky130_fd_sc_hd__decap_3
XFILLER_99_508 VGND VGND VPWR VPWR sky130_fd_sc_hd__fill_1
XFILLER_109_90 VGND VGND VPWR VPWR sky130_fd_sc_hd__decap_3
XFILLER_69_50 VGND VGND VPWR VPWR sky130_fd_sc_hd__decap_3
XFILLER_79_221 VGND VGND VPWR VPWR sky130_fd_sc_hd__decap_3
XFILLER_79_265 VGND VGND VPWR VPWR sky130_fd_sc_hd__fill_2
XFILLER_94_224 VGND VGND VPWR VPWR sky130_fd_sc_hd__fill_2
XFILLER_10_6 VGND VGND VPWR VPWR sky130_fd_sc_hd__decap_3
XFILLER_47_140 VGND VGND VPWR VPWR sky130_fd_sc_hd__fill_1
XFILLER_48_663 VGND VGND VPWR VPWR sky130_fd_sc_hd__fill_1
XFILLER_82_408 VGND VGND VPWR VPWR sky130_fd_sc_hd__decap_3
XFILLER_85_60 VGND VGND VPWR VPWR sky130_fd_sc_hd__decap_3
XFILLER_85_71 VGND VGND VPWR VPWR sky130_fd_sc_hd__fill_2
Xclkbuf_leaf_59_clk clkload6/A VGND VGND VPWR VPWR _6055_/CLK sky130_fd_sc_hd__clkbuf_8
XFILLER_75_460 VGND VGND VPWR VPWR sky130_fd_sc_hd__fill_2
XFILLER_47_184 VGND VGND VPWR VPWR sky130_fd_sc_hd__decap_3
XFILLER_62_165 VGND VGND VPWR VPWR sky130_fd_sc_hd__fill_2
X_3971_ _5035_/A1 _3951_/B _3982_/B1 _3971_/B2 VGND VGND VPWR VPWR _5067_/D sky130_fd_sc_hd__a22o_2
XTAP_TAPCELL_ROW_85_1269 VGND VPWR sky130_fd_sc_hd__tapvpwrvgnd_1
X_5710_ _6062_/CLK _5710_/D VGND VGND VPWR VPWR _5710_/Q sky130_fd_sc_hd__dfxtp_2
X_2922_ _3228_/B2 _2919_/X _2921_/X VGND VGND VPWR VPWR _2922_/X sky130_fd_sc_hd__a21o_2
XFILLER_93_3 VGND VGND VPWR VPWR sky130_fd_sc_hd__decap_3
XFILLER_31_596 VGND VGND VPWR VPWR sky130_fd_sc_hd__fill_2
X_5641_ _6041_/CLK _5641_/D VGND VGND VPWR VPWR _5641_/Q sky130_fd_sc_hd__dfxtp_2
X_2853_ _2497_/B _2850_/X _2852_/X _3229_/A1 VGND VGND VPWR VPWR _2853_/X sky130_fd_sc_hd__a22o_2
X_5572_ _5572_/CLK _5572_/D VGND VGND VPWR VPWR _5572_/Q sky130_fd_sc_hd__dfxtp_2
X_2784_ _6052_/Q _5956_/Q _3159_/S VGND VGND VPWR VPWR _2784_/X sky130_fd_sc_hd__mux2_1
X_4523_ input25/X _4535_/A2 _4535_/B1 _4523_/B2 VGND VGND VPWR VPWR _5577_/D sky130_fd_sc_hd__a22o_2
XFILLER_104_307 VGND VGND VPWR VPWR sky130_fd_sc_hd__fill_1
X_4454_ _4659_/A1 _4467_/A2 _4467_/B1 _4454_/B2 VGND VGND VPWR VPWR _5512_/D sky130_fd_sc_hd__a22o_2
XTAP_TAPCELL_ROW_96_1398 VGND VPWR sky130_fd_sc_hd__tapvpwrvgnd_1
XFILLER_98_541 VGND VGND VPWR VPWR sky130_fd_sc_hd__decap_3
X_4385_ _4659_/A1 wire459/A _4385_/B1 _4385_/B2 VGND VGND VPWR VPWR _5448_/D sky130_fd_sc_hd__a22o_2
X_3405_ _3414_/A _3402_/X _3909_/B1 VGND VGND VPWR VPWR _3405_/X sky130_fd_sc_hd__o21a_2
XFILLER_105_15 VGND VGND VPWR VPWR sky130_fd_sc_hd__decap_3
Xfanout749 _3228_/A1 VGND VGND VPWR VPWR _2492_/A sky130_fd_sc_hd__dlygate4sd1_1
Xfanout738 _2937_/A1 VGND VGND VPWR VPWR _3215_/A sky130_fd_sc_hd__clkbuf_2
X_3336_ _5692_/Q _5660_/Q _5628_/Q _5596_/Q _3284_/S _3627_/S1 VGND VGND VPWR VPWR
+ _3337_/B sky130_fd_sc_hd__mux4_2
X_6055_ _6055_/CLK _6055_/D VGND VGND VPWR VPWR _6055_/Q sky130_fd_sc_hd__dfxtp_2
XFILLER_39_641 VGND VGND VPWR VPWR sky130_fd_sc_hd__decap_3
X_5006_ input33/X _4981_/B _5010_/B1 _5006_/B2 VGND VGND VPWR VPWR _6032_/D sky130_fd_sc_hd__a22o_2
X_3267_ _5561_/Q _5529_/Q _3284_/S VGND VGND VPWR VPWR _3267_/X sky130_fd_sc_hd__mux2_1
XFILLER_39_685 VGND VGND VPWR VPWR sky130_fd_sc_hd__decap_3
XFILLER_54_600 VGND VGND VPWR VPWR sky130_fd_sc_hd__decap_3
X_3198_ _3198_/A _3198_/B VGND VGND VPWR VPWR _3198_/X sky130_fd_sc_hd__or2_2
XFILLER_81_29 VGND VGND VPWR VPWR sky130_fd_sc_hd__fill_1
XTAP_TAPCELL_ROW_24_536 VGND VPWR sky130_fd_sc_hd__tapvpwrvgnd_1
XFILLER_22_552 VGND VGND VPWR VPWR sky130_fd_sc_hd__decap_3
XTAP_TAPCELL_ROW_52_878 VGND VPWR sky130_fd_sc_hd__tapvpwrvgnd_1
X_5908_ _6068_/CLK _5908_/D VGND VGND VPWR VPWR _5908_/Q sky130_fd_sc_hd__dfxtp_2
X_5839_ _6063_/CLK _5839_/D VGND VGND VPWR VPWR _5839_/Q sky130_fd_sc_hd__dfxtp_2
XFILLER_108_657 VGND VGND VPWR VPWR sky130_fd_sc_hd__decap_3
XFILLER_30_55 VGND VGND VPWR VPWR sky130_fd_sc_hd__decap_3
XFILLER_107_178 VGND VGND VPWR VPWR sky130_fd_sc_hd__fill_2
XFILLER_1_445 VGND VGND VPWR VPWR sky130_fd_sc_hd__decap_3
Xhold2160 _5819_/Q VGND VGND VPWR VPWR _4781_/B sky130_fd_sc_hd__dlygate4sd3_1
XTAP_TAPCELL_ROW_4_294 VGND VPWR sky130_fd_sc_hd__tapvpwrvgnd_1
Xhold1470 _5381_/Q VGND VGND VPWR VPWR _4313_/B2 sky130_fd_sc_hd__dlygate4sd3_1
XFILLER_17_335 VGND VGND VPWR VPWR sky130_fd_sc_hd__fill_1
XFILLER_29_195 VGND VGND VPWR VPWR sky130_fd_sc_hd__decap_3
Xhold1481 _5760_/Q VGND VGND VPWR VPWR _4720_/B2 sky130_fd_sc_hd__dlygate4sd3_1
Xhold1492 _5203_/Q VGND VGND VPWR VPWR _4122_/B2 sky130_fd_sc_hd__dlygate4sd3_1
XFILLER_55_96 VGND VGND VPWR VPWR sky130_fd_sc_hd__decap_3
XFILLER_72_474 VGND VGND VPWR VPWR sky130_fd_sc_hd__fill_2
XFILLER_44_176 VGND VGND VPWR VPWR sky130_fd_sc_hd__decap_3
XFILLER_9_534 VGND VGND VPWR VPWR sky130_fd_sc_hd__decap_3
XFILLER_9_545 VGND VGND VPWR VPWR sky130_fd_sc_hd__decap_3
XFILLER_9_589 VGND VGND VPWR VPWR sky130_fd_sc_hd__decap_3
XFILLER_114_616 VGND VGND VPWR VPWR sky130_fd_sc_hd__decap_3
X_4170_ _4989_/A1 wire500/X wire281/X _4170_/B2 VGND VGND VPWR VPWR _5247_/D sky130_fd_sc_hd__a22o_2
XFILLER_95_511 VGND VGND VPWR VPWR sky130_fd_sc_hd__fill_1
X_3121_ _5427_/Q _5075_/Q _3122_/S VGND VGND VPWR VPWR _3121_/X sky130_fd_sc_hd__mux2_1
XFILLER_95_544 VGND VGND VPWR VPWR sky130_fd_sc_hd__decap_3
X_3052_ _5936_/Q _5904_/Q _5872_/Q _5776_/Q _3070_/S _3057_/S1 VGND VGND VPWR VPWR
+ _3052_/X sky130_fd_sc_hd__mux4_2
XFILLER_48_493 VGND VGND VPWR VPWR sky130_fd_sc_hd__fill_1
XFILLER_36_677 VGND VGND VPWR VPWR sky130_fd_sc_hd__decap_3
X_3954_ _4645_/A1 _3981_/A2 wire322/A _3954_/B2 VGND VGND VPWR VPWR _5050_/D sky130_fd_sc_hd__a22o_2
XTAP_TAPCELL_ROW_21_506 VGND VPWR sky130_fd_sc_hd__tapvpwrvgnd_1
X_3885_ _5845_/Q _5461_/Q _3895_/S VGND VGND VPWR VPWR _3885_/X sky130_fd_sc_hd__mux2_1
X_2905_ _2899_/X _2904_/X _2608_/A VGND VGND VPWR VPWR _2905_/X sky130_fd_sc_hd__o21a_2
XFILLER_31_393 VGND VGND VPWR VPWR sky130_fd_sc_hd__decap_3
X_5624_ _5812_/CLK _5624_/D VGND VGND VPWR VPWR _5624_/Q sky130_fd_sc_hd__dfxtp_2
X_2836_ wire643/A _2834_/X _2835_/X _3004_/B2 VGND VGND VPWR VPWR _2836_/X sky130_fd_sc_hd__o22a_2
XTAP_TAPCELL_ROW_98_1427 VGND VPWR sky130_fd_sc_hd__tapvpwrvgnd_1
X_5555_ _5589_/CLK _5555_/D VGND VGND VPWR VPWR _5555_/Q sky130_fd_sc_hd__dfxtp_2
X_2767_ wire676/X _2765_/X _2766_/X wire641/X VGND VGND VPWR VPWR _2767_/X sky130_fd_sc_hd__o22a_2
XFILLER_105_605 VGND VGND VPWR VPWR sky130_fd_sc_hd__decap_3
X_5486_ _5838_/CLK _5486_/D VGND VGND VPWR VPWR _5486_/Q sky130_fd_sc_hd__dfxtp_2
X_4506_ _4506_/A1 wire431/X _4530_/B1 _4506_/B2 VGND VGND VPWR VPWR _5560_/D sky130_fd_sc_hd__a22o_2
X_2698_ _3019_/A _2695_/X _2697_/X wire641/X VGND VGND VPWR VPWR _2698_/X sky130_fd_sc_hd__o22a_2
X_4437_ _4437_/A _4437_/B VGND VGND VPWR VPWR _4437_/Y sky130_fd_sc_hd__nor2_2
Xfanout513 wire516/A VGND VGND VPWR VPWR _4120_/A2 sky130_fd_sc_hd__dlygate4sd1_1
XFILLER_113_671 VGND VGND VPWR VPWR sky130_fd_sc_hd__fill_1
XFILLER_113_682 VGND VGND VPWR VPWR sky130_fd_sc_hd__decap_3
XFILLER_86_500 VGND VGND VPWR VPWR sky130_fd_sc_hd__decap_3
XFILLER_86_533 VGND VGND VPWR VPWR sky130_fd_sc_hd__decap_3
XFILLER_98_360 VGND VGND VPWR VPWR sky130_fd_sc_hd__decap_3
Xfanout557 _2516_/Y VGND VGND VPWR VPWR _3207_/A1 sky130_fd_sc_hd__clkdlybuf4s25_1
X_4368_ _4879_/A _4368_/B VGND VGND VPWR VPWR _4368_/Y sky130_fd_sc_hd__nor2_2
XFILLER_100_321 VGND VGND VPWR VPWR sky130_fd_sc_hd__decap_3
XFILLER_58_235 VGND VGND VPWR VPWR sky130_fd_sc_hd__fill_2
XFILLER_86_566 VGND VGND VPWR VPWR sky130_fd_sc_hd__fill_1
Xfanout579 _3248_/X VGND VGND VPWR VPWR _3843_/C1 sky130_fd_sc_hd__buf_2
Xfanout568 _2499_/X VGND VGND VPWR VPWR _3119_/B1 sky130_fd_sc_hd__buf_2
X_4299_ _4879_/A _4299_/B VGND VGND VPWR VPWR _4299_/Y sky130_fd_sc_hd__nor2_2
X_3319_ _3562_/A _3316_/X _3318_/X _3713_/A1 _3832_/C1 VGND VGND VPWR VPWR _3319_/X
+ sky130_fd_sc_hd__o221a_2
XFILLER_100_376 VGND VGND VPWR VPWR sky130_fd_sc_hd__decap_3
XTAP_TAPCELL_ROW_57_937 VGND VPWR sky130_fd_sc_hd__tapvpwrvgnd_1
X_6038_ _6038_/CLK _6038_/D VGND VGND VPWR VPWR _6038_/Q sky130_fd_sc_hd__dfxtp_2
XFILLER_27_633 VGND VGND VPWR VPWR sky130_fd_sc_hd__fill_1
XTAP_TAPCELL_ROW_107_1534 VGND VPWR sky130_fd_sc_hd__tapvpwrvgnd_1
XTAP_TAPCELL_ROW_1_264 VGND VPWR sky130_fd_sc_hd__tapvpwrvgnd_1
XFILLER_14_327 VGND VGND VPWR VPWR sky130_fd_sc_hd__fill_2
XFILLER_14_338 VGND VGND VPWR VPWR sky130_fd_sc_hd__decap_3
XFILLER_42_625 VGND VGND VPWR VPWR sky130_fd_sc_hd__decap_3
XTAP_TAPCELL_ROW_37_694 VGND VPWR sky130_fd_sc_hd__tapvpwrvgnd_1
XFILLER_41_124 VGND VGND VPWR VPWR sky130_fd_sc_hd__decap_3
XFILLER_10_522 VGND VGND VPWR VPWR sky130_fd_sc_hd__decap_3
XFILLER_10_533 VGND VGND VPWR VPWR sky130_fd_sc_hd__decap_3
XFILLER_10_577 VGND VGND VPWR VPWR sky130_fd_sc_hd__decap_3
XFILLER_108_432 VGND VGND VPWR VPWR sky130_fd_sc_hd__decap_3
XFILLER_104_660 VGND VGND VPWR VPWR sky130_fd_sc_hd__decap_3
XFILLER_111_608 VGND VGND VPWR VPWR sky130_fd_sc_hd__decap_3
XTAP_TAPCELL_ROW_9_353 VGND VPWR sky130_fd_sc_hd__tapvpwrvgnd_1
XFILLER_2_15 VGND VGND VPWR VPWR sky130_fd_sc_hd__decap_3
XFILLER_106_80 VGND VGND VPWR VPWR sky130_fd_sc_hd__decap_3
XFILLER_2_59 VGND VGND VPWR VPWR sky130_fd_sc_hd__decap_3
XFILLER_89_393 VGND VGND VPWR VPWR sky130_fd_sc_hd__decap_3
XFILLER_92_503 VGND VGND VPWR VPWR sky130_fd_sc_hd__decap_3
XFILLER_92_525 VGND VGND VPWR VPWR sky130_fd_sc_hd__decap_3
XFILLER_60_411 VGND VGND VPWR VPWR sky130_fd_sc_hd__fill_1
XTAP_TAPCELL_ROW_82_1228 VGND VPWR sky130_fd_sc_hd__tapvpwrvgnd_1
XTAP_TAPCELL_ROW_82_1239 VGND VPWR sky130_fd_sc_hd__tapvpwrvgnd_1
XFILLER_82_94 VGND VGND VPWR VPWR sky130_fd_sc_hd__decap_3
XFILLER_13_393 VGND VGND VPWR VPWR sky130_fd_sc_hd__decap_3
XFILLER_9_375 VGND VGND VPWR VPWR sky130_fd_sc_hd__fill_1
X_3670_ _3784_/A _3670_/B VGND VGND VPWR VPWR _3670_/X sky130_fd_sc_hd__and2_2
X_2621_ _5501_/Q _5469_/Q _2660_/S VGND VGND VPWR VPWR _2621_/X sky130_fd_sc_hd__mux2_1
XFILLER_99_102 VGND VGND VPWR VPWR sky130_fd_sc_hd__decap_3
Xoutput105 _3923_/X VGND VGND VPWR VPWR rd2[30] sky130_fd_sc_hd__clkbuf_2
X_5340_ _5500_/CLK _5340_/D VGND VGND VPWR VPWR _5340_/Q sky130_fd_sc_hd__dfxtp_2
X_2552_ _5562_/Q _5530_/Q _3115_/S VGND VGND VPWR VPWR _2552_/X sky130_fd_sc_hd__mux2_1
XFILLER_5_570 VGND VGND VPWR VPWR sky130_fd_sc_hd__decap_3
XFILLER_99_113 VGND VGND VPWR VPWR sky130_fd_sc_hd__decap_3
X_5271_ _6055_/CLK _5271_/D VGND VGND VPWR VPWR _5271_/Q sky130_fd_sc_hd__dfxtp_2
XTAP_TAPCELL_ROW_93_1368 VGND VPWR sky130_fd_sc_hd__tapvpwrvgnd_1
X_4222_ _5040_/A1 _4226_/A2 _4226_/B1 _4222_/B2 VGND VGND VPWR VPWR _5296_/D sky130_fd_sc_hd__a22o_2
XFILLER_99_179 VGND VGND VPWR VPWR sky130_fd_sc_hd__decap_3
XFILLER_110_641 VGND VGND VPWR VPWR sky130_fd_sc_hd__decap_3
X_4153_ _4530_/A1 _4128_/B _4157_/B1 _4153_/B2 VGND VGND VPWR VPWR _5232_/D sky130_fd_sc_hd__a22o_2
XFILLER_110_663 VGND VGND VPWR VPWR sky130_fd_sc_hd__decap_3
XFILLER_55_205 VGND VGND VPWR VPWR sky130_fd_sc_hd__decap_3
X_4084_ _4530_/A1 _4059_/B _4088_/B1 _4084_/B2 VGND VGND VPWR VPWR _5168_/D sky130_fd_sc_hd__a22o_2
X_3104_ _5266_/Q _5234_/Q _3104_/S VGND VGND VPWR VPWR _3104_/X sky130_fd_sc_hd__mux2_1
X_3035_ _3147_/A1 _3032_/X _3034_/X VGND VGND VPWR VPWR _3035_/X sky130_fd_sc_hd__a21o_2
XFILLER_102_16 VGND VGND VPWR VPWR sky130_fd_sc_hd__decap_3
XFILLER_83_569 VGND VGND VPWR VPWR sky130_fd_sc_hd__fill_2
XFILLER_23_113 VGND VGND VPWR VPWR sky130_fd_sc_hd__decap_3
X_4986_ _4986_/A1 _5011_/A2 _5011_/B1 _4986_/B2 VGND VGND VPWR VPWR _6012_/D sky130_fd_sc_hd__a22o_2
XTAP_TAPCELL_ROW_34_653 VGND VPWR sky130_fd_sc_hd__tapvpwrvgnd_1
XTAP_TAPCELL_ROW_62_995 VGND VPWR sky130_fd_sc_hd__tapvpwrvgnd_1
X_3937_ _3414_/A _3935_/X _3936_/X _3944_/B2 VGND VGND VPWR VPWR _3937_/X sky130_fd_sc_hd__o22a_2
XTAP_TAPCELL_ROW_102_1475 VGND VPWR sky130_fd_sc_hd__tapvpwrvgnd_1
X_3868_ _5844_/Q _5460_/Q _6068_/Q _5972_/Q _3514_/S _3868_/S1 VGND VGND VPWR VPWR
+ _3869_/B sky130_fd_sc_hd__mux4_2
X_5607_ _5815_/CLK _5607_/D VGND VGND VPWR VPWR _5607_/Q sky130_fd_sc_hd__dfxtp_2
X_3799_ _5713_/Q _5681_/Q _5649_/Q _5617_/Q _3802_/S _3799_/S1 VGND VGND VPWR VPWR
+ _3800_/B sky130_fd_sc_hd__mux4_2
X_2819_ _3222_/B2 _2817_/X _2818_/X _3222_/A1 VGND VGND VPWR VPWR _2819_/X sky130_fd_sc_hd__o22a_2
XFILLER_11_57 VGND VGND VPWR VPWR sky130_fd_sc_hd__decap_3
X_5538_ _5879_/CLK _5538_/D VGND VGND VPWR VPWR _5538_/Q sky130_fd_sc_hd__dfxtp_2
XFILLER_105_424 VGND VGND VPWR VPWR sky130_fd_sc_hd__fill_1
XFILLER_105_468 VGND VGND VPWR VPWR sky130_fd_sc_hd__decap_3
XFILLER_87_28 VGND VGND VPWR VPWR sky130_fd_sc_hd__decap_3
X_5469_ _5922_/CLK _5469_/D VGND VGND VPWR VPWR _5469_/Q sky130_fd_sc_hd__dfxtp_2
XFILLER_59_511 VGND VGND VPWR VPWR sky130_fd_sc_hd__decap_3
XTAP_TAPCELL_ROW_6_323 VGND VPWR sky130_fd_sc_hd__tapvpwrvgnd_1
Xfanout321 wire327/A VGND VGND VPWR VPWR wire322/A sky130_fd_sc_hd__clkdlybuf4s25_1
XFILLER_101_641 VGND VGND VPWR VPWR sky130_fd_sc_hd__decap_3
Xfanout365 _4844_/Y VGND VGND VPWR VPWR _4875_/A2 sky130_fd_sc_hd__clkdlybuf4s25_1
Xfanout354 _4912_/Y VGND VGND VPWR VPWR wire355/A sky130_fd_sc_hd__clkdlybuf4s25_1
XFILLER_86_352 VGND VGND VPWR VPWR sky130_fd_sc_hd__decap_3
Xfanout387 _4710_/Y VGND VGND VPWR VPWR _4741_/A2 sky130_fd_sc_hd__clkdlybuf4s25_1
XFILLER_100_173 VGND VGND VPWR VPWR sky130_fd_sc_hd__fill_1
XFILLER_100_195 VGND VGND VPWR VPWR sky130_fd_sc_hd__fill_1
XFILLER_46_227 VGND VGND VPWR VPWR sky130_fd_sc_hd__fill_2
XFILLER_15_603 VGND VGND VPWR VPWR sky130_fd_sc_hd__decap_3
XFILLER_27_430 VGND VGND VPWR VPWR sky130_fd_sc_hd__decap_3
XFILLER_74_569 VGND VGND VPWR VPWR sky130_fd_sc_hd__decap_3
XFILLER_15_636 VGND VGND VPWR VPWR sky130_fd_sc_hd__decap_3
XTAP_TAPCELL_ROW_68_1061 VGND VPWR sky130_fd_sc_hd__tapvpwrvgnd_1
XFILLER_14_124 VGND VGND VPWR VPWR sky130_fd_sc_hd__decap_3
XFILLER_15_658 VGND VGND VPWR VPWR sky130_fd_sc_hd__decap_3
XFILLER_15_669 VGND VGND VPWR VPWR sky130_fd_sc_hd__decap_3
XFILLER_42_477 VGND VGND VPWR VPWR sky130_fd_sc_hd__decap_3
Xinput18 wd[10] VGND VGND VPWR VPWR input18/X sky130_fd_sc_hd__clkdlybuf4s25_1
XFILLER_6_312 VGND VGND VPWR VPWR sky130_fd_sc_hd__decap_3
Xinput29 wd[20] VGND VGND VPWR VPWR input29/X sky130_fd_sc_hd__clkdlybuf4s25_1
XFILLER_108_262 VGND VGND VPWR VPWR sky130_fd_sc_hd__decap_3
XFILLER_6_356 VGND VGND VPWR VPWR sky130_fd_sc_hd__decap_3
XFILLER_97_617 VGND VGND VPWR VPWR sky130_fd_sc_hd__decap_3
Xload_slew705 _3611_/A1 VGND VGND VPWR VPWR _3496_/A sky130_fd_sc_hd__clkbuf_4
XFILLER_2_573 VGND VGND VPWR VPWR sky130_fd_sc_hd__decap_3
XFILLER_2_584 VGND VGND VPWR VPWR sky130_fd_sc_hd__decap_3
Xload_slew727 _2837_/A1 VGND VGND VPWR VPWR _2987_/A sky130_fd_sc_hd__clkbuf_4
XFILLER_2_595 VGND VGND VPWR VPWR sky130_fd_sc_hd__decap_3
XFILLER_65_514 VGND VGND VPWR VPWR sky130_fd_sc_hd__decap_3
XFILLER_65_525 VGND VGND VPWR VPWR sky130_fd_sc_hd__fill_2
XFILLER_80_506 VGND VGND VPWR VPWR sky130_fd_sc_hd__fill_1
XFILLER_93_60 VGND VGND VPWR VPWR sky130_fd_sc_hd__fill_1
XFILLER_18_485 VGND VGND VPWR VPWR sky130_fd_sc_hd__decap_3
X_4840_ _4908_/A1 wire374/X wire156/X _4840_/B2 VGND VGND VPWR VPWR _5876_/D sky130_fd_sc_hd__a22o_2
XFILLER_21_606 VGND VGND VPWR VPWR sky130_fd_sc_hd__decap_3
XFILLER_21_617 VGND VGND VPWR VPWR sky130_fd_sc_hd__decap_3
XFILLER_33_488 VGND VGND VPWR VPWR sky130_fd_sc_hd__decap_3
XFILLER_21_639 VGND VGND VPWR VPWR sky130_fd_sc_hd__decap_3
XTAP_TAPCELL_ROW_31_623 VGND VPWR sky130_fd_sc_hd__tapvpwrvgnd_1
X_4771_ _4771_/A1 _4777_/A2 _4777_/B1 _4771_/B2 VGND VGND VPWR VPWR _5809_/D sky130_fd_sc_hd__a22o_2
X_3722_ _3831_/A1 _3720_/X _3721_/X _3831_/B2 VGND VGND VPWR VPWR _3722_/X sky130_fd_sc_hd__o22a_2
X_3653_ _6058_/Q _5962_/Q _3700_/S VGND VGND VPWR VPWR _3653_/X sky130_fd_sc_hd__mux2_1
XTAP_TAPCELL_ROW_11_380 VGND VPWR sky130_fd_sc_hd__tapvpwrvgnd_1
X_2604_ _6044_/Q _5948_/Q _2604_/S VGND VGND VPWR VPWR _2604_/X sky130_fd_sc_hd__mux2_1
X_5323_ _6059_/CLK _5323_/D VGND VGND VPWR VPWR _5323_/Q sky130_fd_sc_hd__dfxtp_2
X_3584_ _3687_/A _3584_/B VGND VGND VPWR VPWR _3584_/X sky130_fd_sc_hd__or2_2
X_2535_ _2611_/A _2532_/X _2534_/X wire693/X VGND VGND VPWR VPWR _2535_/X sky130_fd_sc_hd__a22o_2
XFILLER_87_116 VGND VGND VPWR VPWR sky130_fd_sc_hd__decap_3
XFILLER_88_628 VGND VGND VPWR VPWR sky130_fd_sc_hd__decap_3
X_5254_ _6061_/CLK _5254_/D VGND VGND VPWR VPWR _5254_/Q sky130_fd_sc_hd__dfxtp_2
XFILLER_102_449 VGND VGND VPWR VPWR sky130_fd_sc_hd__fill_2
X_5185_ _6026_/CLK _5185_/D VGND VGND VPWR VPWR _5185_/Q sky130_fd_sc_hd__dfxtp_2
X_4205_ _4719_/A1 _4197_/B _4216_/B1 _4205_/B2 VGND VGND VPWR VPWR _5279_/D sky130_fd_sc_hd__a22o_2
XFILLER_68_374 VGND VGND VPWR VPWR sky130_fd_sc_hd__fill_2
X_4136_ _4989_/A1 wire508/X wire290/X _4136_/B2 VGND VGND VPWR VPWR _5215_/D sky130_fd_sc_hd__a22o_2
XFILLER_113_37 VGND VGND VPWR VPWR sky130_fd_sc_hd__decap_3
XTAP_TAPCELL_ROW_39_712 VGND VPWR sky130_fd_sc_hd__tapvpwrvgnd_1
XTAP_TAPCELL_ROW_39_723 VGND VPWR sky130_fd_sc_hd__tapvpwrvgnd_1
XFILLER_83_344 VGND VGND VPWR VPWR sky130_fd_sc_hd__decap_3
X_4067_ _4989_/A1 wire524/X wire306/X _4067_/B2 VGND VGND VPWR VPWR _5151_/D sky130_fd_sc_hd__a22o_2
X_3018_ _5134_/Q _5102_/Q _6030_/Q _5998_/Q _3021_/S _3018_/S1 VGND VGND VPWR VPWR
+ _3019_/B sky130_fd_sc_hd__mux4_2
XFILLER_36_282 VGND VGND VPWR VPWR sky130_fd_sc_hd__decap_3
XTAP_TAPCELL_ROW_19_480 VGND VPWR sky130_fd_sc_hd__tapvpwrvgnd_1
XFILLER_24_477 VGND VGND VPWR VPWR sky130_fd_sc_hd__fill_2
X_4969_ _5003_/A1 _4974_/A2 _4974_/B1 _4969_/B2 VGND VGND VPWR VPWR _5997_/D sky130_fd_sc_hd__a22o_2
XFILLER_20_683 VGND VGND VPWR VPWR sky130_fd_sc_hd__decap_3
XFILLER_22_56 VGND VGND VPWR VPWR sky130_fd_sc_hd__decap_3
XFILLER_98_27 VGND VGND VPWR VPWR sky130_fd_sc_hd__fill_1
XFILLER_98_49 VGND VGND VPWR VPWR sky130_fd_sc_hd__decap_3
XTAP_TAPCELL_ROW_115_1633 VGND VPWR sky130_fd_sc_hd__tapvpwrvgnd_1
XTAP_TAPCELL_ROW_115_1644 VGND VPWR sky130_fd_sc_hd__tapvpwrvgnd_1
XFILLER_78_116 VGND VGND VPWR VPWR sky130_fd_sc_hd__decap_3
XFILLER_105_298 VGND VGND VPWR VPWR sky130_fd_sc_hd__fill_1
XFILLER_78_138 VGND VGND VPWR VPWR sky130_fd_sc_hd__fill_2
XPHY_EDGE_ROW_110_Right_110 VGND VGND VPWR VPWR sky130_fd_sc_hd__decap_3
Xfanout140 _4879_/Y VGND VGND VPWR VPWR _4909_/B1 sky130_fd_sc_hd__clkdlybuf4s25_1
XFILLER_93_108 VGND VGND VPWR VPWR sky130_fd_sc_hd__decap_3
Xfanout162 _4745_/Y VGND VGND VPWR VPWR _4762_/B1 sky130_fd_sc_hd__clkdlybuf4s25_1
XFILLER_59_374 VGND VGND VPWR VPWR sky130_fd_sc_hd__fill_1
Xfanout195 _4574_/Y VGND VGND VPWR VPWR _4591_/B1 sky130_fd_sc_hd__clkdlybuf4s25_1
XFILLER_74_377 VGND VGND VPWR VPWR sky130_fd_sc_hd__fill_2
XFILLER_63_41 VGND VGND VPWR VPWR sky130_fd_sc_hd__decap_3
XFILLER_15_455 VGND VGND VPWR VPWR sky130_fd_sc_hd__fill_1
XFILLER_30_469 VGND VGND VPWR VPWR sky130_fd_sc_hd__decap_3
XFILLER_8_47 VGND VGND VPWR VPWR sky130_fd_sc_hd__decap_3
XFILLER_7_632 VGND VGND VPWR VPWR sky130_fd_sc_hd__fill_2
XFILLER_7_676 VGND VGND VPWR VPWR sky130_fd_sc_hd__decap_3
XFILLER_97_403 VGND VGND VPWR VPWR sky130_fd_sc_hd__fill_1
Xload_slew502 fanout501/X VGND VGND VPWR VPWR _4189_/A2 sky130_fd_sc_hd__clkbuf_4
XTAP_TAPCELL_ROW_90_1327 VGND VPWR sky130_fd_sc_hd__tapvpwrvgnd_1
XFILLER_111_213 VGND VGND VPWR VPWR sky130_fd_sc_hd__fill_2
XFILLER_97_447 VGND VGND VPWR VPWR sky130_fd_sc_hd__fill_1
Xload_slew535 _4005_/A2 VGND VGND VPWR VPWR _4018_/A2 sky130_fd_sc_hd__buf_4
XFILLER_78_661 VGND VGND VPWR VPWR sky130_fd_sc_hd__fill_1
XFILLER_78_683 VGND VGND VPWR VPWR sky130_fd_sc_hd__decap_3
XFILLER_92_141 VGND VGND VPWR VPWR sky130_fd_sc_hd__fill_1
Xclkbuf_4_1_0_clk clkbuf_0_clk/X VGND VGND VPWR VPWR clkload0/A sky130_fd_sc_hd__clkbuf_8
XFILLER_53_539 VGND VGND VPWR VPWR sky130_fd_sc_hd__fill_1
XFILLER_92_174 VGND VGND VPWR VPWR sky130_fd_sc_hd__decap_3
X_5941_ _6069_/CLK _5941_/D VGND VGND VPWR VPWR _5941_/Q sky130_fd_sc_hd__dfxtp_2
XFILLER_61_561 VGND VGND VPWR VPWR sky130_fd_sc_hd__fill_2
X_5872_ _6064_/CLK _5872_/D VGND VGND VPWR VPWR _5872_/Q sky130_fd_sc_hd__dfxtp_2
XFILLER_21_436 VGND VGND VPWR VPWR sky130_fd_sc_hd__decap_3
XTAP_TAPCELL_ROW_44_781 VGND VPWR sky130_fd_sc_hd__tapvpwrvgnd_1
X_4823_ _4891_/A1 wire371/A wire153/X _4823_/B2 VGND VGND VPWR VPWR _5859_/D sky130_fd_sc_hd__a22o_2
X_4754_ _4754_/A1 _4775_/A2 _4768_/B1 _4754_/B2 VGND VGND VPWR VPWR _5792_/D sky130_fd_sc_hd__a22o_2
X_3705_ _5389_/Q _5357_/Q _5325_/Q _5293_/Q _3822_/S _3705_/S1 VGND VGND VPWR VPWR
+ _3705_/X sky130_fd_sc_hd__mux4_2
XFILLER_107_508 VGND VGND VPWR VPWR sky130_fd_sc_hd__decap_3
X_4685_ _4754_/A1 _4706_/A2 _4699_/B1 _4685_/B2 VGND VGND VPWR VPWR _5728_/D sky130_fd_sc_hd__a22o_2
XFILLER_108_15 VGND VGND VPWR VPWR sky130_fd_sc_hd__decap_3
X_3636_ _3624_/X _3634_/X _3635_/X _3855_/B1 VGND VGND VPWR VPWR _3636_/X sky130_fd_sc_hd__o31a_2
XFILLER_108_59 VGND VGND VPWR VPWR sky130_fd_sc_hd__decap_3
X_3567_ _6054_/Q _5958_/Q _3568_/S VGND VGND VPWR VPWR _3567_/X sky130_fd_sc_hd__mux2_1
XFILLER_115_574 VGND VGND VPWR VPWR sky130_fd_sc_hd__decap_3
X_5306_ _5658_/CLK _5306_/D VGND VGND VPWR VPWR _5306_/Q sky130_fd_sc_hd__dfxtp_2
X_2518_ wire685/X _2515_/X _2517_/X wire651/X VGND VGND VPWR VPWR _2518_/X sky130_fd_sc_hd__o22a_2
X_5237_ _5914_/CLK _5237_/D VGND VGND VPWR VPWR _5237_/Q sky130_fd_sc_hd__dfxtp_2
X_3498_ _3837_/A _3498_/B VGND VGND VPWR VPWR _3498_/X sky130_fd_sc_hd__or2_2
XTAP_TAPCELL_ROW_110_1574 VGND VPWR sky130_fd_sc_hd__tapvpwrvgnd_1
Xhold1800 _5052_/Q VGND VGND VPWR VPWR _3956_/B2 sky130_fd_sc_hd__dlygate4sd3_1
Xhold1811 _5444_/Q VGND VGND VPWR VPWR _4381_/B2 sky130_fd_sc_hd__dlygate4sd3_1
XFILLER_29_536 VGND VGND VPWR VPWR sky130_fd_sc_hd__decap_3
XFILLER_84_29 VGND VGND VPWR VPWR sky130_fd_sc_hd__decap_3
Xhold1822 _5154_/Q VGND VGND VPWR VPWR _4070_/B2 sky130_fd_sc_hd__dlygate4sd3_1
Xhold1833 _6046_/Q VGND VGND VPWR VPWR _5022_/B2 sky130_fd_sc_hd__dlygate4sd3_1
Xhold1844 _5462_/Q VGND VGND VPWR VPWR _4399_/B2 sky130_fd_sc_hd__dlygate4sd3_1
X_5168_ _6032_/CLK _5168_/D VGND VGND VPWR VPWR _5168_/Q sky130_fd_sc_hd__dfxtp_2
XFILLER_68_193 VGND VGND VPWR VPWR sky130_fd_sc_hd__decap_3
Xhold1855 _5115_/Q VGND VGND VPWR VPWR _4027_/B2 sky130_fd_sc_hd__dlygate4sd3_1
Xhold1866 _5948_/Q VGND VGND VPWR VPWR _4918_/B2 sky130_fd_sc_hd__dlygate4sd3_1
Xhold1877 _5698_/Q VGND VGND VPWR VPWR _4653_/B2 sky130_fd_sc_hd__dlygate4sd3_1
X_5099_ _6027_/CLK _5099_/D VGND VGND VPWR VPWR _5099_/Q sky130_fd_sc_hd__dfxtp_2
X_4119_ _4530_/A1 _4094_/B _4123_/B1 _4119_/B2 VGND VGND VPWR VPWR _5200_/D sky130_fd_sc_hd__a22o_2
Xhold1888 _5353_/Q VGND VGND VPWR VPWR _4283_/B2 sky130_fd_sc_hd__dlygate4sd3_1
Xhold1899 _5126_/Q VGND VGND VPWR VPWR _4038_/B2 sky130_fd_sc_hd__dlygate4sd3_1
XTAP_TAPCELL_ROW_65_1031 VGND VPWR sky130_fd_sc_hd__tapvpwrvgnd_1
XFILLER_8_407 VGND VGND VPWR VPWR sky130_fd_sc_hd__decap_3
XPHY_EDGE_ROW_49_Left_165 VGND VGND VPWR VPWR sky130_fd_sc_hd__decap_3
XFILLER_4_635 VGND VGND VPWR VPWR sky130_fd_sc_hd__decap_3
XFILLER_106_530 VGND VGND VPWR VPWR sky130_fd_sc_hd__fill_2
XFILLER_4_657 VGND VGND VPWR VPWR sky130_fd_sc_hd__decap_3
XTAP_TAPCELL_ROW_76_1160 VGND VPWR sky130_fd_sc_hd__tapvpwrvgnd_1
XFILLER_58_85 VGND VGND VPWR VPWR sky130_fd_sc_hd__fill_2
XPHY_EDGE_ROW_58_Left_174 VGND VGND VPWR VPWR sky130_fd_sc_hd__decap_3
XFILLER_114_80 VGND VGND VPWR VPWR sky130_fd_sc_hd__decap_3
XFILLER_114_91 VGND VGND VPWR VPWR sky130_fd_sc_hd__decap_3
XFILLER_74_152 VGND VGND VPWR VPWR sky130_fd_sc_hd__decap_3
XFILLER_90_601 VGND VGND VPWR VPWR sky130_fd_sc_hd__fill_1
XFILLER_74_95 VGND VGND VPWR VPWR sky130_fd_sc_hd__decap_3
XFILLER_90_645 VGND VGND VPWR VPWR sky130_fd_sc_hd__decap_3
XFILLER_43_550 VGND VGND VPWR VPWR sky130_fd_sc_hd__fill_1
XFILLER_43_561 VGND VGND VPWR VPWR sky130_fd_sc_hd__decap_3
XFILLER_43_594 VGND VGND VPWR VPWR sky130_fd_sc_hd__decap_3
XPHY_EDGE_ROW_67_Left_183 VGND VGND VPWR VPWR sky130_fd_sc_hd__decap_3
XTAP_TAPCELL_ROW_41_740 VGND VPWR sky130_fd_sc_hd__tapvpwrvgnd_1
XFILLER_11_491 VGND VGND VPWR VPWR sky130_fd_sc_hd__decap_3
Xwire360 _4879_/B VGND VGND VPWR VPWR wire360/X sky130_fd_sc_hd__buf_4
Xwire371 wire371/A VGND VGND VPWR VPWR wire371/X sky130_fd_sc_hd__buf_4
X_4470_ _4844_/A _4504_/B VGND VGND VPWR VPWR _4470_/Y sky130_fd_sc_hd__nor2_2
X_3421_ _3496_/A _3421_/B VGND VGND VPWR VPWR _3421_/X sky130_fd_sc_hd__or2_2
X_3352_ _5693_/Q _5661_/Q _5629_/Q _5597_/Q _3375_/S _3705_/S1 VGND VGND VPWR VPWR
+ _3352_/X sky130_fd_sc_hd__mux4_2
XFILLER_112_533 VGND VGND VPWR VPWR sky130_fd_sc_hd__fill_1
Xload_slew310 _4040_/B1 VGND VGND VPWR VPWR _4053_/B1 sky130_fd_sc_hd__buf_4
Xfanout909 _5044_/A1 VGND VGND VPWR VPWR _4908_/A1 sky130_fd_sc_hd__clkdlybuf4s25_1
XPHY_EDGE_ROW_76_Left_192 VGND VGND VPWR VPWR sky130_fd_sc_hd__decap_3
Xload_slew343 _4964_/A2 VGND VGND VPWR VPWR _4977_/A2 sky130_fd_sc_hd__buf_4
X_6071_ _6071_/CLK _6071_/D VGND VGND VPWR VPWR _6071_/Q sky130_fd_sc_hd__dfxtp_2
X_3283_ _6041_/Q _5945_/Q _3284_/S VGND VGND VPWR VPWR _3283_/X sky130_fd_sc_hd__mux2_1
XFILLER_66_631 VGND VGND VPWR VPWR sky130_fd_sc_hd__decap_3
XFILLER_85_428 VGND VGND VPWR VPWR sky130_fd_sc_hd__decap_3
X_5022_ _5022_/A1 _5045_/A2 _5045_/B1 _5022_/B2 VGND VGND VPWR VPWR _6046_/D sky130_fd_sc_hd__a22o_2
XFILLER_66_642 VGND VGND VPWR VPWR sky130_fd_sc_hd__fill_2
XFILLER_78_491 VGND VGND VPWR VPWR sky130_fd_sc_hd__decap_3
XTAP_TAPCELL_ROW_49_840 VGND VPWR sky130_fd_sc_hd__tapvpwrvgnd_1
XFILLER_26_517 VGND VGND VPWR VPWR sky130_fd_sc_hd__decap_3
XFILLER_66_675 VGND VGND VPWR VPWR sky130_fd_sc_hd__decap_3
X_5924_ _6052_/CLK _5924_/D VGND VGND VPWR VPWR _5924_/Q sky130_fd_sc_hd__dfxtp_2
XFILLER_110_27 VGND VGND VPWR VPWR sky130_fd_sc_hd__fill_1
XFILLER_110_38 VGND VGND VPWR VPWR sky130_fd_sc_hd__decap_3
X_5855_ _6065_/CLK _5855_/D VGND VGND VPWR VPWR _5855_/Q sky130_fd_sc_hd__dfxtp_2
XFILLER_61_391 VGND VGND VPWR VPWR sky130_fd_sc_hd__fill_1
X_4806_ input16/X _4806_/B VGND VGND VPWR VPWR _5844_/D sky130_fd_sc_hd__and2b_2
X_5786_ _6010_/CLK _5786_/D VGND VGND VPWR VPWR _5786_/Q sky130_fd_sc_hd__dfxtp_2
X_2998_ _5517_/Q _5485_/Q _2998_/S VGND VGND VPWR VPWR _2998_/X sky130_fd_sc_hd__mux2_1
X_4737_ _4771_/A1 wire389/X wire171/X _4737_/B2 VGND VGND VPWR VPWR _5777_/D sky130_fd_sc_hd__a22o_2
XFILLER_107_327 VGND VGND VPWR VPWR sky130_fd_sc_hd__fill_1
X_4668_ _4771_/A1 _4668_/A2 _4668_/B1 _4668_/B2 VGND VGND VPWR VPWR _5713_/D sky130_fd_sc_hd__a22o_2
X_3619_ _3619_/A1 _3616_/X _3618_/X VGND VGND VPWR VPWR _3619_/X sky130_fd_sc_hd__a21o_2
XFILLER_1_605 VGND VGND VPWR VPWR sky130_fd_sc_hd__decap_3
X_4599_ _4904_/A1 _4605_/A2 _4605_/B1 _4599_/B2 VGND VGND VPWR VPWR _5648_/D sky130_fd_sc_hd__a22o_2
XFILLER_103_522 VGND VGND VPWR VPWR sky130_fd_sc_hd__decap_3
XFILLER_1_638 VGND VGND VPWR VPWR sky130_fd_sc_hd__decap_3
XFILLER_103_599 VGND VGND VPWR VPWR sky130_fd_sc_hd__decap_3
XFILLER_48_119 VGND VGND VPWR VPWR sky130_fd_sc_hd__fill_1
XFILLER_57_620 VGND VGND VPWR VPWR sky130_fd_sc_hd__decap_3
XFILLER_28_44 VGND VGND VPWR VPWR sky130_fd_sc_hd__fill_2
XFILLER_28_66 VGND VGND VPWR VPWR sky130_fd_sc_hd__fill_2
XFILLER_29_322 VGND VGND VPWR VPWR sky130_fd_sc_hd__decap_3
XFILLER_29_333 VGND VGND VPWR VPWR sky130_fd_sc_hd__decap_3
XFILLER_57_653 VGND VGND VPWR VPWR sky130_fd_sc_hd__fill_2
Xhold1630 _5905_/Q VGND VGND VPWR VPWR _4871_/B2 sky130_fd_sc_hd__dlygate4sd3_1
Xhold1641 _5078_/Q VGND VGND VPWR VPWR _3982_/B2 sky130_fd_sc_hd__dlygate4sd3_1
Xhold1652 _5076_/Q VGND VGND VPWR VPWR _3980_/B2 sky130_fd_sc_hd__dlygate4sd3_1
XFILLER_28_88 VGND VGND VPWR VPWR sky130_fd_sc_hd__decap_3
XFILLER_56_141 VGND VGND VPWR VPWR sky130_fd_sc_hd__decap_3
XFILLER_57_686 VGND VGND VPWR VPWR sky130_fd_sc_hd__fill_2
XFILLER_72_601 VGND VGND VPWR VPWR sky130_fd_sc_hd__decap_3
XFILLER_84_483 VGND VGND VPWR VPWR sky130_fd_sc_hd__decap_3
Xhold1663 _5436_/Q VGND VGND VPWR VPWR _4373_/B2 sky130_fd_sc_hd__dlygate4sd3_1
Xhold1674 _5898_/Q VGND VGND VPWR VPWR _4864_/B2 sky130_fd_sc_hd__dlygate4sd3_1
Xhold1685 _5323_/Q VGND VGND VPWR VPWR _4251_/B2 sky130_fd_sc_hd__dlygate4sd3_1
Xhold1696 _5396_/Q VGND VGND VPWR VPWR _4328_/B2 sky130_fd_sc_hd__dlygate4sd3_1
XFILLER_44_336 VGND VGND VPWR VPWR sky130_fd_sc_hd__fill_2
XFILLER_71_122 VGND VGND VPWR VPWR sky130_fd_sc_hd__decap_3
XFILLER_72_645 VGND VGND VPWR VPWR sky130_fd_sc_hd__decap_3
XFILLER_32_509 VGND VGND VPWR VPWR sky130_fd_sc_hd__decap_3
XFILLER_44_369 VGND VGND VPWR VPWR sky130_fd_sc_hd__fill_2
XFILLER_71_155 VGND VGND VPWR VPWR sky130_fd_sc_hd__decap_3
XTAP_TAPCELL_ROW_27_578 VGND VPWR sky130_fd_sc_hd__tapvpwrvgnd_1
XFILLER_44_54 VGND VGND VPWR VPWR sky130_fd_sc_hd__decap_3
XFILLER_40_531 VGND VGND VPWR VPWR sky130_fd_sc_hd__fill_1
XFILLER_40_597 VGND VGND VPWR VPWR sky130_fd_sc_hd__decap_3
XFILLER_8_237 VGND VGND VPWR VPWR sky130_fd_sc_hd__decap_3
XFILLER_100_93 VGND VGND VPWR VPWR sky130_fd_sc_hd__decap_3
XFILLER_4_421 VGND VGND VPWR VPWR sky130_fd_sc_hd__fill_1
XFILLER_5_15 VGND VGND VPWR VPWR sky130_fd_sc_hd__decap_3
XFILLER_5_48 VGND VGND VPWR VPWR sky130_fd_sc_hd__decap_3
XFILLER_106_371 VGND VGND VPWR VPWR sky130_fd_sc_hd__decap_3
XFILLER_0_660 VGND VGND VPWR VPWR sky130_fd_sc_hd__decap_3
XFILLER_0_682 VGND VGND VPWR VPWR sky130_fd_sc_hd__decap_3
XFILLER_39_119 VGND VGND VPWR VPWR sky130_fd_sc_hd__fill_1
XFILLER_94_203 VGND VGND VPWR VPWR sky130_fd_sc_hd__decap_3
XPHY_EDGE_ROW_13_Right_13 VGND VGND VPWR VPWR sky130_fd_sc_hd__decap_3
XFILLER_47_152 VGND VGND VPWR VPWR sky130_fd_sc_hd__decap_3
XFILLER_63_645 VGND VGND VPWR VPWR sky130_fd_sc_hd__decap_3
XFILLER_75_494 VGND VGND VPWR VPWR sky130_fd_sc_hd__fill_1
XFILLER_16_550 VGND VGND VPWR VPWR sky130_fd_sc_hd__decap_3
XFILLER_35_358 VGND VGND VPWR VPWR sky130_fd_sc_hd__decap_3
X_3970_ _4695_/A1 wire548/X wire327/X _3970_/B2 VGND VGND VPWR VPWR _5066_/D sky130_fd_sc_hd__a22o_2
X_2921_ _2497_/B _2918_/X _2920_/X _3229_/A1 VGND VGND VPWR VPWR _2921_/X sky130_fd_sc_hd__a22o_2
XFILLER_31_564 VGND VGND VPWR VPWR sky130_fd_sc_hd__decap_3
X_5640_ _5704_/CLK _5640_/D VGND VGND VPWR VPWR _5640_/Q sky130_fd_sc_hd__dfxtp_2
X_2852_ _6055_/Q _5959_/Q _2919_/S VGND VGND VPWR VPWR _2852_/X sky130_fd_sc_hd__mux2_1
XPHY_EDGE_ROW_22_Right_22 VGND VGND VPWR VPWR sky130_fd_sc_hd__decap_3
X_5571_ _5571_/CLK _5571_/D VGND VGND VPWR VPWR _5571_/Q sky130_fd_sc_hd__dfxtp_2
X_2783_ _5828_/Q _5444_/Q _3159_/S VGND VGND VPWR VPWR _2783_/X sky130_fd_sc_hd__mux2_1
X_4522_ _4659_/A1 _4528_/A2 _4528_/B1 _4522_/B2 VGND VGND VPWR VPWR _5576_/D sky130_fd_sc_hd__a22o_2
X_4453_ _4727_/A1 _4469_/A2 _4453_/B1 _4453_/B2 VGND VGND VPWR VPWR _5511_/D sky130_fd_sc_hd__a22o_2
XPHY_EDGE_ROW_84_Left_200 VGND VGND VPWR VPWR sky130_fd_sc_hd__decap_3
X_3404_ _3404_/A _3404_/B VGND VGND VPWR VPWR _3404_/X sky130_fd_sc_hd__or2_2
XTAP_TAPCELL_ROW_96_1399 VGND VPWR sky130_fd_sc_hd__tapvpwrvgnd_1
Xfanout706 _3597_/S VGND VGND VPWR VPWR _3305_/A sky130_fd_sc_hd__clkdlybuf4s25_1
X_4384_ _4727_/A1 wire459/X _4400_/B1 _4384_/B2 VGND VGND VPWR VPWR _5447_/D sky130_fd_sc_hd__a22o_2
Xfanout728 _3108_/A VGND VGND VPWR VPWR _3005_/A1 sky130_fd_sc_hd__dlymetal6s2s_1
Xfanout717 _3941_/A VGND VGND VPWR VPWR _3800_/A sky130_fd_sc_hd__dlymetal6s4s_1
X_3335_ _3335_/A1 _3331_/X _3334_/X _3843_/C1 VGND VGND VPWR VPWR _3335_/X sky130_fd_sc_hd__o211a_2
XFILLER_100_514 VGND VGND VPWR VPWR sky130_fd_sc_hd__decap_3
XFILLER_100_536 VGND VGND VPWR VPWR sky130_fd_sc_hd__decap_3
XFILLER_105_27 VGND VGND VPWR VPWR sky130_fd_sc_hd__decap_3
XFILLER_58_417 VGND VGND VPWR VPWR sky130_fd_sc_hd__decap_3
XFILLER_85_225 VGND VGND VPWR VPWR sky130_fd_sc_hd__fill_1
XFILLER_98_586 VGND VGND VPWR VPWR sky130_fd_sc_hd__fill_2
XPHY_EDGE_ROW_31_Right_31 VGND VGND VPWR VPWR sky130_fd_sc_hd__decap_3
Xload_slew173 _4706_/B1 VGND VGND VPWR VPWR _4699_/B1 sky130_fd_sc_hd__clkbuf_4
X_6054_ _6061_/CLK _6054_/D VGND VGND VPWR VPWR _6054_/Q sky130_fd_sc_hd__dfxtp_2
X_3266_ _5497_/Q _5465_/Q _3284_/S VGND VGND VPWR VPWR _3266_/X sky130_fd_sc_hd__mux2_1
XFILLER_105_49 VGND VGND VPWR VPWR sky130_fd_sc_hd__decap_3
X_5005_ _5005_/A1 _5010_/A2 _5012_/B1 _5005_/B2 VGND VGND VPWR VPWR _6031_/D sky130_fd_sc_hd__a22o_2
X_3197_ _5718_/Q _5686_/Q _5654_/Q _5622_/Q _3199_/S _3202_/S1 VGND VGND VPWR VPWR
+ _3198_/B sky130_fd_sc_hd__mux4_2
XFILLER_54_645 VGND VGND VPWR VPWR sky130_fd_sc_hd__decap_3
X_5907_ _6067_/CLK _5907_/D VGND VGND VPWR VPWR _5907_/Q sky130_fd_sc_hd__dfxtp_2
XTAP_TAPCELL_ROW_24_537 VGND VPWR sky130_fd_sc_hd__tapvpwrvgnd_1
XTAP_TAPCELL_ROW_52_868 VGND VPWR sky130_fd_sc_hd__tapvpwrvgnd_1
XFILLER_22_564 VGND VGND VPWR VPWR sky130_fd_sc_hd__decap_3
XPHY_EDGE_ROW_40_Right_40 VGND VGND VPWR VPWR sky130_fd_sc_hd__decap_3
XTAP_TAPCELL_ROW_52_879 VGND VPWR sky130_fd_sc_hd__tapvpwrvgnd_1
X_5838_ _5838_/CLK _5838_/D VGND VGND VPWR VPWR _5838_/Q sky130_fd_sc_hd__dfxtp_2
XFILLER_14_79 VGND VGND VPWR VPWR sky130_fd_sc_hd__decap_3
X_5769_ clkload9/A _5769_/D VGND VGND VPWR VPWR _5769_/Q sky130_fd_sc_hd__dfxtp_2
XFILLER_108_603 VGND VGND VPWR VPWR sky130_fd_sc_hd__decap_3
XFILLER_107_135 VGND VGND VPWR VPWR sky130_fd_sc_hd__decap_3
XFILLER_108_669 VGND VGND VPWR VPWR sky130_fd_sc_hd__decap_3
XTAP_TAPCELL_ROW_73_1130 VGND VPWR sky130_fd_sc_hd__tapvpwrvgnd_1
XFILLER_39_43 VGND VGND VPWR VPWR sky130_fd_sc_hd__decap_3
XFILLER_89_597 VGND VGND VPWR VPWR sky130_fd_sc_hd__fill_2
Xhold2150 _5842_/Q VGND VGND VPWR VPWR _4804_/B sky130_fd_sc_hd__dlygate4sd3_1
Xhold2161 _5832_/Q VGND VGND VPWR VPWR _4794_/B sky130_fd_sc_hd__dlygate4sd3_1
Xhold1460 _5859_/Q VGND VGND VPWR VPWR _4823_/B2 sky130_fd_sc_hd__dlygate4sd3_1
XFILLER_44_122 VGND VGND VPWR VPWR sky130_fd_sc_hd__fill_2
XFILLER_45_634 VGND VGND VPWR VPWR sky130_fd_sc_hd__decap_3
XFILLER_45_645 VGND VGND VPWR VPWR sky130_fd_sc_hd__decap_3
XFILLER_91_228 VGND VGND VPWR VPWR sky130_fd_sc_hd__fill_1
XTAP_TAPCELL_ROW_4_295 VGND VPWR sky130_fd_sc_hd__tapvpwrvgnd_1
Xhold1471 _5119_/Q VGND VGND VPWR VPWR _4031_/B2 sky130_fd_sc_hd__dlygate4sd3_1
Xhold1482 _5736_/Q VGND VGND VPWR VPWR _4693_/B2 sky130_fd_sc_hd__dlygate4sd3_1
Xhold1493 _5997_/Q VGND VGND VPWR VPWR _4969_/B2 sky130_fd_sc_hd__dlygate4sd3_1
XFILLER_44_155 VGND VGND VPWR VPWR sky130_fd_sc_hd__fill_1
XFILLER_45_667 VGND VGND VPWR VPWR sky130_fd_sc_hd__decap_3
XFILLER_60_604 VGND VGND VPWR VPWR sky130_fd_sc_hd__decap_3
XFILLER_32_306 VGND VGND VPWR VPWR sky130_fd_sc_hd__fill_2
XFILLER_60_637 VGND VGND VPWR VPWR sky130_fd_sc_hd__decap_3
XFILLER_60_648 VGND VGND VPWR VPWR sky130_fd_sc_hd__decap_3
XFILLER_111_81 VGND VGND VPWR VPWR sky130_fd_sc_hd__decap_3
XFILLER_13_586 VGND VGND VPWR VPWR sky130_fd_sc_hd__decap_3
XFILLER_71_63 VGND VGND VPWR VPWR sky130_fd_sc_hd__fill_1
XFILLER_9_524 VGND VGND VPWR VPWR sky130_fd_sc_hd__fill_2
XFILLER_9_557 VGND VGND VPWR VPWR sky130_fd_sc_hd__decap_3
XFILLER_114_628 VGND VGND VPWR VPWR sky130_fd_sc_hd__decap_3
XFILLER_99_317 VGND VGND VPWR VPWR sky130_fd_sc_hd__decap_3
XFILLER_67_225 VGND VGND VPWR VPWR sky130_fd_sc_hd__fill_1
X_3120_ _5715_/Q _5683_/Q _5651_/Q _5619_/Q _3122_/S _3180_/S1 VGND VGND VPWR VPWR
+ _3120_/X sky130_fd_sc_hd__mux4_2
XFILLER_36_601 VGND VGND VPWR VPWR sky130_fd_sc_hd__decap_3
XFILLER_82_217 VGND VGND VPWR VPWR sky130_fd_sc_hd__decap_3
X_3051_ _3040_/X _3049_/X _3050_/X wire570/X VGND VGND VPWR VPWR _3051_/X sky130_fd_sc_hd__o31a_2
XFILLER_36_656 VGND VGND VPWR VPWR sky130_fd_sc_hd__fill_2
XFILLER_51_637 VGND VGND VPWR VPWR sky130_fd_sc_hd__decap_3
XFILLER_63_486 VGND VGND VPWR VPWR sky130_fd_sc_hd__fill_1
X_3953_ _5017_/A1 _3981_/A2 wire322/X _3953_/B2 VGND VGND VPWR VPWR _5049_/D sky130_fd_sc_hd__a22o_2
XTAP_TAPCELL_ROW_21_507 VGND VPWR sky130_fd_sc_hd__tapvpwrvgnd_1
X_3884_ _6069_/Q _5973_/Q _3895_/S VGND VGND VPWR VPWR _3884_/X sky130_fd_sc_hd__mux2_1
X_2904_ _2904_/A1 _2901_/X _2903_/X _2516_/B VGND VGND VPWR VPWR _2904_/X sky130_fd_sc_hd__o211a_2
X_5623_ _6071_/CLK _5623_/D VGND VGND VPWR VPWR _5623_/Q sky130_fd_sc_hd__dfxtp_2
X_2835_ _5574_/Q _5542_/Q _3099_/S VGND VGND VPWR VPWR _2835_/X sky130_fd_sc_hd__mux2_1
XTAP_TAPCELL_ROW_98_1428 VGND VPWR sky130_fd_sc_hd__tapvpwrvgnd_1
X_5554_ _6045_/CLK _5554_/D VGND VGND VPWR VPWR _5554_/Q sky130_fd_sc_hd__dfxtp_2
X_2766_ _5507_/Q _5475_/Q _3026_/S VGND VGND VPWR VPWR _2766_/X sky130_fd_sc_hd__mux2_1
XFILLER_105_617 VGND VGND VPWR VPWR sky130_fd_sc_hd__fill_1
X_5485_ _5885_/CLK _5485_/D VGND VGND VPWR VPWR _5485_/Q sky130_fd_sc_hd__dfxtp_2
X_4505_ _4913_/A _4505_/B VGND VGND VPWR VPWR _4505_/Y sky130_fd_sc_hd__nor2_2
X_2697_ _6048_/Q _5952_/Q _2760_/S VGND VGND VPWR VPWR _2697_/X sky130_fd_sc_hd__mux2_1
X_4436_ _5014_/A _4504_/B VGND VGND VPWR VPWR _4436_/Y sky130_fd_sc_hd__nor2_2
XFILLER_113_650 VGND VGND VPWR VPWR sky130_fd_sc_hd__decap_3
Xfanout503 fanout509/X VGND VGND VPWR VPWR _4145_/A2 sky130_fd_sc_hd__clkdlybuf4s25_1
X_4367_ _4844_/A _5014_/B VGND VGND VPWR VPWR _4367_/Y sky130_fd_sc_hd__nor2_2
XFILLER_58_203 VGND VGND VPWR VPWR sky130_fd_sc_hd__decap_3
XFILLER_86_523 VGND VGND VPWR VPWR sky130_fd_sc_hd__decap_3
Xfanout547 _3950_/Y VGND VGND VPWR VPWR wire548/A sky130_fd_sc_hd__clkdlybuf4s25_1
Xfanout536 _3987_/Y VGND VGND VPWR VPWR _4015_/A2 sky130_fd_sc_hd__clkdlybuf4s25_1
Xfanout525 _4058_/Y VGND VGND VPWR VPWR wire526/A sky130_fd_sc_hd__clkdlybuf4s25_1
X_3318_ _5403_/Q _5051_/Q _3318_/S VGND VGND VPWR VPWR _3318_/X sky130_fd_sc_hd__mux2_1
XFILLER_100_333 VGND VGND VPWR VPWR sky130_fd_sc_hd__decap_3
Xfanout569 _2499_/X VGND VGND VPWR VPWR wire570/A sky130_fd_sc_hd__clkbuf_2
Xfanout558 fanout560/A VGND VGND VPWR VPWR wire559/A sky130_fd_sc_hd__clkdlybuf4s25_1
X_4298_ _4878_/A _4298_/B VGND VGND VPWR VPWR _4298_/Y sky130_fd_sc_hd__nor2_2
XFILLER_86_589 VGND VGND VPWR VPWR sky130_fd_sc_hd__decap_3
X_6037_ _6037_/CLK _6037_/D VGND VGND VPWR VPWR _6037_/Q sky130_fd_sc_hd__dfxtp_2
X_3249_ _3763_/A _3247_/X _3922_/B1 VGND VGND VPWR VPWR _3249_/X sky130_fd_sc_hd__o21a_2
XFILLER_100_399 VGND VGND VPWR VPWR sky130_fd_sc_hd__decap_3
XFILLER_39_472 VGND VGND VPWR VPWR sky130_fd_sc_hd__fill_1
XFILLER_73_228 VGND VGND VPWR VPWR sky130_fd_sc_hd__fill_1
XFILLER_92_18 VGND VGND VPWR VPWR sky130_fd_sc_hd__decap_3
XTAP_TAPCELL_ROW_57_938 VGND VPWR sky130_fd_sc_hd__tapvpwrvgnd_1
XFILLER_42_604 VGND VGND VPWR VPWR sky130_fd_sc_hd__decap_3
XFILLER_92_29 VGND VGND VPWR VPWR sky130_fd_sc_hd__fill_1
XTAP_TAPCELL_ROW_107_1535 VGND VPWR sky130_fd_sc_hd__tapvpwrvgnd_1
XTAP_TAPCELL_ROW_1_265 VGND VPWR sky130_fd_sc_hd__tapvpwrvgnd_1
XFILLER_42_637 VGND VGND VPWR VPWR sky130_fd_sc_hd__decap_3
XFILLER_25_67 VGND VGND VPWR VPWR sky130_fd_sc_hd__fill_1
XFILLER_41_147 VGND VGND VPWR VPWR sky130_fd_sc_hd__decap_3
XTAP_TAPCELL_ROW_37_695 VGND VPWR sky130_fd_sc_hd__tapvpwrvgnd_1
XFILLER_22_361 VGND VGND VPWR VPWR sky130_fd_sc_hd__decap_3
XFILLER_10_545 VGND VGND VPWR VPWR sky130_fd_sc_hd__decap_3
XFILLER_41_44 VGND VGND VPWR VPWR sky130_fd_sc_hd__decap_3
XFILLER_10_589 VGND VGND VPWR VPWR sky130_fd_sc_hd__decap_3
XFILLER_41_77 VGND VGND VPWR VPWR sky130_fd_sc_hd__fill_1
XFILLER_104_650 VGND VGND VPWR VPWR sky130_fd_sc_hd__fill_2
XFILLER_96_309 VGND VGND VPWR VPWR sky130_fd_sc_hd__decap_3
XTAP_TAPCELL_ROW_9_354 VGND VPWR sky130_fd_sc_hd__tapvpwrvgnd_1
XFILLER_104_672 VGND VGND VPWR VPWR sky130_fd_sc_hd__decap_3
XFILLER_2_27 VGND VGND VPWR VPWR sky130_fd_sc_hd__fill_1
XFILLER_2_38 VGND VGND VPWR VPWR sky130_fd_sc_hd__decap_3
XFILLER_49_225 VGND VGND VPWR VPWR sky130_fd_sc_hd__decap_3
XFILLER_77_589 VGND VGND VPWR VPWR sky130_fd_sc_hd__decap_3
XFILLER_66_85 VGND VGND VPWR VPWR sky130_fd_sc_hd__fill_1
Xhold1290 _5325_/Q VGND VGND VPWR VPWR _4253_/B2 sky130_fd_sc_hd__dlygate4sd3_1
XFILLER_17_188 VGND VGND VPWR VPWR sky130_fd_sc_hd__fill_1
XFILLER_45_486 VGND VGND VPWR VPWR sky130_fd_sc_hd__decap_3
XTAP_TAPCELL_ROW_82_1229 VGND VPWR sky130_fd_sc_hd__tapvpwrvgnd_1
XFILLER_32_125 VGND VGND VPWR VPWR sky130_fd_sc_hd__decap_3
XFILLER_32_136 VGND VGND VPWR VPWR sky130_fd_sc_hd__decap_3
XFILLER_32_147 VGND VGND VPWR VPWR sky130_fd_sc_hd__decap_3
XFILLER_13_350 VGND VGND VPWR VPWR sky130_fd_sc_hd__decap_3
XFILLER_70_6 VGND VGND VPWR VPWR sky130_fd_sc_hd__fill_1
X_2620_ _5373_/Q _5341_/Q _5309_/Q _5277_/Q _2660_/S _2996_/S1 VGND VGND VPWR VPWR
+ _2620_/X sky130_fd_sc_hd__mux4_2
Xoutput106 _3946_/X VGND VGND VPWR VPWR rd2[31] sky130_fd_sc_hd__dlymetal6s4s_1
X_2551_ _5370_/Q _5338_/Q _5306_/Q _5274_/Q _3115_/S _3113_/S1 VGND VGND VPWR VPWR
+ _2551_/X sky130_fd_sc_hd__mux4_2
X_5270_ _6021_/CLK _5270_/D VGND VGND VPWR VPWR _5270_/Q sky130_fd_sc_hd__dfxtp_2
XFILLER_49_3 VGND VGND VPWR VPWR sky130_fd_sc_hd__decap_3
XFILLER_99_169 VGND VGND VPWR VPWR sky130_fd_sc_hd__fill_2
X_4221_ _4529_/A1 _4226_/A2 _4226_/B1 _4221_/B2 VGND VGND VPWR VPWR _5295_/D sky130_fd_sc_hd__a22o_2
XTAP_TAPCELL_ROW_93_1369 VGND VPWR sky130_fd_sc_hd__tapvpwrvgnd_1
X_4152_ _5005_/A1 _4154_/A2 _4157_/B1 _4152_/B2 VGND VGND VPWR VPWR _5231_/D sky130_fd_sc_hd__a22o_2
XFILLER_110_675 VGND VGND VPWR VPWR sky130_fd_sc_hd__decap_3
XFILLER_68_567 VGND VGND VPWR VPWR sky130_fd_sc_hd__decap_3
XFILLER_68_589 VGND VGND VPWR VPWR sky130_fd_sc_hd__decap_3
X_4083_ _5005_/A1 _4085_/A2 _4088_/B1 _4083_/B2 VGND VGND VPWR VPWR _5167_/D sky130_fd_sc_hd__a22o_2
X_3103_ _5202_/Q _5170_/Q _3104_/S VGND VGND VPWR VPWR _3103_/X sky130_fd_sc_hd__mux2_1
X_3034_ _3044_/A _3031_/X _3033_/X _3146_/B2 VGND VGND VPWR VPWR _3034_/X sky130_fd_sc_hd__a22o_2
XFILLER_48_291 VGND VGND VPWR VPWR sky130_fd_sc_hd__fill_1
XFILLER_83_559 VGND VGND VPWR VPWR sky130_fd_sc_hd__fill_1
XFILLER_23_103 VGND VGND VPWR VPWR sky130_fd_sc_hd__decap_3
XFILLER_23_147 VGND VGND VPWR VPWR sky130_fd_sc_hd__decap_3
X_4985_ _4985_/A1 _5011_/A2 _5011_/B1 _4985_/B2 VGND VGND VPWR VPWR _6011_/D sky130_fd_sc_hd__a22o_2
XTAP_TAPCELL_ROW_34_654 VGND VPWR sky130_fd_sc_hd__tapvpwrvgnd_1
X_3936_ _5207_/Q _5175_/Q _3936_/S VGND VGND VPWR VPWR _3936_/X sky130_fd_sc_hd__mux2_1
XTAP_TAPCELL_ROW_102_1476 VGND VPWR sky130_fd_sc_hd__tapvpwrvgnd_1
XTAP_TAPCELL_ROW_62_996 VGND VPWR sky130_fd_sc_hd__tapvpwrvgnd_1
XFILLER_109_208 VGND VGND VPWR VPWR sky130_fd_sc_hd__decap_3
XPHY_EDGE_ROW_12_Left_128 VGND VGND VPWR VPWR sky130_fd_sc_hd__decap_3
X_3867_ _3867_/A _3867_/B VGND VGND VPWR VPWR _3867_/X sky130_fd_sc_hd__or2_2
X_5606_ _5790_/CLK _5606_/D VGND VGND VPWR VPWR _5606_/Q sky130_fd_sc_hd__dfxtp_2
X_3798_ _3806_/A _3797_/X _3796_/X _3248_/X VGND VGND VPWR VPWR _3798_/X sky130_fd_sc_hd__o211a_2
X_2818_ _5189_/Q _5157_/Q _2856_/S VGND VGND VPWR VPWR _2818_/X sky130_fd_sc_hd__mux2_1
X_5537_ _6058_/CLK _5537_/D VGND VGND VPWR VPWR _5537_/Q sky130_fd_sc_hd__dfxtp_2
X_2749_ _5410_/Q _5058_/Q _3110_/S VGND VGND VPWR VPWR _2749_/X sky130_fd_sc_hd__mux2_1
XFILLER_105_436 VGND VGND VPWR VPWR sky130_fd_sc_hd__decap_3
XFILLER_2_9 VGND VGND VPWR VPWR sky130_fd_sc_hd__decap_3
X_5468_ _5500_/CLK _5468_/D VGND VGND VPWR VPWR _5468_/Q sky130_fd_sc_hd__dfxtp_2
XFILLER_59_501 VGND VGND VPWR VPWR sky130_fd_sc_hd__decap_3
XFILLER_99_670 VGND VGND VPWR VPWR sky130_fd_sc_hd__fill_2
XFILLER_99_681 VGND VGND VPWR VPWR sky130_fd_sc_hd__decap_3
XTAP_TAPCELL_ROW_6_324 VGND VPWR sky130_fd_sc_hd__tapvpwrvgnd_1
Xfanout311 _4023_/Y VGND VGND VPWR VPWR _4050_/B1 sky130_fd_sc_hd__clkdlybuf4s25_1
X_5399_ _5879_/CLK _5399_/D VGND VGND VPWR VPWR _5399_/Q sky130_fd_sc_hd__dfxtp_2
X_4419_ _4727_/A1 _4435_/A2 _4419_/B1 _4419_/B2 VGND VGND VPWR VPWR _5479_/D sky130_fd_sc_hd__a22o_2
Xfanout366 _4870_/A2 VGND VGND VPWR VPWR _4845_/B sky130_fd_sc_hd__clkdlybuf4s25_1
Xfanout344 _4946_/Y VGND VGND VPWR VPWR _4974_/A2 sky130_fd_sc_hd__clkdlybuf4s25_1
Xfanout333 _5014_/Y VGND VGND VPWR VPWR wire334/A sky130_fd_sc_hd__clkdlybuf4s25_1
XFILLER_100_141 VGND VGND VPWR VPWR sky130_fd_sc_hd__fill_2
XFILLER_100_152 VGND VGND VPWR VPWR sky130_fd_sc_hd__fill_2
XPHY_EDGE_ROW_21_Left_137 VGND VGND VPWR VPWR sky130_fd_sc_hd__decap_3
Xfanout399 _4641_/Y VGND VGND VPWR VPWR wire400/A sky130_fd_sc_hd__clkdlybuf4s25_1
Xfanout388 _4736_/A2 VGND VGND VPWR VPWR _4711_/B sky130_fd_sc_hd__clkdlybuf4s25_1
XFILLER_14_103 VGND VGND VPWR VPWR sky130_fd_sc_hd__decap_3
XTAP_TAPCELL_ROW_68_1062 VGND VPWR sky130_fd_sc_hd__tapvpwrvgnd_1
XFILLER_14_136 VGND VGND VPWR VPWR sky130_fd_sc_hd__decap_3
XFILLER_27_497 VGND VGND VPWR VPWR sky130_fd_sc_hd__decap_3
XFILLER_14_147 VGND VGND VPWR VPWR sky130_fd_sc_hd__decap_3
XFILLER_42_456 VGND VGND VPWR VPWR sky130_fd_sc_hd__decap_3
XPHY_EDGE_ROW_30_Left_146 VGND VGND VPWR VPWR sky130_fd_sc_hd__decap_3
XFILLER_22_180 VGND VGND VPWR VPWR sky130_fd_sc_hd__decap_3
Xinput19 wd[11] VGND VGND VPWR VPWR input19/X sky130_fd_sc_hd__clkdlybuf4s25_1
XFILLER_6_335 VGND VGND VPWR VPWR sky130_fd_sc_hd__decap_3
XFILLER_6_368 VGND VGND VPWR VPWR sky130_fd_sc_hd__decap_3
XFILLER_108_274 VGND VGND VPWR VPWR sky130_fd_sc_hd__decap_3
XFILLER_97_629 VGND VGND VPWR VPWR sky130_fd_sc_hd__decap_3
Xload_slew739 _3215_/A VGND VGND VPWR VPWR _3081_/A sky130_fd_sc_hd__buf_4
XFILLER_104_480 VGND VGND VPWR VPWR sky130_fd_sc_hd__decap_3
XFILLER_89_180 VGND VGND VPWR VPWR sky130_fd_sc_hd__fill_1
XFILLER_37_228 VGND VGND VPWR VPWR sky130_fd_sc_hd__decap_3
XFILLER_92_345 VGND VGND VPWR VPWR sky130_fd_sc_hd__decap_3
XFILLER_80_518 VGND VGND VPWR VPWR sky130_fd_sc_hd__decap_3
XFILLER_93_83 VGND VGND VPWR VPWR sky130_fd_sc_hd__decap_3
XFILLER_33_467 VGND VGND VPWR VPWR sky130_fd_sc_hd__fill_1
XFILLER_60_242 VGND VGND VPWR VPWR sky130_fd_sc_hd__fill_1
XFILLER_60_253 VGND VGND VPWR VPWR sky130_fd_sc_hd__fill_2
XFILLER_14_681 VGND VGND VPWR VPWR sky130_fd_sc_hd__decap_3
XTAP_TAPCELL_ROW_31_624 VGND VPWR sky130_fd_sc_hd__tapvpwrvgnd_1
X_4770_ _4904_/A1 _4776_/A2 _4776_/B1 _4770_/B2 VGND VGND VPWR VPWR _5808_/D sky130_fd_sc_hd__a22o_2
X_3721_ _5805_/Q _5741_/Q _3721_/S VGND VGND VPWR VPWR _3721_/X sky130_fd_sc_hd__mux2_1
XFILLER_9_162 VGND VGND VPWR VPWR sky130_fd_sc_hd__decap_3
X_3652_ _5930_/Q _5898_/Q _5866_/Q _5770_/Q _3683_/S _3808_/S1 VGND VGND VPWR VPWR
+ _3652_/X sky130_fd_sc_hd__mux4_2
XFILLER_9_195 VGND VGND VPWR VPWR sky130_fd_sc_hd__decap_3
XTAP_TAPCELL_ROW_11_381 VGND VPWR sky130_fd_sc_hd__tapvpwrvgnd_1
X_3583_ _5927_/Q _5895_/Q _5863_/Q _5767_/Q _3929_/S0 _3239_/B VGND VGND VPWR VPWR
+ _3584_/B sky130_fd_sc_hd__mux4_2
X_2603_ _5916_/Q _5884_/Q _5852_/Q _5756_/Q _2604_/S _2911_/S1 VGND VGND VPWR VPWR
+ _2603_/X sky130_fd_sc_hd__mux4_2
X_5322_ _6033_/CLK _5322_/D VGND VGND VPWR VPWR _5322_/Q sky130_fd_sc_hd__dfxtp_2
X_2534_ _5241_/Q _5209_/Q _2534_/S VGND VGND VPWR VPWR _2534_/X sky130_fd_sc_hd__mux2_1
X_5253_ _6033_/CLK _5253_/D VGND VGND VPWR VPWR _5253_/Q sky130_fd_sc_hd__dfxtp_2
XFILLER_114_288 VGND VGND VPWR VPWR sky130_fd_sc_hd__decap_3
X_5184_ _6030_/CLK _5184_/D VGND VGND VPWR VPWR _5184_/Q sky130_fd_sc_hd__dfxtp_2
X_4204_ _4886_/A1 _4224_/A2 _4227_/B1 _4204_/B2 VGND VGND VPWR VPWR _5278_/D sky130_fd_sc_hd__a22o_2
X_4135_ _4988_/A1 _4155_/A2 wire292/X _4135_/B2 VGND VGND VPWR VPWR _5214_/D sky130_fd_sc_hd__a22o_2
XFILLER_113_16 VGND VGND VPWR VPWR sky130_fd_sc_hd__decap_3
XFILLER_95_172 VGND VGND VPWR VPWR sky130_fd_sc_hd__decap_3
XTAP_TAPCELL_ROW_39_713 VGND VPWR sky130_fd_sc_hd__tapvpwrvgnd_1
XFILLER_113_49 VGND VGND VPWR VPWR sky130_fd_sc_hd__decap_3
X_4066_ _4988_/A1 wire524/X wire306/X _4066_/B2 VGND VGND VPWR VPWR _5150_/D sky130_fd_sc_hd__a22o_2
XFILLER_83_378 VGND VGND VPWR VPWR sky130_fd_sc_hd__decap_3
X_3017_ _3019_/A _3013_/X _3016_/X _3017_/C1 VGND VGND VPWR VPWR _3017_/X sky130_fd_sc_hd__o211a_2
XFILLER_64_592 VGND VGND VPWR VPWR sky130_fd_sc_hd__decap_3
XTAP_TAPCELL_ROW_19_481 VGND VPWR sky130_fd_sc_hd__tapvpwrvgnd_1
X_4968_ _5002_/A1 _4979_/A2 _4979_/B1 _4968_/B2 VGND VGND VPWR VPWR _5996_/D sky130_fd_sc_hd__a22o_2
X_4899_ _4899_/A1 _4904_/A2 _4908_/B1 _4899_/B2 VGND VGND VPWR VPWR _5931_/D sky130_fd_sc_hd__a22o_2
X_3919_ _5846_/Q _5462_/Q _6070_/Q _5974_/Q _3915_/S _3919_/S1 VGND VGND VPWR VPWR
+ _3920_/B sky130_fd_sc_hd__mux4_2
XFILLER_22_68 VGND VGND VPWR VPWR sky130_fd_sc_hd__fill_1
XFILLER_3_316 VGND VGND VPWR VPWR sky130_fd_sc_hd__decap_3
XTAP_TAPCELL_ROW_115_1634 VGND VPWR sky130_fd_sc_hd__tapvpwrvgnd_1
XTAP_TAPCELL_ROW_115_1645 VGND VPWR sky130_fd_sc_hd__tapvpwrvgnd_1
XFILLER_0_6 VGND VGND VPWR VPWR sky130_fd_sc_hd__decap_3
XFILLER_105_244 VGND VGND VPWR VPWR sky130_fd_sc_hd__fill_2
Xfanout1117 _3689_/S VGND VGND VPWR VPWR _3929_/S0 sky130_fd_sc_hd__dlymetal6s4s_1
Xfanout1106 _3858_/S VGND VGND VPWR VPWR _3857_/S sky130_fd_sc_hd__clkdlybuf4s25_1
XFILLER_87_673 VGND VGND VPWR VPWR sky130_fd_sc_hd__decap_3
Xfanout174 _4676_/Y VGND VGND VPWR VPWR _4707_/B1 sky130_fd_sc_hd__clkdlybuf4s25_1
Xfanout152 _4811_/Y VGND VGND VPWR VPWR wire153/A sky130_fd_sc_hd__clkdlybuf4s25_1
Xfanout141 _4879_/Y VGND VGND VPWR VPWR _4895_/B1 sky130_fd_sc_hd__clkdlybuf4s25_1
XFILLER_19_228 VGND VGND VPWR VPWR sky130_fd_sc_hd__fill_2
XFILLER_47_537 VGND VGND VPWR VPWR sky130_fd_sc_hd__decap_3
Xfanout185 _4608_/Y VGND VGND VPWR VPWR wire186/A sky130_fd_sc_hd__clkdlybuf4s25_1
XFILLER_47_559 VGND VGND VPWR VPWR sky130_fd_sc_hd__fill_1
XFILLER_55_570 VGND VGND VPWR VPWR sky130_fd_sc_hd__decap_3
XFILLER_15_445 VGND VGND VPWR VPWR sky130_fd_sc_hd__decap_3
XFILLER_15_467 VGND VGND VPWR VPWR sky130_fd_sc_hd__decap_3
XPHY_EDGE_ROW_69_Right_69 VGND VGND VPWR VPWR sky130_fd_sc_hd__decap_3
XFILLER_70_595 VGND VGND VPWR VPWR sky130_fd_sc_hd__decap_3
XFILLER_8_15 VGND VGND VPWR VPWR sky130_fd_sc_hd__decap_3
XFILLER_11_673 VGND VGND VPWR VPWR sky130_fd_sc_hd__decap_3
XFILLER_7_611 VGND VGND VPWR VPWR sky130_fd_sc_hd__decap_3
XFILLER_8_59 VGND VGND VPWR VPWR sky130_fd_sc_hd__decap_3
XFILLER_10_194 VGND VGND VPWR VPWR sky130_fd_sc_hd__fill_2
Xwire553 wire553/A VGND VGND VPWR VPWR wire553/X sky130_fd_sc_hd__clkbuf_4
XFILLER_109_572 VGND VGND VPWR VPWR sky130_fd_sc_hd__decap_3
XFILLER_109_583 VGND VGND VPWR VPWR sky130_fd_sc_hd__decap_3
XPHY_EDGE_ROW_78_Right_78 VGND VGND VPWR VPWR sky130_fd_sc_hd__decap_3
XFILLER_88_61 VGND VGND VPWR VPWR sky130_fd_sc_hd__decap_3
XFILLER_97_415 VGND VGND VPWR VPWR sky130_fd_sc_hd__decap_3
XFILLER_97_426 VGND VGND VPWR VPWR sky130_fd_sc_hd__decap_3
Xload_slew514 _4120_/A2 VGND VGND VPWR VPWR _4094_/B sky130_fd_sc_hd__buf_2
XTAP_TAPCELL_ROW_90_1328 VGND VPWR sky130_fd_sc_hd__tapvpwrvgnd_1
XFILLER_111_225 VGND VGND VPWR VPWR sky130_fd_sc_hd__decap_3
XFILLER_33_6 VGND VGND VPWR VPWR sky130_fd_sc_hd__decap_3
XFILLER_78_640 VGND VGND VPWR VPWR sky130_fd_sc_hd__decap_3
XFILLER_65_323 VGND VGND VPWR VPWR sky130_fd_sc_hd__fill_1
XFILLER_93_687 VGND VGND VPWR VPWR sky130_fd_sc_hd__fill_1
X_5940_ _6068_/CLK _5940_/D VGND VGND VPWR VPWR _5940_/Q sky130_fd_sc_hd__dfxtp_2
XFILLER_80_359 VGND VGND VPWR VPWR sky130_fd_sc_hd__decap_3
XFILLER_92_197 VGND VGND VPWR VPWR sky130_fd_sc_hd__decap_3
XPHY_EDGE_ROW_87_Right_87 VGND VGND VPWR VPWR sky130_fd_sc_hd__decap_3
XTAP_TAPCELL_ROW_16_440 VGND VPWR sky130_fd_sc_hd__tapvpwrvgnd_1
X_5871_ _5871_/CLK _5871_/D VGND VGND VPWR VPWR _5871_/Q sky130_fd_sc_hd__dfxtp_2
XTAP_TAPCELL_ROW_44_782 VGND VPWR sky130_fd_sc_hd__tapvpwrvgnd_1
X_4822_ _4822_/A1 _4841_/A2 _4841_/B1 _4822_/B2 VGND VGND VPWR VPWR _5858_/D sky130_fd_sc_hd__a22o_2
X_4753_ _4753_/A1 _4772_/A2 _4772_/B1 _4753_/B2 VGND VGND VPWR VPWR _5791_/D sky130_fd_sc_hd__a22o_2
X_3704_ _3697_/X _3703_/X _3946_/B1 VGND VGND VPWR VPWR _3704_/X sky130_fd_sc_hd__o21a_2
X_4684_ _4753_/A1 _4703_/A2 _4703_/B1 _4684_/B2 VGND VGND VPWR VPWR _5727_/D sky130_fd_sc_hd__a22o_2
XPHY_EDGE_ROW_96_Right_96 VGND VGND VPWR VPWR sky130_fd_sc_hd__decap_3
X_3635_ wire628/X _3626_/X _3628_/X _3843_/C1 _3619_/X VGND VGND VPWR VPWR _3635_/X
+ sky130_fd_sc_hd__a32o_2
XFILLER_108_27 VGND VGND VPWR VPWR sky130_fd_sc_hd__fill_1
XFILLER_108_38 VGND VGND VPWR VPWR sky130_fd_sc_hd__decap_3
X_3566_ _5926_/Q _5894_/Q _5862_/Q _5766_/Q _3326_/S _3566_/S1 VGND VGND VPWR VPWR
+ _3566_/X sky130_fd_sc_hd__mux4_2
XFILLER_102_203 VGND VGND VPWR VPWR sky130_fd_sc_hd__decap_3
X_5305_ _5824_/CLK _5305_/D VGND VGND VPWR VPWR _5305_/Q sky130_fd_sc_hd__dfxtp_2
X_3497_ _5827_/Q _5443_/Q _6051_/Q _5955_/Q _3501_/S _3615_/S1 VGND VGND VPWR VPWR
+ _3498_/B sky130_fd_sc_hd__mux4_2
X_2517_ _5784_/Q _5720_/Q _3150_/S VGND VGND VPWR VPWR _2517_/X sky130_fd_sc_hd__mux2_1
X_5236_ _5572_/CLK _5236_/D VGND VGND VPWR VPWR _5236_/Q sky130_fd_sc_hd__dfxtp_2
XTAP_TAPCELL_ROW_110_1564 VGND VPWR sky130_fd_sc_hd__tapvpwrvgnd_1
XTAP_TAPCELL_ROW_110_1575 VGND VPWR sky130_fd_sc_hd__tapvpwrvgnd_1
Xhold1801 _6037_/Q VGND VGND VPWR VPWR _5011_/B2 sky130_fd_sc_hd__dlygate4sd3_1
XFILLER_69_684 VGND VGND VPWR VPWR sky130_fd_sc_hd__decap_3
XFILLER_84_19 VGND VGND VPWR VPWR sky130_fd_sc_hd__fill_1
XFILLER_84_621 VGND VGND VPWR VPWR sky130_fd_sc_hd__fill_2
Xhold1812 _5151_/Q VGND VGND VPWR VPWR _4067_/B2 sky130_fd_sc_hd__dlygate4sd3_1
Xhold1823 _5077_/Q VGND VGND VPWR VPWR _3981_/B2 sky130_fd_sc_hd__dlygate4sd3_1
Xhold1834 _5777_/Q VGND VGND VPWR VPWR _4737_/B2 sky130_fd_sc_hd__dlygate4sd3_1
Xhold1845 _5533_/Q VGND VGND VPWR VPWR _4477_/B2 sky130_fd_sc_hd__dlygate4sd3_1
X_5167_ _5999_/CLK _5167_/D VGND VGND VPWR VPWR _5167_/Q sky130_fd_sc_hd__dfxtp_2
XFILLER_29_559 VGND VGND VPWR VPWR sky130_fd_sc_hd__fill_1
XFILLER_84_643 VGND VGND VPWR VPWR sky130_fd_sc_hd__fill_1
Xhold1856 _6005_/Q VGND VGND VPWR VPWR _4977_/B2 sky130_fd_sc_hd__dlygate4sd3_1
Xhold1867 _5656_/Q VGND VGND VPWR VPWR _4609_/B2 sky130_fd_sc_hd__dlygate4sd3_1
Xhold1878 _6006_/Q VGND VGND VPWR VPWR _4978_/B2 sky130_fd_sc_hd__dlygate4sd3_1
X_5098_ _6023_/CLK _5098_/D VGND VGND VPWR VPWR _5098_/Q sky130_fd_sc_hd__dfxtp_2
X_4118_ _5005_/A1 _4120_/A2 _4123_/B1 _4118_/B2 VGND VGND VPWR VPWR _5199_/D sky130_fd_sc_hd__a22o_2
XFILLER_17_24 VGND VGND VPWR VPWR sky130_fd_sc_hd__decap_3
XFILLER_17_35 VGND VGND VPWR VPWR sky130_fd_sc_hd__decap_3
XFILLER_44_507 VGND VGND VPWR VPWR sky130_fd_sc_hd__fill_2
XFILLER_84_676 VGND VGND VPWR VPWR sky130_fd_sc_hd__decap_3
Xhold1889 _5094_/Q VGND VGND VPWR VPWR _4003_/B2 sky130_fd_sc_hd__dlygate4sd3_1
X_4049_ _5007_/A1 _4023_/B _4054_/B1 _4049_/B2 VGND VGND VPWR VPWR _5137_/D sky130_fd_sc_hd__a22o_2
XFILLER_17_57 VGND VGND VPWR VPWR sky130_fd_sc_hd__fill_2
XFILLER_71_337 VGND VGND VPWR VPWR sky130_fd_sc_hd__fill_1
XFILLER_52_551 VGND VGND VPWR VPWR sky130_fd_sc_hd__decap_3
XFILLER_52_562 VGND VGND VPWR VPWR sky130_fd_sc_hd__fill_1
XTAP_TAPCELL_ROW_65_1032 VGND VPWR sky130_fd_sc_hd__tapvpwrvgnd_1
XFILLER_12_415 VGND VGND VPWR VPWR sky130_fd_sc_hd__decap_3
XFILLER_33_45 VGND VGND VPWR VPWR sky130_fd_sc_hd__decap_3
XFILLER_8_419 VGND VGND VPWR VPWR sky130_fd_sc_hd__fill_1
XPHY_EDGE_ROW_104_Left_220 VGND VGND VPWR VPWR sky130_fd_sc_hd__decap_3
XFILLER_4_614 VGND VGND VPWR VPWR sky130_fd_sc_hd__decap_3
XFILLER_3_113 VGND VGND VPWR VPWR sky130_fd_sc_hd__decap_3
XFILLER_3_135 VGND VGND VPWR VPWR sky130_fd_sc_hd__fill_1
XFILLER_4_669 VGND VGND VPWR VPWR sky130_fd_sc_hd__decap_3
XTAP_TAPCELL_ROW_76_1161 VGND VPWR sky130_fd_sc_hd__tapvpwrvgnd_1
XFILLER_79_437 VGND VGND VPWR VPWR sky130_fd_sc_hd__fill_2
XFILLER_94_429 VGND VGND VPWR VPWR sky130_fd_sc_hd__fill_2
XFILLER_75_687 VGND VGND VPWR VPWR sky130_fd_sc_hd__fill_1
XFILLER_28_592 VGND VGND VPWR VPWR sky130_fd_sc_hd__decap_3
XFILLER_74_197 VGND VGND VPWR VPWR sky130_fd_sc_hd__fill_1
XFILLER_74_85 VGND VGND VPWR VPWR sky130_fd_sc_hd__fill_1
XFILLER_15_231 VGND VGND VPWR VPWR sky130_fd_sc_hd__decap_3
XTAP_TAPCELL_ROW_87_1290 VGND VPWR sky130_fd_sc_hd__tapvpwrvgnd_1
XTAP_TAPCELL_ROW_13_410 VGND VPWR sky130_fd_sc_hd__tapvpwrvgnd_1
XTAP_TAPCELL_ROW_41_741 VGND VPWR sky130_fd_sc_hd__tapvpwrvgnd_1
XFILLER_109_380 VGND VGND VPWR VPWR sky130_fd_sc_hd__decap_3
XFILLER_99_60 VGND VGND VPWR VPWR sky130_fd_sc_hd__fill_1
X_3420_ _5376_/Q _5344_/Q _5312_/Q _5280_/Q _3487_/S _3839_/S1 VGND VGND VPWR VPWR
+ _3421_/B sky130_fd_sc_hd__mux4_2
X_3351_ _3335_/X _3341_/X _3350_/X _3855_/B1 VGND VGND VPWR VPWR _3351_/X sky130_fd_sc_hd__o31a_2
XFILLER_31_3 VGND VGND VPWR VPWR sky130_fd_sc_hd__decap_3
XFILLER_97_223 VGND VGND VPWR VPWR sky130_fd_sc_hd__fill_1
Xload_slew300 fanout299/X VGND VGND VPWR VPWR _4121_/B1 sky130_fd_sc_hd__clkbuf_4
XFILLER_112_578 VGND VGND VPWR VPWR sky130_fd_sc_hd__decap_3
X_6070_ _6070_/CLK _6070_/D VGND VGND VPWR VPWR _6070_/Q sky130_fd_sc_hd__dfxtp_2
X_3282_ _3626_/A _3282_/B VGND VGND VPWR VPWR _3282_/X sky130_fd_sc_hd__or2_2
XFILLER_112_589 VGND VGND VPWR VPWR sky130_fd_sc_hd__decap_3
XFILLER_66_610 VGND VGND VPWR VPWR sky130_fd_sc_hd__decap_3
XFILLER_66_621 VGND VGND VPWR VPWR sky130_fd_sc_hd__fill_2
X_5021_ _5021_/A1 _5038_/A2 wire115/A _5021_/B2 VGND VGND VPWR VPWR _6045_/D sky130_fd_sc_hd__a22o_2
XFILLER_38_323 VGND VGND VPWR VPWR sky130_fd_sc_hd__decap_3
XFILLER_38_345 VGND VGND VPWR VPWR sky130_fd_sc_hd__decap_3
XTAP_TAPCELL_ROW_49_841 VGND VPWR sky130_fd_sc_hd__tapvpwrvgnd_1
XFILLER_26_529 VGND VGND VPWR VPWR sky130_fd_sc_hd__decap_3
XFILLER_66_687 VGND VGND VPWR VPWR sky130_fd_sc_hd__fill_1
XFILLER_0_60 VGND VGND VPWR VPWR sky130_fd_sc_hd__decap_3
XFILLER_65_186 VGND VGND VPWR VPWR sky130_fd_sc_hd__decap_3
XFILLER_80_123 VGND VGND VPWR VPWR sky130_fd_sc_hd__fill_1
XFILLER_0_82 VGND VGND VPWR VPWR sky130_fd_sc_hd__fill_2
X_5923_ _6051_/CLK _5923_/D VGND VGND VPWR VPWR _5923_/Q sky130_fd_sc_hd__dfxtp_2
XFILLER_34_584 VGND VGND VPWR VPWR sky130_fd_sc_hd__decap_3
XFILLER_34_595 VGND VGND VPWR VPWR sky130_fd_sc_hd__decap_3
X_5854_ _6046_/CLK _5854_/D VGND VGND VPWR VPWR _5854_/Q sky130_fd_sc_hd__dfxtp_2
XFILLER_21_234 VGND VGND VPWR VPWR sky130_fd_sc_hd__decap_3
X_4805_ _4805_/A_N _4805_/B VGND VGND VPWR VPWR _5843_/D sky130_fd_sc_hd__and2b_2
XFILLER_21_256 VGND VGND VPWR VPWR sky130_fd_sc_hd__decap_3
X_5785_ _5785_/CLK _5785_/D VGND VGND VPWR VPWR _5785_/Q sky130_fd_sc_hd__dfxtp_2
X_2997_ _5581_/Q _5549_/Q _3114_/S VGND VGND VPWR VPWR _2997_/X sky130_fd_sc_hd__mux2_1
X_4736_ _4904_/A1 _4736_/A2 _4740_/B1 _4736_/B2 VGND VGND VPWR VPWR _5776_/D sky130_fd_sc_hd__a22o_2
X_4667_ _4904_/A1 _4673_/A2 _4673_/B1 _4667_/B2 VGND VGND VPWR VPWR _5712_/D sky130_fd_sc_hd__a22o_2
X_3618_ _3837_/A _3615_/X _3617_/X _3745_/B2 VGND VGND VPWR VPWR _3618_/X sky130_fd_sc_hd__a22o_2
XFILLER_1_617 VGND VGND VPWR VPWR sky130_fd_sc_hd__decap_3
Xmax_cap672 _2498_/Y VGND VGND VPWR VPWR fanout671/A sky130_fd_sc_hd__buf_4
X_4598_ _4903_/A1 _4605_/A2 _4605_/B1 _4598_/B2 VGND VGND VPWR VPWR _5647_/D sky130_fd_sc_hd__a22o_2
XFILLER_0_116 VGND VGND VPWR VPWR sky130_fd_sc_hd__decap_3
X_3549_ _3909_/B1 _3540_/X _3543_/X _3533_/X _3922_/B1 VGND VGND VPWR VPWR _3549_/X
+ sky130_fd_sc_hd__a32o_2
XFILLER_88_256 VGND VGND VPWR VPWR sky130_fd_sc_hd__fill_2
XFILLER_103_578 VGND VGND VPWR VPWR sky130_fd_sc_hd__fill_2
XFILLER_69_481 VGND VGND VPWR VPWR sky130_fd_sc_hd__decap_3
XFILLER_76_418 VGND VGND VPWR VPWR sky130_fd_sc_hd__fill_2
XFILLER_88_289 VGND VGND VPWR VPWR sky130_fd_sc_hd__decap_3
X_5219_ _6019_/CLK _5219_/D VGND VGND VPWR VPWR _5219_/Q sky130_fd_sc_hd__dfxtp_2
XFILLER_29_345 VGND VGND VPWR VPWR sky130_fd_sc_hd__decap_3
XFILLER_57_632 VGND VGND VPWR VPWR sky130_fd_sc_hd__decap_3
Xhold1620 _6065_/Q VGND VGND VPWR VPWR _5041_/B2 sky130_fd_sc_hd__dlygate4sd3_1
Xhold1631 _5680_/Q VGND VGND VPWR VPWR _4633_/B2 sky130_fd_sc_hd__dlygate4sd3_1
Xhold1642 _5491_/Q VGND VGND VPWR VPWR _4431_/B2 sky130_fd_sc_hd__dlygate4sd3_1
Xhold1653 _5621_/Q VGND VGND VPWR VPWR _4570_/B2 sky130_fd_sc_hd__dlygate4sd3_1
Xload_slew1105 _3908_/S VGND VGND VPWR VPWR _3785_/S sky130_fd_sc_hd__buf_2
Xload_slew1116 _3585_/S VGND VGND VPWR VPWR _3575_/S sky130_fd_sc_hd__buf_4
Xhold1664 _5890_/Q VGND VGND VPWR VPWR _4856_/B2 sky130_fd_sc_hd__dlygate4sd3_1
Xhold1675 _5796_/Q VGND VGND VPWR VPWR _4758_/B2 sky130_fd_sc_hd__dlygate4sd3_1
Xhold1686 _5993_/Q VGND VGND VPWR VPWR _4965_/B2 sky130_fd_sc_hd__dlygate4sd3_1
XFILLER_56_197 VGND VGND VPWR VPWR sky130_fd_sc_hd__decap_3
XFILLER_72_635 VGND VGND VPWR VPWR sky130_fd_sc_hd__decap_3
Xhold1697 _5849_/Q VGND VGND VPWR VPWR _4813_/B2 sky130_fd_sc_hd__dlygate4sd3_1
XFILLER_25_540 VGND VGND VPWR VPWR sky130_fd_sc_hd__decap_3
XFILLER_71_134 VGND VGND VPWR VPWR sky130_fd_sc_hd__decap_3
XTAP_TAPCELL_ROW_27_568 VGND VPWR sky130_fd_sc_hd__tapvpwrvgnd_1
XFILLER_44_66 VGND VGND VPWR VPWR sky130_fd_sc_hd__decap_3
XTAP_TAPCELL_ROW_27_579 VGND VPWR sky130_fd_sc_hd__tapvpwrvgnd_1
XFILLER_12_234 VGND VGND VPWR VPWR sky130_fd_sc_hd__fill_2
XFILLER_12_278 VGND VGND VPWR VPWR sky130_fd_sc_hd__decap_3
XFILLER_40_587 VGND VGND VPWR VPWR sky130_fd_sc_hd__fill_1
XFILLER_100_83 VGND VGND VPWR VPWR sky130_fd_sc_hd__fill_1
XFILLER_5_27 VGND VGND VPWR VPWR sky130_fd_sc_hd__decap_3
Xclkbuf_4_0_0_clk clkbuf_0_clk/X VGND VGND VPWR VPWR clkbuf_4_0_0_clk/X sky130_fd_sc_hd__clkbuf_8
XFILLER_109_81 VGND VGND VPWR VPWR sky130_fd_sc_hd__decap_3
XFILLER_4_477 VGND VGND VPWR VPWR sky130_fd_sc_hd__decap_3
XFILLER_106_361 VGND VGND VPWR VPWR sky130_fd_sc_hd__decap_3
XFILLER_67_429 VGND VGND VPWR VPWR sky130_fd_sc_hd__decap_3
XFILLER_79_278 VGND VGND VPWR VPWR sky130_fd_sc_hd__fill_2
XFILLER_79_289 VGND VGND VPWR VPWR sky130_fd_sc_hd__fill_2
XFILLER_94_215 VGND VGND VPWR VPWR sky130_fd_sc_hd__fill_1
XFILLER_47_120 VGND VGND VPWR VPWR sky130_fd_sc_hd__decap_3
XFILLER_48_632 VGND VGND VPWR VPWR sky130_fd_sc_hd__decap_3
XFILLER_63_602 VGND VGND VPWR VPWR sky130_fd_sc_hd__decap_3
XFILLER_63_613 VGND VGND VPWR VPWR sky130_fd_sc_hd__decap_3
XFILLER_85_95 VGND VGND VPWR VPWR sky130_fd_sc_hd__decap_3
XTAP_TAPCELL_ROW_46_800 VGND VPWR sky130_fd_sc_hd__tapvpwrvgnd_1
XFILLER_35_315 VGND VGND VPWR VPWR sky130_fd_sc_hd__fill_1
XFILLER_47_175 VGND VGND VPWR VPWR sky130_fd_sc_hd__decap_3
XFILLER_90_410 VGND VGND VPWR VPWR sky130_fd_sc_hd__fill_2
XFILLER_63_668 VGND VGND VPWR VPWR sky130_fd_sc_hd__decap_3
XFILLER_63_679 VGND VGND VPWR VPWR sky130_fd_sc_hd__decap_3
XFILLER_90_465 VGND VGND VPWR VPWR sky130_fd_sc_hd__decap_3
XFILLER_90_498 VGND VGND VPWR VPWR sky130_fd_sc_hd__decap_3
X_2920_ _5514_/Q _5482_/Q _2981_/S VGND VGND VPWR VPWR _2920_/X sky130_fd_sc_hd__mux2_1
XFILLER_16_595 VGND VGND VPWR VPWR sky130_fd_sc_hd__decap_3
X_2851_ _5831_/Q _5447_/Q _2980_/S VGND VGND VPWR VPWR _2851_/X sky130_fd_sc_hd__mux2_1
XFILLER_79_3 VGND VGND VPWR VPWR sky130_fd_sc_hd__decap_3
X_5570_ _5943_/CLK _5570_/D VGND VGND VPWR VPWR _5570_/Q sky130_fd_sc_hd__dfxtp_2
X_2782_ _5924_/Q _5892_/Q _5860_/Q _5764_/Q _3159_/S _3157_/S1 VGND VGND VPWR VPWR
+ _2782_/X sky130_fd_sc_hd__mux4_2
X_4521_ _4727_/A1 _4537_/A2 _4537_/B1 _4521_/B2 VGND VGND VPWR VPWR _5575_/D sky130_fd_sc_hd__a22o_2
X_4452_ _4520_/A1 _4459_/A2 _4459_/B1 _4452_/B2 VGND VGND VPWR VPWR _5510_/D sky130_fd_sc_hd__a22o_2
XFILLER_104_309 VGND VGND VPWR VPWR sky130_fd_sc_hd__decap_3
X_3403_ _5183_/Q _5151_/Q _3645_/S VGND VGND VPWR VPWR _3404_/B sky130_fd_sc_hd__mux2_1
X_4383_ _4894_/A1 _4398_/A2 _4398_/B1 _4383_/B2 VGND VGND VPWR VPWR _5446_/D sky130_fd_sc_hd__a22o_2
Xload_slew130 _4978_/B1 VGND VGND VPWR VPWR _4976_/B1 sky130_fd_sc_hd__buf_4
X_3334_ wire603/A _3332_/X _3333_/X wire583/A VGND VGND VPWR VPWR _3334_/X sky130_fd_sc_hd__o22a_2
XFILLER_100_504 VGND VGND VPWR VPWR sky130_fd_sc_hd__fill_2
XFILLER_98_598 VGND VGND VPWR VPWR sky130_fd_sc_hd__fill_1
Xload_slew163 _4762_/B1 VGND VGND VPWR VPWR _4772_/B1 sky130_fd_sc_hd__clkbuf_4
X_6053_ _6053_/CLK _6053_/D VGND VGND VPWR VPWR _6053_/Q sky130_fd_sc_hd__dfxtp_2
X_3265_ _5369_/Q _5337_/Q _5305_/Q _5273_/Q _3284_/S _3627_/S1 VGND VGND VPWR VPWR
+ _3265_/X sky130_fd_sc_hd__mux4_2
Xload_slew196 _4591_/B1 VGND VGND VPWR VPWR _4606_/B1 sky130_fd_sc_hd__buf_4
X_5004_ _5004_/A1 _4981_/B _5010_/B1 _5004_/B2 VGND VGND VPWR VPWR _6030_/D sky130_fd_sc_hd__a22o_2
X_3196_ _3206_/A1 _3192_/X _3195_/X _3196_/C1 VGND VGND VPWR VPWR _3196_/X sky130_fd_sc_hd__o211a_2
XFILLER_38_175 VGND VGND VPWR VPWR sky130_fd_sc_hd__decap_3
XFILLER_38_186 VGND VGND VPWR VPWR sky130_fd_sc_hd__fill_2
XFILLER_93_281 VGND VGND VPWR VPWR sky130_fd_sc_hd__decap_3
XFILLER_26_359 VGND VGND VPWR VPWR sky130_fd_sc_hd__decap_3
XFILLER_53_156 VGND VGND VPWR VPWR sky130_fd_sc_hd__decap_3
X_5906_ _6066_/CLK _5906_/D VGND VGND VPWR VPWR _5906_/Q sky130_fd_sc_hd__dfxtp_2
XTAP_TAPCELL_ROW_24_538 VGND VPWR sky130_fd_sc_hd__tapvpwrvgnd_1
XTAP_TAPCELL_ROW_52_869 VGND VPWR sky130_fd_sc_hd__tapvpwrvgnd_1
X_5837_ _6061_/CLK _5837_/D VGND VGND VPWR VPWR _5837_/Q sky130_fd_sc_hd__dfxtp_2
X_5768_ _6032_/CLK _5768_/D VGND VGND VPWR VPWR _5768_/Q sky130_fd_sc_hd__dfxtp_2
X_4719_ _4719_/A1 wire389/X _4727_/B1 _4719_/B2 VGND VGND VPWR VPWR _5759_/D sky130_fd_sc_hd__a22o_2
XFILLER_108_648 VGND VGND VPWR VPWR sky130_fd_sc_hd__decap_3
XFILLER_30_24 VGND VGND VPWR VPWR sky130_fd_sc_hd__decap_3
X_5699_ _6048_/CLK _5699_/D VGND VGND VPWR VPWR _5699_/Q sky130_fd_sc_hd__dfxtp_2
XFILLER_100_6 VGND VGND VPWR VPWR sky130_fd_sc_hd__decap_3
XFILLER_107_147 VGND VGND VPWR VPWR sky130_fd_sc_hd__decap_3
XFILLER_107_169 VGND VGND VPWR VPWR sky130_fd_sc_hd__decap_3
XTAP_TAPCELL_ROW_73_1120 VGND VPWR sky130_fd_sc_hd__tapvpwrvgnd_1
XTAP_TAPCELL_ROW_73_1131 VGND VPWR sky130_fd_sc_hd__tapvpwrvgnd_1
XFILLER_89_543 VGND VGND VPWR VPWR sky130_fd_sc_hd__fill_1
XFILLER_39_55 VGND VGND VPWR VPWR sky130_fd_sc_hd__fill_1
Xhold2140 _5834_/Q VGND VGND VPWR VPWR _4796_/B sky130_fd_sc_hd__dlygate4sd3_1
Xhold2151 _5835_/Q VGND VGND VPWR VPWR _4797_/B sky130_fd_sc_hd__dlygate4sd3_1
Xhold1450 _5653_/Q VGND VGND VPWR VPWR _4604_/B2 sky130_fd_sc_hd__dlygate4sd3_1
Xhold1461 _5578_/Q VGND VGND VPWR VPWR _4524_/B2 sky130_fd_sc_hd__dlygate4sd3_1
XFILLER_29_186 VGND VGND VPWR VPWR sky130_fd_sc_hd__decap_3
XFILLER_72_421 VGND VGND VPWR VPWR sky130_fd_sc_hd__decap_3
XTAP_TAPCELL_ROW_4_296 VGND VPWR sky130_fd_sc_hd__tapvpwrvgnd_1
Xhold1472 _5721_/Q VGND VGND VPWR VPWR _4678_/B2 sky130_fd_sc_hd__dlygate4sd3_1
Xhold1483 _5579_/Q VGND VGND VPWR VPWR _4525_/B2 sky130_fd_sc_hd__dlygate4sd3_1
Xhold1494 _5960_/Q VGND VGND VPWR VPWR _4930_/B2 sky130_fd_sc_hd__dlygate4sd3_1
XFILLER_17_348 VGND VGND VPWR VPWR sky130_fd_sc_hd__decap_3
XPHY_EDGE_ROW_105_Right_105 VGND VGND VPWR VPWR sky130_fd_sc_hd__decap_3
XTAP_TAPCELL_ROW_84_1260 VGND VPWR sky130_fd_sc_hd__tapvpwrvgnd_1
XFILLER_111_60 VGND VGND VPWR VPWR sky130_fd_sc_hd__decap_3
XFILLER_111_93 VGND VGND VPWR VPWR sky130_fd_sc_hd__decap_3
XFILLER_71_53 VGND VGND VPWR VPWR sky130_fd_sc_hd__decap_3
XFILLER_114_607 VGND VGND VPWR VPWR sky130_fd_sc_hd__decap_3
XFILLER_4_230 VGND VGND VPWR VPWR sky130_fd_sc_hd__decap_3
XFILLER_4_274 VGND VGND VPWR VPWR sky130_fd_sc_hd__fill_2
XFILLER_96_61 VGND VGND VPWR VPWR sky130_fd_sc_hd__fill_2
XFILLER_96_83 VGND VGND VPWR VPWR sky130_fd_sc_hd__fill_1
X_3050_ _3196_/C1 _3042_/X _3044_/X _3035_/X _3206_/C1 VGND VGND VPWR VPWR _3050_/X
+ sky130_fd_sc_hd__a32o_2
XFILLER_36_635 VGND VGND VPWR VPWR sky130_fd_sc_hd__fill_1
XFILLER_75_281 VGND VGND VPWR VPWR sky130_fd_sc_hd__fill_1
XFILLER_63_432 VGND VGND VPWR VPWR sky130_fd_sc_hd__fill_2
XFILLER_23_318 VGND VGND VPWR VPWR sky130_fd_sc_hd__decap_3
X_3952_ _5016_/A1 _3982_/A2 _3982_/B1 _3952_/B2 VGND VGND VPWR VPWR _5048_/D sky130_fd_sc_hd__a22o_2
X_3883_ _5941_/Q _5909_/Q _5877_/Q _5781_/Q _3851_/S _3893_/S1 VGND VGND VPWR VPWR
+ _3883_/X sky130_fd_sc_hd__mux4_2
X_2903_ _3019_/A _2900_/X _2902_/X wire641/X VGND VGND VPWR VPWR _2903_/X sky130_fd_sc_hd__o22a_2
X_5622_ _6070_/CLK _5622_/D VGND VGND VPWR VPWR _5622_/Q sky130_fd_sc_hd__dfxtp_2
X_2834_ _5510_/Q _5478_/Q _3099_/S VGND VGND VPWR VPWR _2834_/X sky130_fd_sc_hd__mux2_1
X_5553_ _5866_/CLK _5553_/D VGND VGND VPWR VPWR _5553_/Q sky130_fd_sc_hd__dfxtp_2
XTAP_TAPCELL_ROW_98_1429 VGND VPWR sky130_fd_sc_hd__tapvpwrvgnd_1
X_4504_ _4878_/A _4504_/B VGND VGND VPWR VPWR _4504_/Y sky130_fd_sc_hd__nor2_2
X_2765_ _5571_/Q _5539_/Q _3026_/S VGND VGND VPWR VPWR _2765_/X sky130_fd_sc_hd__mux2_1
X_5484_ _5578_/CLK _5484_/D VGND VGND VPWR VPWR _5484_/Q sky130_fd_sc_hd__dfxtp_2
X_2696_ _5824_/Q _5440_/Q _2760_/S VGND VGND VPWR VPWR _2696_/X sky130_fd_sc_hd__mux2_1
XFILLER_104_128 VGND VGND VPWR VPWR sky130_fd_sc_hd__decap_3
X_4435_ _4843_/A1 _4435_/A2 _4435_/B1 _4435_/B2 VGND VGND VPWR VPWR _5495_/D sky130_fd_sc_hd__a22o_2
Xfanout515 wire518/A VGND VGND VPWR VPWR wire516/A sky130_fd_sc_hd__clkdlybuf4s25_1
X_4366_ input5/X input4/X _4401_/B _4878_/A VGND VGND VPWR VPWR _5014_/B sky130_fd_sc_hd__or4b_2
XFILLER_113_662 VGND VGND VPWR VPWR sky130_fd_sc_hd__decap_3
XFILLER_113_673 VGND VGND VPWR VPWR sky130_fd_sc_hd__decap_3
XFILLER_98_384 VGND VGND VPWR VPWR sky130_fd_sc_hd__decap_3
Xfanout537 wire540/A VGND VGND VPWR VPWR _4017_/A2 sky130_fd_sc_hd__clkdlybuf4s25_1
X_3317_ _5787_/Q _5723_/Q _3317_/S VGND VGND VPWR VPWR _3317_/X sky130_fd_sc_hd__mux2_1
XFILLER_100_312 VGND VGND VPWR VPWR sky130_fd_sc_hd__decap_3
XFILLER_58_248 VGND VGND VPWR VPWR sky130_fd_sc_hd__decap_3
XFILLER_86_557 VGND VGND VPWR VPWR sky130_fd_sc_hd__decap_3
X_4297_ _4843_/A1 _4297_/A2 _4297_/B1 _4297_/B2 VGND VGND VPWR VPWR _5367_/D sky130_fd_sc_hd__a22o_2
XTAP_TAPCELL_ROW_57_928 VGND VPWR sky130_fd_sc_hd__tapvpwrvgnd_1
X_6036_ _6036_/CLK _6036_/D VGND VGND VPWR VPWR _6036_/Q sky130_fd_sc_hd__dfxtp_2
X_3248_ _3261_/B _3261_/A VGND VGND VPWR VPWR _3248_/X sky130_fd_sc_hd__and2b_2
XFILLER_39_484 VGND VGND VPWR VPWR sky130_fd_sc_hd__fill_1
XTAP_TAPCELL_ROW_57_939 VGND VPWR sky130_fd_sc_hd__tapvpwrvgnd_1
X_3179_ _3179_/A1 _3175_/X _3178_/X _3173_/X VGND VGND VPWR VPWR _3179_/X sky130_fd_sc_hd__a31o_2
XFILLER_26_134 VGND VGND VPWR VPWR sky130_fd_sc_hd__decap_3
XTAP_TAPCELL_ROW_107_1536 VGND VPWR sky130_fd_sc_hd__tapvpwrvgnd_1
XTAP_TAPCELL_ROW_1_266 VGND VPWR sky130_fd_sc_hd__tapvpwrvgnd_1
XFILLER_14_307 VGND VGND VPWR VPWR sky130_fd_sc_hd__fill_1
XFILLER_25_24 VGND VGND VPWR VPWR sky130_fd_sc_hd__decap_3
XFILLER_42_616 VGND VGND VPWR VPWR sky130_fd_sc_hd__fill_1
XFILLER_81_295 VGND VGND VPWR VPWR sky130_fd_sc_hd__fill_2
XTAP_TAPCELL_ROW_37_696 VGND VPWR sky130_fd_sc_hd__tapvpwrvgnd_1
XFILLER_10_502 VGND VGND VPWR VPWR sky130_fd_sc_hd__decap_3
XFILLER_10_513 VGND VGND VPWR VPWR sky130_fd_sc_hd__decap_3
XFILLER_10_557 VGND VGND VPWR VPWR sky130_fd_sc_hd__decap_3
XFILLER_9_3 VGND VGND VPWR VPWR sky130_fd_sc_hd__decap_3
XTAP_TAPCELL_ROW_9_355 VGND VPWR sky130_fd_sc_hd__tapvpwrvgnd_1
XFILLER_104_684 VGND VGND VPWR VPWR sky130_fd_sc_hd__decap_3
XFILLER_103_172 VGND VGND VPWR VPWR sky130_fd_sc_hd__decap_3
XFILLER_106_71 VGND VGND VPWR VPWR sky130_fd_sc_hd__decap_3
XFILLER_1_299 VGND VGND VPWR VPWR sky130_fd_sc_hd__fill_1
XFILLER_49_215 VGND VGND VPWR VPWR sky130_fd_sc_hd__fill_1
XFILLER_92_549 VGND VGND VPWR VPWR sky130_fd_sc_hd__decap_3
Xhold1280 _5784_/Q VGND VGND VPWR VPWR _4746_/B2 sky130_fd_sc_hd__dlygate4sd3_1
Xhold1291 _5923_/Q VGND VGND VPWR VPWR _4891_/B2 sky130_fd_sc_hd__dlygate4sd3_1
XFILLER_45_498 VGND VGND VPWR VPWR sky130_fd_sc_hd__decap_3
XFILLER_72_295 VGND VGND VPWR VPWR sky130_fd_sc_hd__fill_2
XFILLER_82_52 VGND VGND VPWR VPWR sky130_fd_sc_hd__fill_1
XFILLER_13_340 VGND VGND VPWR VPWR sky130_fd_sc_hd__fill_1
XFILLER_32_159 VGND VGND VPWR VPWR sky130_fd_sc_hd__fill_2
XFILLER_15_90 VGND VGND VPWR VPWR sky130_fd_sc_hd__decap_3
XFILLER_9_366 VGND VGND VPWR VPWR sky130_fd_sc_hd__decap_3
Xoutput107 _3330_/X VGND VGND VPWR VPWR rd2[3] sky130_fd_sc_hd__clkbuf_4
X_2550_ _2537_/X _2549_/X _2619_/A VGND VGND VPWR VPWR _2550_/X sky130_fd_sc_hd__o21a_2
XFILLER_5_561 VGND VGND VPWR VPWR sky130_fd_sc_hd__decap_3
XFILLER_99_137 VGND VGND VPWR VPWR sky130_fd_sc_hd__decap_3
X_4220_ _4528_/A1 wire489/A wire269/X _4220_/B2 VGND VGND VPWR VPWR _5294_/D sky130_fd_sc_hd__a22o_2
XFILLER_101_109 VGND VGND VPWR VPWR sky130_fd_sc_hd__decap_3
XFILLER_110_610 VGND VGND VPWR VPWR sky130_fd_sc_hd__decap_3
XFILLER_110_632 VGND VGND VPWR VPWR sky130_fd_sc_hd__decap_3
X_4151_ _5004_/A1 _4128_/B _4151_/B1 _4151_/B2 VGND VGND VPWR VPWR _5230_/D sky130_fd_sc_hd__a22o_2
XFILLER_110_654 VGND VGND VPWR VPWR sky130_fd_sc_hd__decap_3
X_4082_ _5004_/A1 _4059_/B _4088_/B1 _4082_/B2 VGND VGND VPWR VPWR _5166_/D sky130_fd_sc_hd__a22o_2
X_3102_ _5138_/Q _5106_/Q _6034_/Q _6002_/Q _3104_/S _3102_/S1 VGND VGND VPWR VPWR
+ _3102_/X sky130_fd_sc_hd__mux4_2
XFILLER_110_687 VGND VGND VPWR VPWR sky130_fd_sc_hd__fill_1
X_3033_ _6063_/Q _5967_/Q _3038_/S VGND VGND VPWR VPWR _3033_/X sky130_fd_sc_hd__mux2_1
XFILLER_48_281 VGND VGND VPWR VPWR sky130_fd_sc_hd__fill_2
XFILLER_102_29 VGND VGND VPWR VPWR sky130_fd_sc_hd__fill_2
XFILLER_91_593 VGND VGND VPWR VPWR sky130_fd_sc_hd__decap_3
X_4984_ _4984_/A1 _5011_/A2 _5011_/B1 _4984_/B2 VGND VGND VPWR VPWR _6010_/D sky130_fd_sc_hd__a22o_2
XTAP_TAPCELL_ROW_34_655 VGND VPWR sky130_fd_sc_hd__tapvpwrvgnd_1
X_3935_ _5271_/Q _5239_/Q _3936_/S VGND VGND VPWR VPWR _3935_/X sky130_fd_sc_hd__mux2_1
XTAP_TAPCELL_ROW_102_1477 VGND VPWR sky130_fd_sc_hd__tapvpwrvgnd_1
XTAP_TAPCELL_ROW_62_997 VGND VPWR sky130_fd_sc_hd__tapvpwrvgnd_1
X_5605_ _5925_/CLK _5605_/D VGND VGND VPWR VPWR _5605_/Q sky130_fd_sc_hd__dfxtp_2
X_3866_ _5940_/Q _5908_/Q _5876_/Q _5780_/Q _3514_/S _3866_/S1 VGND VGND VPWR VPWR
+ _3867_/B sky130_fd_sc_hd__mux4_2
XFILLER_11_15 VGND VGND VPWR VPWR sky130_fd_sc_hd__decap_3
X_3797_ _5585_/Q _5553_/Q _5521_/Q _5489_/Q _3398_/S _3808_/S1 VGND VGND VPWR VPWR
+ _3797_/X sky130_fd_sc_hd__mux4_2
X_2817_ _5253_/Q _5221_/Q _2856_/S VGND VGND VPWR VPWR _2817_/X sky130_fd_sc_hd__mux2_1
X_5536_ _6019_/CLK _5536_/D VGND VGND VPWR VPWR _5536_/Q sky130_fd_sc_hd__dfxtp_2
X_2748_ _5794_/Q _5730_/Q _3110_/S VGND VGND VPWR VPWR _2748_/X sky130_fd_sc_hd__mux2_1
XFILLER_105_415 VGND VGND VPWR VPWR sky130_fd_sc_hd__decap_3
X_5467_ _5502_/CLK _5467_/D VGND VGND VPWR VPWR _5467_/Q sky130_fd_sc_hd__dfxtp_2
X_4418_ _4520_/A1 _4425_/A2 _4425_/B1 _4418_/B2 VGND VGND VPWR VPWR _5478_/D sky130_fd_sc_hd__a22o_2
X_2679_ _5247_/Q _5215_/Q _2925_/S VGND VGND VPWR VPWR _2679_/X sky130_fd_sc_hd__mux2_1
XFILLER_99_660 VGND VGND VPWR VPWR sky130_fd_sc_hd__fill_2
XTAP_TAPCELL_ROW_6_325 VGND VPWR sky130_fd_sc_hd__tapvpwrvgnd_1
Xfanout323 wire327/X VGND VGND VPWR VPWR _3982_/B1 sky130_fd_sc_hd__clkdlybuf4s25_1
Xfanout312 _4023_/Y VGND VGND VPWR VPWR _4054_/B1 sky130_fd_sc_hd__clkdlybuf4s25_1
Xfanout301 _4086_/B1 VGND VGND VPWR VPWR _4077_/B1 sky130_fd_sc_hd__clkdlybuf4s25_1
X_5398_ _6021_/CLK _5398_/D VGND VGND VPWR VPWR _5398_/Q sky130_fd_sc_hd__dfxtp_2
Xfanout356 _4878_/Y VGND VGND VPWR VPWR _4902_/A2 sky130_fd_sc_hd__clkdlybuf4s25_1
Xfanout345 _4978_/A2 VGND VGND VPWR VPWR _4976_/A2 sky130_fd_sc_hd__clkdlybuf4s25_1
X_4349_ _4997_/A1 _4365_/A2 _4365_/B1 _4349_/B2 VGND VGND VPWR VPWR _5415_/D sky130_fd_sc_hd__a22o_2
XFILLER_59_557 VGND VGND VPWR VPWR sky130_fd_sc_hd__decap_3
XFILLER_86_343 VGND VGND VPWR VPWR sky130_fd_sc_hd__decap_3
Xfanout378 _4744_/Y VGND VGND VPWR VPWR _4745_/B sky130_fd_sc_hd__clkdlybuf4s25_1
XFILLER_101_687 VGND VGND VPWR VPWR sky130_fd_sc_hd__fill_1
XFILLER_74_527 VGND VGND VPWR VPWR sky130_fd_sc_hd__decap_3
X_6019_ _6019_/CLK _6019_/D VGND VGND VPWR VPWR _6019_/Q sky130_fd_sc_hd__dfxtp_2
XFILLER_100_197 VGND VGND VPWR VPWR sky130_fd_sc_hd__decap_3
XFILLER_39_281 VGND VGND VPWR VPWR sky130_fd_sc_hd__decap_3
XFILLER_67_590 VGND VGND VPWR VPWR sky130_fd_sc_hd__decap_3
XFILLER_27_476 VGND VGND VPWR VPWR sky130_fd_sc_hd__decap_3
XTAP_TAPCELL_ROW_68_1063 VGND VPWR sky130_fd_sc_hd__tapvpwrvgnd_1
XFILLER_42_424 VGND VGND VPWR VPWR sky130_fd_sc_hd__fill_1
XFILLER_23_682 VGND VGND VPWR VPWR sky130_fd_sc_hd__decap_3
XFILLER_52_55 VGND VGND VPWR VPWR sky130_fd_sc_hd__fill_1
XFILLER_10_365 VGND VGND VPWR VPWR sky130_fd_sc_hd__decap_3
XFILLER_108_231 VGND VGND VPWR VPWR sky130_fd_sc_hd__fill_2
XFILLER_108_253 VGND VGND VPWR VPWR sky130_fd_sc_hd__decap_3
XFILLER_6_347 VGND VGND VPWR VPWR sky130_fd_sc_hd__decap_3
XFILLER_108_286 VGND VGND VPWR VPWR sky130_fd_sc_hd__fill_2
XTAP_TAPCELL_ROW_79_1192 VGND VPWR sky130_fd_sc_hd__tapvpwrvgnd_1
XFILLER_111_407 VGND VGND VPWR VPWR sky130_fd_sc_hd__decap_3
Xload_slew729 _3005_/A1 VGND VGND VPWR VPWR _2649_/A sky130_fd_sc_hd__buf_4
Xload_slew718 _3800_/A VGND VGND VPWR VPWR _3454_/A sky130_fd_sc_hd__buf_2
Xload_slew707 _3305_/A VGND VGND VPWR VPWR _3562_/A sky130_fd_sc_hd__buf_2
XFILLER_28_9 VGND VGND VPWR VPWR sky130_fd_sc_hd__fill_1
XFILLER_65_505 VGND VGND VPWR VPWR sky130_fd_sc_hd__decap_3
XFILLER_77_354 VGND VGND VPWR VPWR sky130_fd_sc_hd__decap_3
XFILLER_77_74 VGND VGND VPWR VPWR sky130_fd_sc_hd__decap_3
Xfanout890 input42/X VGND VGND VPWR VPWR _4985_/A1 sky130_fd_sc_hd__clkdlybuf4s25_1
XFILLER_93_51 VGND VGND VPWR VPWR sky130_fd_sc_hd__decap_3
XFILLER_33_402 VGND VGND VPWR VPWR sky130_fd_sc_hd__fill_1
XFILLER_33_435 VGND VGND VPWR VPWR sky130_fd_sc_hd__decap_3
XFILLER_93_95 VGND VGND VPWR VPWR sky130_fd_sc_hd__decap_3
XFILLER_33_457 VGND VGND VPWR VPWR sky130_fd_sc_hd__fill_2
XFILLER_33_479 VGND VGND VPWR VPWR sky130_fd_sc_hd__decap_3
XFILLER_14_660 VGND VGND VPWR VPWR sky130_fd_sc_hd__decap_3
XTAP_TAPCELL_ROW_31_625 VGND VPWR sky130_fd_sc_hd__tapvpwrvgnd_1
X_3720_ _5421_/Q _5069_/Q _3721_/S VGND VGND VPWR VPWR _3720_/X sky130_fd_sc_hd__mux2_1
XFILLER_9_141 VGND VGND VPWR VPWR sky130_fd_sc_hd__decap_3
Xclkbuf_leaf_40_clk clkbuf_4_12_0_clk/X VGND VGND VPWR VPWR _5514_/CLK sky130_fd_sc_hd__clkbuf_8
X_3651_ _3234_/B _3650_/X _3649_/X _3922_/B1 VGND VGND VPWR VPWR _3651_/X sky130_fd_sc_hd__o211a_2
XTAP_TAPCELL_ROW_11_382 VGND VPWR sky130_fd_sc_hd__tapvpwrvgnd_1
X_3582_ _3687_/A _3578_/X _3581_/X _3909_/B1 VGND VGND VPWR VPWR _3582_/X sky130_fd_sc_hd__o211a_2
X_2602_ _2904_/A1 _2599_/X _2601_/X input9/X VGND VGND VPWR VPWR _2608_/B sky130_fd_sc_hd__o211a_2
X_5321_ _5824_/CLK _5321_/D VGND VGND VPWR VPWR _5321_/Q sky130_fd_sc_hd__dfxtp_2
X_2533_ _5177_/Q _5145_/Q _2534_/S VGND VGND VPWR VPWR _2533_/X sky130_fd_sc_hd__mux2_1
XFILLER_5_391 VGND VGND VPWR VPWR sky130_fd_sc_hd__fill_1
XFILLER_102_418 VGND VGND VPWR VPWR sky130_fd_sc_hd__fill_2
X_5252_ _6038_/CLK _5252_/D VGND VGND VPWR VPWR _5252_/Q sky130_fd_sc_hd__dfxtp_2
X_5183_ _5802_/CLK _5183_/D VGND VGND VPWR VPWR _5183_/Q sky130_fd_sc_hd__dfxtp_2
X_4203_ _4885_/A1 _4224_/A2 _4219_/B1 _4203_/B2 VGND VGND VPWR VPWR _5277_/D sky130_fd_sc_hd__a22o_2
XFILLER_110_440 VGND VGND VPWR VPWR sky130_fd_sc_hd__fill_1
XFILLER_3_60 VGND VGND VPWR VPWR sky130_fd_sc_hd__decap_3
XFILLER_68_343 VGND VGND VPWR VPWR sky130_fd_sc_hd__fill_2
XFILLER_68_365 VGND VGND VPWR VPWR sky130_fd_sc_hd__fill_1
XFILLER_95_140 VGND VGND VPWR VPWR sky130_fd_sc_hd__decap_3
X_4134_ _4751_/A1 _4145_/A2 _4134_/B1 _4134_/B2 VGND VGND VPWR VPWR _5213_/D sky130_fd_sc_hd__a22o_2
XFILLER_113_28 VGND VGND VPWR VPWR sky130_fd_sc_hd__decap_3
XFILLER_28_218 VGND VGND VPWR VPWR sky130_fd_sc_hd__fill_1
XFILLER_56_527 VGND VGND VPWR VPWR sky130_fd_sc_hd__decap_3
XFILLER_95_184 VGND VGND VPWR VPWR sky130_fd_sc_hd__decap_3
XFILLER_96_685 VGND VGND VPWR VPWR sky130_fd_sc_hd__decap_3
XTAP_TAPCELL_ROW_39_714 VGND VPWR sky130_fd_sc_hd__tapvpwrvgnd_1
XFILLER_83_335 VGND VGND VPWR VPWR sky130_fd_sc_hd__fill_1
X_4065_ _4987_/A1 _4076_/A2 _4089_/B1 _4065_/B2 VGND VGND VPWR VPWR _5149_/D sky130_fd_sc_hd__a22o_2
XFILLER_36_240 VGND VGND VPWR VPWR sky130_fd_sc_hd__decap_3
X_3016_ wire641/X _3014_/X _3015_/X wire676/X VGND VGND VPWR VPWR _3016_/X sky130_fd_sc_hd__o22a_2
XFILLER_24_435 VGND VGND VPWR VPWR sky130_fd_sc_hd__decap_3
XFILLER_36_273 VGND VGND VPWR VPWR sky130_fd_sc_hd__fill_2
XTAP_TAPCELL_ROW_19_482 VGND VPWR sky130_fd_sc_hd__tapvpwrvgnd_1
X_4967_ _5001_/A1 _4947_/B _4976_/B1 _4967_/B2 VGND VGND VPWR VPWR _5995_/D sky130_fd_sc_hd__a22o_2
Xclkbuf_leaf_31_clk clkload5/A VGND VGND VPWR VPWR _5925_/CLK sky130_fd_sc_hd__clkbuf_8
X_4898_ _5034_/A1 wire360/X wire144/X _4898_/B2 VGND VGND VPWR VPWR _5930_/D sky130_fd_sc_hd__a22o_2
X_3918_ _3918_/A _3918_/B VGND VGND VPWR VPWR _3918_/X sky130_fd_sc_hd__or2_2
X_3849_ _5139_/Q _5107_/Q _6035_/Q _6003_/Q _3277_/S _3893_/S1 VGND VGND VPWR VPWR
+ _3849_/X sky130_fd_sc_hd__mux4_2
XFILLER_98_18 VGND VGND VPWR VPWR sky130_fd_sc_hd__decap_3
XFILLER_98_29 VGND VGND VPWR VPWR sky130_fd_sc_hd__decap_3
XTAP_TAPCELL_ROW_115_1624 VGND VPWR sky130_fd_sc_hd__tapvpwrvgnd_1
XTAP_TAPCELL_ROW_115_1635 VGND VPWR sky130_fd_sc_hd__tapvpwrvgnd_1
X_5519_ _5999_/CLK _5519_/D VGND VGND VPWR VPWR _5519_/Q sky130_fd_sc_hd__dfxtp_2
XTAP_TAPCELL_ROW_115_1646 VGND VPWR sky130_fd_sc_hd__tapvpwrvgnd_1
XFILLER_78_107 VGND VGND VPWR VPWR sky130_fd_sc_hd__decap_3
XFILLER_105_289 VGND VGND VPWR VPWR sky130_fd_sc_hd__decap_3
Xfanout131 _4947_/Y VGND VGND VPWR VPWR _4979_/B1 sky130_fd_sc_hd__clkdlybuf4s25_1
Xfanout120 _4981_/Y VGND VGND VPWR VPWR _4998_/B1 sky130_fd_sc_hd__clkdlybuf4s25_1
Xfanout1129 _3645_/S VGND VGND VPWR VPWR _3402_/S sky130_fd_sc_hd__dlymetal6s4s_1
Xclkbuf_leaf_98_clk clkload0/A VGND VGND VPWR VPWR _6012_/CLK sky130_fd_sc_hd__clkbuf_8
Xfanout164 _4745_/Y VGND VGND VPWR VPWR _4777_/B1 sky130_fd_sc_hd__clkdlybuf4s25_1
XFILLER_47_55 VGND VGND VPWR VPWR sky130_fd_sc_hd__fill_1
Xfanout197 fanout197/A VGND VGND VPWR VPWR _4600_/B1 sky130_fd_sc_hd__clkdlybuf4s25_1
Xfanout175 _4676_/Y VGND VGND VPWR VPWR _4693_/B1 sky130_fd_sc_hd__clkdlybuf4s25_1
XFILLER_47_549 VGND VGND VPWR VPWR sky130_fd_sc_hd__fill_2
XFILLER_74_346 VGND VGND VPWR VPWR sky130_fd_sc_hd__decap_3
XFILLER_27_262 VGND VGND VPWR VPWR sky130_fd_sc_hd__decap_3
XFILLER_15_424 VGND VGND VPWR VPWR sky130_fd_sc_hd__decap_3
XFILLER_55_593 VGND VGND VPWR VPWR sky130_fd_sc_hd__decap_3
XFILLER_30_427 VGND VGND VPWR VPWR sky130_fd_sc_hd__decap_3
XFILLER_8_27 VGND VGND VPWR VPWR sky130_fd_sc_hd__fill_1
XFILLER_8_38 VGND VGND VPWR VPWR sky130_fd_sc_hd__decap_3
Xclkbuf_leaf_22_clk clkbuf_4_10_0_clk/X VGND VGND VPWR VPWR _5400_/CLK sky130_fd_sc_hd__clkbuf_8
XFILLER_10_151 VGND VGND VPWR VPWR sky130_fd_sc_hd__decap_3
XFILLER_11_685 VGND VGND VPWR VPWR sky130_fd_sc_hd__decap_3
XFILLER_7_623 VGND VGND VPWR VPWR sky130_fd_sc_hd__decap_3
XFILLER_109_540 VGND VGND VPWR VPWR sky130_fd_sc_hd__decap_3
XFILLER_12_91 VGND VGND VPWR VPWR sky130_fd_sc_hd__decap_3
Xload_slew504 _4145_/A2 VGND VGND VPWR VPWR _4158_/A2 sky130_fd_sc_hd__clkbuf_4
XTAP_TAPCELL_ROW_90_1329 VGND VPWR sky130_fd_sc_hd__tapvpwrvgnd_1
XFILLER_97_438 VGND VGND VPWR VPWR sky130_fd_sc_hd__decap_3
XFILLER_97_449 VGND VGND VPWR VPWR sky130_fd_sc_hd__fill_2
XFILLER_26_6 VGND VGND VPWR VPWR sky130_fd_sc_hd__decap_3
Xclkbuf_leaf_89_clk clkbuf_4_6_0_clk/X VGND VGND VPWR VPWR _6024_/CLK sky130_fd_sc_hd__clkbuf_8
XFILLER_38_516 VGND VGND VPWR VPWR sky130_fd_sc_hd__decap_3
X_5870_ _5934_/CLK _5870_/D VGND VGND VPWR VPWR _5870_/Q sky130_fd_sc_hd__dfxtp_2
XFILLER_73_390 VGND VGND VPWR VPWR sky130_fd_sc_hd__fill_2
XTAP_TAPCELL_ROW_16_441 VGND VPWR sky130_fd_sc_hd__tapvpwrvgnd_1
X_4821_ _5025_/A1 wire374/X wire156/A _4821_/B2 VGND VGND VPWR VPWR _5857_/D sky130_fd_sc_hd__a22o_2
XTAP_TAPCELL_ROW_44_772 VGND VPWR sky130_fd_sc_hd__tapvpwrvgnd_1
XTAP_TAPCELL_ROW_44_783 VGND VPWR sky130_fd_sc_hd__tapvpwrvgnd_1
Xclkbuf_leaf_13_clk clkload4/A VGND VGND VPWR VPWR _6032_/CLK sky130_fd_sc_hd__clkbuf_8
X_4752_ _4752_/A1 _4772_/A2 _4772_/B1 _4752_/B2 VGND VGND VPWR VPWR _5790_/D sky130_fd_sc_hd__a22o_2
X_4683_ _4752_/A1 _4703_/A2 _4703_/B1 _4683_/B2 VGND VGND VPWR VPWR _5726_/D sky130_fd_sc_hd__a22o_2
X_3703_ _3939_/A1 _3685_/X _3702_/X _3253_/X VGND VGND VPWR VPWR _3703_/X sky130_fd_sc_hd__a22o_2
X_3634_ _3626_/A _3629_/X _3632_/X _3633_/X VGND VGND VPWR VPWR _3634_/X sky130_fd_sc_hd__o211a_2
X_3565_ _3713_/A1 _3563_/X _3564_/X _3713_/B2 VGND VGND VPWR VPWR _3565_/X sky130_fd_sc_hd__o22a_2
XFILLER_115_565 VGND VGND VPWR VPWR sky130_fd_sc_hd__decap_3
X_5304_ _6040_/CLK _5304_/D VGND VGND VPWR VPWR _5304_/Q sky130_fd_sc_hd__dfxtp_2
X_3496_ _3496_/A _3496_/B VGND VGND VPWR VPWR _3496_/X sky130_fd_sc_hd__or2_2
X_2516_ _2608_/A _2516_/B VGND VGND VPWR VPWR _2516_/Y sky130_fd_sc_hd__nor2_2
XFILLER_115_587 VGND VGND VPWR VPWR sky130_fd_sc_hd__fill_1
XFILLER_115_598 VGND VGND VPWR VPWR sky130_fd_sc_hd__decap_3
X_5235_ _6037_/CLK _5235_/D VGND VGND VPWR VPWR _5235_/Q sky130_fd_sc_hd__dfxtp_2
XFILLER_102_237 VGND VGND VPWR VPWR sky130_fd_sc_hd__decap_3
XTAP_TAPCELL_ROW_110_1565 VGND VPWR sky130_fd_sc_hd__tapvpwrvgnd_1
Xhold1802 _5954_/Q VGND VGND VPWR VPWR _4924_/B2 sky130_fd_sc_hd__dlygate4sd3_1
XFILLER_29_505 VGND VGND VPWR VPWR sky130_fd_sc_hd__decap_3
Xhold1813 _5500_/Q VGND VGND VPWR VPWR _4442_/B2 sky130_fd_sc_hd__dlygate4sd3_1
Xhold1824 _5394_/Q VGND VGND VPWR VPWR _4326_/B2 sky130_fd_sc_hd__dlygate4sd3_1
Xhold1835 _5899_/Q VGND VGND VPWR VPWR _4865_/B2 sky130_fd_sc_hd__dlygate4sd3_1
X_5166_ _6030_/CLK _5166_/D VGND VGND VPWR VPWR _5166_/Q sky130_fd_sc_hd__dfxtp_2
Xhold1846 _5971_/Q VGND VGND VPWR VPWR _4941_/B2 sky130_fd_sc_hd__dlygate4sd3_1
Xhold1857 _5961_/Q VGND VGND VPWR VPWR _4931_/B2 sky130_fd_sc_hd__dlygate4sd3_1
Xhold1868 _5104_/Q VGND VGND VPWR VPWR _4013_/B2 sky130_fd_sc_hd__dlygate4sd3_1
X_5097_ _6012_/CLK _5097_/D VGND VGND VPWR VPWR _5097_/Q sky130_fd_sc_hd__dfxtp_2
X_4117_ _5004_/A1 _4094_/B _4123_/B1 _4117_/B2 VGND VGND VPWR VPWR _5198_/D sky130_fd_sc_hd__a22o_2
XFILLER_17_47 VGND VGND VPWR VPWR sky130_fd_sc_hd__decap_3
Xhold1879 _5370_/Q VGND VGND VPWR VPWR _4302_/B2 sky130_fd_sc_hd__dlygate4sd3_1
X_4048_ _4530_/A1 _4023_/B _4052_/B1 _4048_/B2 VGND VGND VPWR VPWR _5136_/D sky130_fd_sc_hd__a22o_2
XTAP_TAPCELL_ROW_65_1033 VGND VPWR sky130_fd_sc_hd__tapvpwrvgnd_1
X_5999_ _5999_/CLK _5999_/D VGND VGND VPWR VPWR _5999_/Q sky130_fd_sc_hd__dfxtp_2
XFILLER_33_57 VGND VGND VPWR VPWR sky130_fd_sc_hd__decap_3
XFILLER_4_626 VGND VGND VPWR VPWR sky130_fd_sc_hd__decap_3
XFILLER_106_521 VGND VGND VPWR VPWR sky130_fd_sc_hd__decap_3
XFILLER_109_3 VGND VGND VPWR VPWR sky130_fd_sc_hd__decap_3
XFILLER_4_648 VGND VGND VPWR VPWR sky130_fd_sc_hd__decap_3
XTAP_TAPCELL_ROW_76_1162 VGND VPWR sky130_fd_sc_hd__tapvpwrvgnd_1
XFILLER_59_151 VGND VGND VPWR VPWR sky130_fd_sc_hd__fill_1
XFILLER_94_419 VGND VGND VPWR VPWR sky130_fd_sc_hd__fill_1
XFILLER_101_281 VGND VGND VPWR VPWR sky130_fd_sc_hd__fill_2
XFILLER_59_195 VGND VGND VPWR VPWR sky130_fd_sc_hd__decap_3
XFILLER_74_110 VGND VGND VPWR VPWR sky130_fd_sc_hd__fill_2
XFILLER_74_121 VGND VGND VPWR VPWR sky130_fd_sc_hd__fill_2
Xwire1043 _3870_/S1 VGND VGND VPWR VPWR _3917_/S1 sky130_fd_sc_hd__clkbuf_4
XFILLER_114_71 VGND VGND VPWR VPWR sky130_fd_sc_hd__decap_3
XFILLER_90_614 VGND VGND VPWR VPWR sky130_fd_sc_hd__decap_3
XFILLER_90_636 VGND VGND VPWR VPWR sky130_fd_sc_hd__decap_3
XTAP_TAPCELL_ROW_87_1291 VGND VPWR sky130_fd_sc_hd__tapvpwrvgnd_1
XFILLER_15_265 VGND VGND VPWR VPWR sky130_fd_sc_hd__decap_3
XFILLER_15_276 VGND VGND VPWR VPWR sky130_fd_sc_hd__decap_3
XFILLER_95_9 VGND VGND VPWR VPWR sky130_fd_sc_hd__fill_1
XTAP_TAPCELL_ROW_13_400 VGND VPWR sky130_fd_sc_hd__tapvpwrvgnd_1
XFILLER_15_298 VGND VGND VPWR VPWR sky130_fd_sc_hd__decap_3
XTAP_TAPCELL_ROW_13_411 VGND VPWR sky130_fd_sc_hd__tapvpwrvgnd_1
XTAP_TAPCELL_ROW_41_742 VGND VPWR sky130_fd_sc_hd__tapvpwrvgnd_1
XFILLER_11_460 VGND VGND VPWR VPWR sky130_fd_sc_hd__fill_2
XFILLER_7_420 VGND VGND VPWR VPWR sky130_fd_sc_hd__fill_1
XFILLER_7_475 VGND VGND VPWR VPWR sky130_fd_sc_hd__decap_3
X_3350_ wire628/X _3344_/X _3347_/X _3349_/X VGND VGND VPWR VPWR _3350_/X sky130_fd_sc_hd__a22o_2
XFILLER_97_268 VGND VGND VPWR VPWR sky130_fd_sc_hd__decap_3
X_5020_ _5020_/A1 _5043_/A2 wire115/X _5020_/B2 VGND VGND VPWR VPWR _6044_/D sky130_fd_sc_hd__a22o_2
X_3281_ _5913_/Q _5881_/Q _5849_/Q _5753_/Q _3284_/S _3629_/S1 VGND VGND VPWR VPWR
+ _3282_/B sky130_fd_sc_hd__mux4_2
XFILLER_24_3 VGND VGND VPWR VPWR sky130_fd_sc_hd__decap_3
Xclkbuf_leaf_2_clk clkbuf_4_2_0_clk/X VGND VGND VPWR VPWR _5824_/CLK sky130_fd_sc_hd__clkbuf_8
XFILLER_93_430 VGND VGND VPWR VPWR sky130_fd_sc_hd__fill_1
XTAP_TAPCELL_ROW_49_842 VGND VPWR sky130_fd_sc_hd__tapvpwrvgnd_1
XFILLER_0_50 VGND VGND VPWR VPWR sky130_fd_sc_hd__decap_3
XFILLER_53_316 VGND VGND VPWR VPWR sky130_fd_sc_hd__fill_2
XFILLER_0_94 VGND VGND VPWR VPWR sky130_fd_sc_hd__decap_3
XFILLER_81_669 VGND VGND VPWR VPWR sky130_fd_sc_hd__decap_3
X_5922_ _5922_/CLK _5922_/D VGND VGND VPWR VPWR _5922_/Q sky130_fd_sc_hd__dfxtp_2
XFILLER_110_18 VGND VGND VPWR VPWR sky130_fd_sc_hd__decap_3
XFILLER_110_29 VGND VGND VPWR VPWR sky130_fd_sc_hd__decap_3
X_5853_ _5885_/CLK _5853_/D VGND VGND VPWR VPWR _5853_/Q sky130_fd_sc_hd__dfxtp_2
X_5784_ _5812_/CLK _5784_/D VGND VGND VPWR VPWR _5784_/Q sky130_fd_sc_hd__dfxtp_2
X_4804_ _4807_/A_N _4804_/B VGND VGND VPWR VPWR _5842_/D sky130_fd_sc_hd__and2b_2
XFILLER_21_279 VGND VGND VPWR VPWR sky130_fd_sc_hd__fill_1
X_4735_ _4903_/A1 _4742_/A2 _4740_/B1 _4735_/B2 VGND VGND VPWR VPWR _5775_/D sky130_fd_sc_hd__a22o_2
X_2996_ _5389_/Q _5357_/Q _5325_/Q _5293_/Q _3115_/S _2996_/S1 VGND VGND VPWR VPWR
+ _2996_/X sky130_fd_sc_hd__mux4_2
XFILLER_107_318 VGND VGND VPWR VPWR sky130_fd_sc_hd__decap_3
X_4666_ _4903_/A1 _4673_/A2 _4673_/B1 _4666_/B2 VGND VGND VPWR VPWR _5711_/D sky130_fd_sc_hd__a22o_2
X_4597_ _5038_/A1 wire414/X wire193/X _4597_/B2 VGND VGND VPWR VPWR _5646_/D sky130_fd_sc_hd__a22o_2
X_3617_ _5513_/Q _5481_/Q _3743_/S VGND VGND VPWR VPWR _3617_/X sky130_fd_sc_hd__mux2_1
X_3548_ _3548_/A1 _3544_/X _3547_/X _3939_/A1 VGND VGND VPWR VPWR _3548_/X sky130_fd_sc_hd__o211a_2
XFILLER_103_502 VGND VGND VPWR VPWR sky130_fd_sc_hd__fill_2
XFILLER_1_629 VGND VGND VPWR VPWR sky130_fd_sc_hd__decap_3
XFILLER_103_557 VGND VGND VPWR VPWR sky130_fd_sc_hd__decap_3
X_3479_ _5570_/Q _5538_/Q _3926_/S VGND VGND VPWR VPWR _3479_/X sky130_fd_sc_hd__mux2_1
XFILLER_57_611 VGND VGND VPWR VPWR sky130_fd_sc_hd__decap_3
Xhold1610 _5615_/Q VGND VGND VPWR VPWR _4564_/B2 sky130_fd_sc_hd__dlygate4sd3_1
X_5218_ _5794_/CLK _5218_/D VGND VGND VPWR VPWR _5218_/Q sky130_fd_sc_hd__dfxtp_2
XFILLER_111_590 VGND VGND VPWR VPWR sky130_fd_sc_hd__decap_3
XFILLER_28_24 VGND VGND VPWR VPWR sky130_fd_sc_hd__decap_3
XFILLER_28_35 VGND VGND VPWR VPWR sky130_fd_sc_hd__fill_1
XFILLER_28_57 VGND VGND VPWR VPWR sky130_fd_sc_hd__decap_3
XFILLER_29_313 VGND VGND VPWR VPWR sky130_fd_sc_hd__decap_3
XFILLER_57_644 VGND VGND VPWR VPWR sky130_fd_sc_hd__fill_1
XFILLER_96_290 VGND VGND VPWR VPWR sky130_fd_sc_hd__fill_1
Xhold1621 _5172_/Q VGND VGND VPWR VPWR _4088_/B2 sky130_fd_sc_hd__dlygate4sd3_1
Xhold1632 _5090_/Q VGND VGND VPWR VPWR _3999_/B2 sky130_fd_sc_hd__dlygate4sd3_1
Xhold1643 _5467_/Q VGND VGND VPWR VPWR _4407_/B2 sky130_fd_sc_hd__dlygate4sd3_1
X_5149_ _5810_/CLK _5149_/D VGND VGND VPWR VPWR _5149_/Q sky130_fd_sc_hd__dfxtp_2
XFILLER_17_508 VGND VGND VPWR VPWR sky130_fd_sc_hd__fill_1
XFILLER_29_357 VGND VGND VPWR VPWR sky130_fd_sc_hd__decap_3
XFILLER_84_441 VGND VGND VPWR VPWR sky130_fd_sc_hd__fill_1
XFILLER_84_474 VGND VGND VPWR VPWR sky130_fd_sc_hd__fill_2
Xhold1654 _5737_/Q VGND VGND VPWR VPWR _4694_/B2 sky130_fd_sc_hd__dlygate4sd3_1
Xhold1665 _5609_/Q VGND VGND VPWR VPWR _4558_/B2 sky130_fd_sc_hd__dlygate4sd3_1
Xhold1676 _5802_/Q VGND VGND VPWR VPWR _4764_/B2 sky130_fd_sc_hd__dlygate4sd3_1
Xhold1687 _5945_/Q VGND VGND VPWR VPWR _4915_/B2 sky130_fd_sc_hd__dlygate4sd3_1
XFILLER_44_327 VGND VGND VPWR VPWR sky130_fd_sc_hd__fill_1
XFILLER_56_187 VGND VGND VPWR VPWR sky130_fd_sc_hd__fill_1
XFILLER_71_113 VGND VGND VPWR VPWR sky130_fd_sc_hd__decap_3
Xhold1698 _6044_/Q VGND VGND VPWR VPWR _5020_/B2 sky130_fd_sc_hd__dlygate4sd3_1
XFILLER_44_23 VGND VGND VPWR VPWR sky130_fd_sc_hd__decap_3
XFILLER_71_146 VGND VGND VPWR VPWR sky130_fd_sc_hd__decap_3
XTAP_TAPCELL_ROW_27_569 VGND VPWR sky130_fd_sc_hd__tapvpwrvgnd_1
XFILLER_44_45 VGND VGND VPWR VPWR sky130_fd_sc_hd__decap_3
XFILLER_40_522 VGND VGND VPWR VPWR sky130_fd_sc_hd__fill_1
XFILLER_8_228 VGND VGND VPWR VPWR sky130_fd_sc_hd__decap_3
XFILLER_60_88 VGND VGND VPWR VPWR sky130_fd_sc_hd__decap_3
XFILLER_109_60 VGND VGND VPWR VPWR sky130_fd_sc_hd__decap_3
XFILLER_5_39 VGND VGND VPWR VPWR sky130_fd_sc_hd__decap_3
XFILLER_109_93 VGND VGND VPWR VPWR sky130_fd_sc_hd__decap_3
XFILLER_69_53 VGND VGND VPWR VPWR sky130_fd_sc_hd__decap_3
XFILLER_0_640 VGND VGND VPWR VPWR sky130_fd_sc_hd__decap_3
XFILLER_0_651 VGND VGND VPWR VPWR sky130_fd_sc_hd__decap_3
XFILLER_0_673 VGND VGND VPWR VPWR sky130_fd_sc_hd__decap_3
XFILLER_10_9 VGND VGND VPWR VPWR sky130_fd_sc_hd__decap_3
XTAP_TAPCELL_ROW_89_1320 VGND VPWR sky130_fd_sc_hd__tapvpwrvgnd_1
XTAP_TAPCELL_ROW_46_801 VGND VPWR sky130_fd_sc_hd__tapvpwrvgnd_1
XFILLER_62_124 VGND VGND VPWR VPWR sky130_fd_sc_hd__decap_3
XFILLER_90_477 VGND VGND VPWR VPWR sky130_fd_sc_hd__fill_1
XFILLER_93_6 VGND VGND VPWR VPWR sky130_fd_sc_hd__decap_3
X_2850_ _5927_/Q _5895_/Q _5863_/Q _5767_/Q _3209_/S0 _3225_/S1 VGND VGND VPWR VPWR
+ _2850_/X sky130_fd_sc_hd__mux4_2
X_2781_ _2774_/X _2780_/X _2712_/D VGND VGND VPWR VPWR _2781_/X sky130_fd_sc_hd__o21a_2
X_4520_ _4520_/A1 _4532_/A2 _4532_/B1 _4520_/B2 VGND VGND VPWR VPWR _5574_/D sky130_fd_sc_hd__a22o_2
X_4451_ _4519_/A1 _4437_/B _4453_/B1 _4451_/B2 VGND VGND VPWR VPWR _5509_/D sky130_fd_sc_hd__a22o_2
X_3402_ _5247_/Q _5215_/Q _3402_/S VGND VGND VPWR VPWR _3402_/X sky130_fd_sc_hd__mux2_1
XFILLER_98_500 VGND VGND VPWR VPWR sky130_fd_sc_hd__decap_3
X_4382_ _4927_/A1 wire459/X _4400_/B1 _4382_/B2 VGND VGND VPWR VPWR _5445_/D sky130_fd_sc_hd__a22o_2
Xfanout719 _2494_/Y VGND VGND VPWR VPWR fanout719/X sky130_fd_sc_hd__clkdlybuf4s25_1
Xfanout708 _3470_/S VGND VGND VPWR VPWR _3827_/S sky130_fd_sc_hd__clkdlybuf4s25_1
X_3333_ _5500_/Q _5468_/Q _3487_/S VGND VGND VPWR VPWR _3333_/X sky130_fd_sc_hd__mux2_1
XFILLER_100_527 VGND VGND VPWR VPWR sky130_fd_sc_hd__decap_3
XFILLER_105_18 VGND VGND VPWR VPWR sky130_fd_sc_hd__decap_3
XFILLER_98_577 VGND VGND VPWR VPWR sky130_fd_sc_hd__decap_3
XPHY_EDGE_ROW_7_Right_7 VGND VGND VPWR VPWR sky130_fd_sc_hd__decap_3
Xload_slew142 _4895_/B1 VGND VGND VPWR VPWR _4908_/B1 sky130_fd_sc_hd__clkbuf_4
X_6052_ _6052_/CLK _6052_/D VGND VGND VPWR VPWR _6052_/Q sky130_fd_sc_hd__dfxtp_2
X_3264_ _3256_/X _3263_/X wire553/X VGND VGND VPWR VPWR _3264_/X sky130_fd_sc_hd__o21a_2
XFILLER_39_644 VGND VGND VPWR VPWR sky130_fd_sc_hd__decap_3
X_5003_ _5003_/A1 _5008_/A2 _5008_/B1 _5003_/B2 VGND VGND VPWR VPWR _6029_/D sky130_fd_sc_hd__a22o_2
XFILLER_54_603 VGND VGND VPWR VPWR sky130_fd_sc_hd__decap_3
X_3195_ _3195_/A1 _3193_/X _3194_/X wire685/A VGND VGND VPWR VPWR _3195_/X sky130_fd_sc_hd__o22a_2
XFILLER_93_293 VGND VGND VPWR VPWR sky130_fd_sc_hd__decap_3
X_5905_ _6065_/CLK _5905_/D VGND VGND VPWR VPWR _5905_/Q sky130_fd_sc_hd__dfxtp_2
XFILLER_22_522 VGND VGND VPWR VPWR sky130_fd_sc_hd__fill_1
XFILLER_22_533 VGND VGND VPWR VPWR sky130_fd_sc_hd__fill_2
XTAP_TAPCELL_ROW_24_539 VGND VPWR sky130_fd_sc_hd__tapvpwrvgnd_1
XFILLER_14_59 VGND VGND VPWR VPWR sky130_fd_sc_hd__decap_3
XFILLER_22_555 VGND VGND VPWR VPWR sky130_fd_sc_hd__decap_3
X_5836_ _6060_/CLK _5836_/D VGND VGND VPWR VPWR _5836_/Q sky130_fd_sc_hd__dfxtp_2
X_5767_ _5943_/CLK _5767_/D VGND VGND VPWR VPWR _5767_/Q sky130_fd_sc_hd__dfxtp_2
X_2979_ _5388_/Q _5356_/Q _5324_/Q _5292_/Q _2981_/S _2979_/S1 VGND VGND VPWR VPWR
+ _2979_/X sky130_fd_sc_hd__mux4_2
XFILLER_108_616 VGND VGND VPWR VPWR sky130_fd_sc_hd__fill_2
X_5698_ _5794_/CLK _5698_/D VGND VGND VPWR VPWR _5698_/Q sky130_fd_sc_hd__dfxtp_2
X_4718_ _4886_/A1 _4741_/A2 _4741_/B1 _4718_/B2 VGND VGND VPWR VPWR _5758_/D sky130_fd_sc_hd__a22o_2
X_4649_ _4752_/A1 _4674_/A2 _4674_/B1 _4649_/B2 VGND VGND VPWR VPWR _5694_/D sky130_fd_sc_hd__a22o_2
XFILLER_107_159 VGND VGND VPWR VPWR sky130_fd_sc_hd__decap_3
XFILLER_30_58 VGND VGND VPWR VPWR sky130_fd_sc_hd__fill_1
XFILLER_89_522 VGND VGND VPWR VPWR sky130_fd_sc_hd__fill_1
XTAP_TAPCELL_ROW_73_1121 VGND VPWR sky130_fd_sc_hd__tapvpwrvgnd_1
Xhold2130 _5827_/Q VGND VGND VPWR VPWR _4789_/B sky130_fd_sc_hd__dlygate4sd3_1
Xhold2141 _5448_/Q VGND VGND VPWR VPWR _4385_/B2 sky130_fd_sc_hd__dlygate4sd3_1
Xhold2152 _5820_/Q VGND VGND VPWR VPWR _4782_/B sky130_fd_sc_hd__dlygate4sd3_1
Xhold1440 _5183_/Q VGND VGND VPWR VPWR _4102_/B2 sky130_fd_sc_hd__dlygate4sd3_1
Xhold1451 _5357_/Q VGND VGND VPWR VPWR _4287_/B2 sky130_fd_sc_hd__dlygate4sd3_1
XTAP_TAPCELL_ROW_4_297 VGND VPWR sky130_fd_sc_hd__tapvpwrvgnd_1
Xhold1462 _5152_/Q VGND VGND VPWR VPWR _4068_/B2 sky130_fd_sc_hd__dlygate4sd3_1
Xhold1473 _5460_/Q VGND VGND VPWR VPWR _4397_/B2 sky130_fd_sc_hd__dlygate4sd3_1
Xhold1484 _5322_/Q VGND VGND VPWR VPWR _4250_/B2 sky130_fd_sc_hd__dlygate4sd3_1
Xhold1495 _5386_/Q VGND VGND VPWR VPWR _4318_/B2 sky130_fd_sc_hd__dlygate4sd3_1
XFILLER_13_500 VGND VGND VPWR VPWR sky130_fd_sc_hd__decap_3
XFILLER_44_179 VGND VGND VPWR VPWR sky130_fd_sc_hd__fill_1
XFILLER_72_477 VGND VGND VPWR VPWR sky130_fd_sc_hd__decap_3
XTAP_TAPCELL_ROW_84_1261 VGND VPWR sky130_fd_sc_hd__tapvpwrvgnd_1
XFILLER_111_72 VGND VGND VPWR VPWR sky130_fd_sc_hd__decap_3
XFILLER_9_515 VGND VGND VPWR VPWR sky130_fd_sc_hd__fill_1
XFILLER_9_548 VGND VGND VPWR VPWR sky130_fd_sc_hd__decap_3
XFILLER_114_619 VGND VGND VPWR VPWR sky130_fd_sc_hd__decap_3
XFILLER_107_660 VGND VGND VPWR VPWR sky130_fd_sc_hd__decap_3
XFILLER_107_682 VGND VGND VPWR VPWR sky130_fd_sc_hd__decap_3
XTAP_TAPCELL_ROW_95_1390 VGND VPWR sky130_fd_sc_hd__tapvpwrvgnd_1
XFILLER_95_503 VGND VGND VPWR VPWR sky130_fd_sc_hd__fill_1
XFILLER_95_547 VGND VGND VPWR VPWR sky130_fd_sc_hd__decap_3
XFILLER_95_558 VGND VGND VPWR VPWR sky130_fd_sc_hd__fill_2
XFILLER_63_422 VGND VGND VPWR VPWR sky130_fd_sc_hd__fill_1
X_3951_ _4913_/A _3951_/B VGND VGND VPWR VPWR _3951_/Y sky130_fd_sc_hd__nor2_2
XFILLER_16_371 VGND VGND VPWR VPWR sky130_fd_sc_hd__decap_3
X_2902_ _5513_/Q _5481_/Q _3026_/S VGND VGND VPWR VPWR _2902_/X sky130_fd_sc_hd__mux2_1
XFILLER_91_3 VGND VGND VPWR VPWR sky130_fd_sc_hd__decap_3
X_3882_ _3385_/A _3879_/X _3881_/X VGND VGND VPWR VPWR _3882_/X sky130_fd_sc_hd__a21o_2
XFILLER_31_396 VGND VGND VPWR VPWR sky130_fd_sc_hd__decap_3
X_5621_ _5813_/CLK _5621_/D VGND VGND VPWR VPWR _5621_/Q sky130_fd_sc_hd__dfxtp_2
X_2833_ _5382_/Q _5350_/Q _5318_/Q _5286_/Q _2589_/S wire760/X VGND VGND VPWR VPWR
+ _2833_/X sky130_fd_sc_hd__mux4_2
X_5552_ _6027_/CLK _5552_/D VGND VGND VPWR VPWR _5552_/Q sky130_fd_sc_hd__dfxtp_2
X_2764_ _5379_/Q _5347_/Q _5315_/Q _5283_/Q _2760_/S _3024_/S1 VGND VGND VPWR VPWR
+ _2764_/X sky130_fd_sc_hd__mux4_2
X_4503_ _4843_/A1 _4503_/A2 _4503_/B1 _4503_/B2 VGND VGND VPWR VPWR _5559_/D sky130_fd_sc_hd__a22o_2
X_5483_ _5547_/CLK _5483_/D VGND VGND VPWR VPWR _5483_/Q sky130_fd_sc_hd__dfxtp_2
X_2695_ _5920_/Q _5888_/Q _5856_/Q _5760_/Q _2777_/S _3013_/S1 VGND VGND VPWR VPWR
+ _2695_/X sky130_fd_sc_hd__mux4_2
X_4434_ _4468_/A1 _4434_/A2 _4434_/B1 _4434_/B2 VGND VGND VPWR VPWR _5494_/D sky130_fd_sc_hd__a22o_2
XFILLER_113_641 VGND VGND VPWR VPWR sky130_fd_sc_hd__decap_3
Xfanout505 wire508/A VGND VGND VPWR VPWR _4154_/A2 sky130_fd_sc_hd__dlymetal6s4s_1
X_4365_ _4777_/A1 _4365_/A2 _4365_/B1 _4365_/B2 VGND VGND VPWR VPWR _5431_/D sky130_fd_sc_hd__a22o_2
XFILLER_113_685 VGND VGND VPWR VPWR sky130_fd_sc_hd__decap_3
XFILLER_86_503 VGND VGND VPWR VPWR sky130_fd_sc_hd__decap_3
XFILLER_86_514 VGND VGND VPWR VPWR sky130_fd_sc_hd__decap_3
XFILLER_98_363 VGND VGND VPWR VPWR sky130_fd_sc_hd__fill_1
Xfanout527 _4022_/Y VGND VGND VPWR VPWR _4040_/A2 sky130_fd_sc_hd__clkdlybuf4s25_1
X_3316_ _5691_/Q _5659_/Q _5627_/Q _5595_/Q _3318_/S _3566_/S1 VGND VGND VPWR VPWR
+ _3316_/X sky130_fd_sc_hd__mux4_2
XFILLER_100_324 VGND VGND VPWR VPWR sky130_fd_sc_hd__decap_3
XFILLER_86_536 VGND VGND VPWR VPWR sky130_fd_sc_hd__decap_3
Xfanout549 _3235_/X VGND VGND VPWR VPWR _3899_/B1 sky130_fd_sc_hd__dlymetal6s2s_1
X_6035_ _6035_/CLK _6035_/D VGND VGND VPWR VPWR _6035_/Q sky130_fd_sc_hd__dfxtp_2
X_4296_ _4468_/A1 _4297_/A2 _4297_/B1 _4296_/B2 VGND VGND VPWR VPWR _5366_/D sky130_fd_sc_hd__a22o_2
XFILLER_39_452 VGND VGND VPWR VPWR sky130_fd_sc_hd__decap_3
X_3247_ _5496_/Q _5464_/Q _3774_/S VGND VGND VPWR VPWR _3247_/X sky130_fd_sc_hd__mux2_1
XFILLER_54_411 VGND VGND VPWR VPWR sky130_fd_sc_hd__fill_1
XFILLER_73_219 VGND VGND VPWR VPWR sky130_fd_sc_hd__decap_3
XTAP_TAPCELL_ROW_57_929 VGND VPWR sky130_fd_sc_hd__tapvpwrvgnd_1
X_3178_ _3178_/A1 _3176_/X _3177_/X wire676/A VGND VGND VPWR VPWR _3178_/X sky130_fd_sc_hd__o22a_2
XFILLER_27_669 VGND VGND VPWR VPWR sky130_fd_sc_hd__decap_3
XTAP_TAPCELL_ROW_107_1537 VGND VPWR sky130_fd_sc_hd__tapvpwrvgnd_1
XTAP_TAPCELL_ROW_1_256 VGND VPWR sky130_fd_sc_hd__tapvpwrvgnd_1
XTAP_TAPCELL_ROW_1_267 VGND VPWR sky130_fd_sc_hd__tapvpwrvgnd_1
XFILLER_42_628 VGND VGND VPWR VPWR sky130_fd_sc_hd__decap_3
XFILLER_41_127 VGND VGND VPWR VPWR sky130_fd_sc_hd__fill_2
XTAP_TAPCELL_ROW_37_697 VGND VPWR sky130_fd_sc_hd__tapvpwrvgnd_1
XFILLER_10_525 VGND VGND VPWR VPWR sky130_fd_sc_hd__decap_3
X_5819_ _6043_/CLK _5819_/D VGND VGND VPWR VPWR _5819_/Q sky130_fd_sc_hd__dfxtp_2
XFILLER_10_536 VGND VGND VPWR VPWR sky130_fd_sc_hd__fill_1
XFILLER_108_435 VGND VGND VPWR VPWR sky130_fd_sc_hd__decap_3
XFILLER_1_201 VGND VGND VPWR VPWR sky130_fd_sc_hd__decap_3
XFILLER_104_630 VGND VGND VPWR VPWR sky130_fd_sc_hd__fill_1
XTAP_TAPCELL_ROW_9_356 VGND VPWR sky130_fd_sc_hd__tapvpwrvgnd_1
XFILLER_104_663 VGND VGND VPWR VPWR sky130_fd_sc_hd__decap_3
XFILLER_89_352 VGND VGND VPWR VPWR sky130_fd_sc_hd__decap_3
XFILLER_106_50 VGND VGND VPWR VPWR sky130_fd_sc_hd__decap_3
XFILLER_2_18 VGND VGND VPWR VPWR sky130_fd_sc_hd__decap_3
XFILLER_2_29 VGND VGND VPWR VPWR sky130_fd_sc_hd__decap_3
XFILLER_89_396 VGND VGND VPWR VPWR sky130_fd_sc_hd__fill_2
XFILLER_106_83 VGND VGND VPWR VPWR sky130_fd_sc_hd__fill_1
XFILLER_77_569 VGND VGND VPWR VPWR sky130_fd_sc_hd__decap_3
XFILLER_92_506 VGND VGND VPWR VPWR sky130_fd_sc_hd__decap_3
XFILLER_92_528 VGND VGND VPWR VPWR sky130_fd_sc_hd__decap_3
Xhold1270 _5312_/Q VGND VGND VPWR VPWR _4240_/B2 sky130_fd_sc_hd__dlygate4sd3_1
XFILLER_17_113 VGND VGND VPWR VPWR sky130_fd_sc_hd__decap_3
XFILLER_85_591 VGND VGND VPWR VPWR sky130_fd_sc_hd__decap_3
Xhold1281 _5991_/Q VGND VGND VPWR VPWR _4963_/B2 sky130_fd_sc_hd__dlygate4sd3_1
Xhold1292 _5268_/Q VGND VGND VPWR VPWR _4191_/B2 sky130_fd_sc_hd__dlygate4sd3_1
XFILLER_17_179 VGND VGND VPWR VPWR sky130_fd_sc_hd__fill_1
XFILLER_82_97 VGND VGND VPWR VPWR sky130_fd_sc_hd__decap_3
XFILLER_9_312 VGND VGND VPWR VPWR sky130_fd_sc_hd__fill_2
XFILLER_13_396 VGND VGND VPWR VPWR sky130_fd_sc_hd__decap_3
XFILLER_5_573 VGND VGND VPWR VPWR sky130_fd_sc_hd__fill_1
XFILLER_99_105 VGND VGND VPWR VPWR sky130_fd_sc_hd__decap_3
XFILLER_99_116 VGND VGND VPWR VPWR sky130_fd_sc_hd__fill_2
Xoutput108 _3351_/X VGND VGND VPWR VPWR rd2[4] sky130_fd_sc_hd__buf_6
X_4150_ _5003_/A1 _4155_/A2 wire292/X _4150_/B2 VGND VGND VPWR VPWR _5229_/D sky130_fd_sc_hd__a22o_2
Xoutput90 _3636_/X VGND VGND VPWR VPWR rd2[17] sky130_fd_sc_hd__buf_2
X_3101_ _2830_/A _3098_/X _3100_/X VGND VGND VPWR VPWR _3101_/X sky130_fd_sc_hd__a21o_2
XFILLER_110_666 VGND VGND VPWR VPWR sky130_fd_sc_hd__decap_3
X_4081_ _5037_/A1 wire526/X _4086_/B1 _4081_/B2 VGND VGND VPWR VPWR _5165_/D sky130_fd_sc_hd__a22o_2
X_3032_ _5839_/Q _5455_/Q _3038_/S VGND VGND VPWR VPWR _3032_/X sky130_fd_sc_hd__mux2_1
XFILLER_102_19 VGND VGND VPWR VPWR sky130_fd_sc_hd__decap_3
X_4983_ _4983_/A1 _5011_/A2 _5011_/B1 _4983_/B2 VGND VGND VPWR VPWR _6009_/D sky130_fd_sc_hd__a22o_2
XTAP_TAPCELL_ROW_34_656 VGND VPWR sky130_fd_sc_hd__tapvpwrvgnd_1
X_3934_ _5143_/Q _5111_/Q _6039_/Q _6007_/Q _3936_/S _3940_/S1 VGND VGND VPWR VPWR
+ _3934_/X sky130_fd_sc_hd__mux4_2
XTAP_TAPCELL_ROW_102_1478 VGND VPWR sky130_fd_sc_hd__tapvpwrvgnd_1
XTAP_TAPCELL_ROW_62_998 VGND VPWR sky130_fd_sc_hd__tapvpwrvgnd_1
X_3865_ _3867_/A _3861_/X _3864_/X _3916_/B1 VGND VGND VPWR VPWR _3865_/X sky130_fd_sc_hd__o211a_2
X_5604_ _6052_/CLK _5604_/D VGND VGND VPWR VPWR _5604_/Q sky130_fd_sc_hd__dfxtp_2
X_2816_ _2816_/A _2816_/B VGND VGND VPWR VPWR _2816_/X sky130_fd_sc_hd__or2_2
X_3796_ _3800_/A _3796_/B VGND VGND VPWR VPWR _3796_/X sky130_fd_sc_hd__or2_2
XFILLER_11_49 VGND VGND VPWR VPWR sky130_fd_sc_hd__decap_3
X_5535_ _5866_/CLK _5535_/D VGND VGND VPWR VPWR _5535_/Q sky130_fd_sc_hd__dfxtp_2
X_2747_ _3108_/A _2747_/B VGND VGND VPWR VPWR _2747_/X sky130_fd_sc_hd__or2_2
X_5466_ _5658_/CLK _5466_/D VGND VGND VPWR VPWR _5466_/Q sky130_fd_sc_hd__dfxtp_2
X_2678_ _5183_/Q _5151_/Q _2678_/S VGND VGND VPWR VPWR _2678_/X sky130_fd_sc_hd__mux2_1
X_4417_ _4519_/A1 _4403_/B _4419_/B1 _4417_/B2 VGND VGND VPWR VPWR _5477_/D sky130_fd_sc_hd__a22o_2
XTAP_TAPCELL_ROW_6_326 VGND VPWR sky130_fd_sc_hd__tapvpwrvgnd_1
X_5397_ _5525_/CLK _5397_/D VGND VGND VPWR VPWR _5397_/Q sky130_fd_sc_hd__dfxtp_2
XFILLER_59_514 VGND VGND VPWR VPWR sky130_fd_sc_hd__decap_3
XFILLER_86_322 VGND VGND VPWR VPWR sky130_fd_sc_hd__fill_1
Xfanout335 _4980_/Y VGND VGND VPWR VPWR _4998_/A2 sky130_fd_sc_hd__clkdlybuf4s25_1
Xfanout324 wire327/X VGND VGND VPWR VPWR wire325/A sky130_fd_sc_hd__clkdlybuf4s25_1
X_4348_ _4520_/A1 wire465/X _4350_/B1 _4348_/B2 VGND VGND VPWR VPWR _5414_/D sky130_fd_sc_hd__a22o_2
XFILLER_86_355 VGND VGND VPWR VPWR sky130_fd_sc_hd__fill_1
Xfanout368 _4844_/Y VGND VGND VPWR VPWR _4870_/A2 sky130_fd_sc_hd__clkdlybuf4s25_1
X_4279_ _4519_/A1 _4265_/B _4294_/B1 _4279_/B2 VGND VGND VPWR VPWR _5349_/D sky130_fd_sc_hd__a22o_2
X_6018_ _6071_/CLK _6018_/D VGND VGND VPWR VPWR _6018_/Q sky130_fd_sc_hd__dfxtp_2
XFILLER_27_433 VGND VGND VPWR VPWR sky130_fd_sc_hd__fill_1
XFILLER_36_46 VGND VGND VPWR VPWR sky130_fd_sc_hd__fill_1
XFILLER_15_606 VGND VGND VPWR VPWR sky130_fd_sc_hd__fill_2
XTAP_TAPCELL_ROW_68_1064 VGND VPWR sky130_fd_sc_hd__tapvpwrvgnd_1
XFILLER_14_127 VGND VGND VPWR VPWR sky130_fd_sc_hd__decap_3
XFILLER_15_639 VGND VGND VPWR VPWR sky130_fd_sc_hd__decap_3
XTAP_TAPCELL_ROW_81_1220 VGND VPWR sky130_fd_sc_hd__tapvpwrvgnd_1
XFILLER_22_171 VGND VGND VPWR VPWR sky130_fd_sc_hd__decap_3
Xwire725 wire725/A VGND VGND VPWR VPWR _3019_/A sky130_fd_sc_hd__clkbuf_4
XFILLER_6_359 VGND VGND VPWR VPWR sky130_fd_sc_hd__decap_3
XFILLER_108_265 VGND VGND VPWR VPWR sky130_fd_sc_hd__decap_3
XTAP_TAPCELL_ROW_79_1193 VGND VPWR sky130_fd_sc_hd__tapvpwrvgnd_1
XFILLER_2_521 VGND VGND VPWR VPWR sky130_fd_sc_hd__decap_3
XFILLER_2_587 VGND VGND VPWR VPWR sky130_fd_sc_hd__fill_1
XFILLER_2_598 VGND VGND VPWR VPWR sky130_fd_sc_hd__decap_3
XFILLER_77_53 VGND VGND VPWR VPWR sky130_fd_sc_hd__decap_3
XFILLER_96_119 VGND VGND VPWR VPWR sky130_fd_sc_hd__decap_3
XFILLER_77_399 VGND VGND VPWR VPWR sky130_fd_sc_hd__decap_3
Xfanout891 input42/X VGND VGND VPWR VPWR _4749_/A1 sky130_fd_sc_hd__clkdlybuf4s25_1
Xfanout880 input45/X VGND VGND VPWR VPWR _4988_/A1 sky130_fd_sc_hd__clkdlybuf4s25_1
XFILLER_73_572 VGND VGND VPWR VPWR sky130_fd_sc_hd__fill_2
XFILLER_18_488 VGND VGND VPWR VPWR sky130_fd_sc_hd__fill_1
XFILLER_21_609 VGND VGND VPWR VPWR sky130_fd_sc_hd__fill_1
XFILLER_14_672 VGND VGND VPWR VPWR sky130_fd_sc_hd__decap_3
XTAP_TAPCELL_ROW_31_626 VGND VPWR sky130_fd_sc_hd__tapvpwrvgnd_1
X_3650_ _5578_/Q _5546_/Q _5514_/Q _5482_/Q _3585_/S _3686_/S1 VGND VGND VPWR VPWR
+ _3650_/X sky130_fd_sc_hd__mux4_2
XTAP_TAPCELL_ROW_11_383 VGND VPWR sky130_fd_sc_hd__tapvpwrvgnd_1
X_3581_ _3695_/A1 _3579_/X _3580_/X _3694_/A VGND VGND VPWR VPWR _3581_/X sky130_fd_sc_hd__o22a_2
X_2601_ _3131_/A _2598_/X _2600_/X _3134_/A1 VGND VGND VPWR VPWR _2601_/X sky130_fd_sc_hd__o22a_2
X_5320_ _6056_/CLK _5320_/D VGND VGND VPWR VPWR _5320_/Q sky130_fd_sc_hd__dfxtp_2
X_2532_ _5113_/Q _5081_/Q _6009_/Q _5977_/Q _2534_/S _2610_/S1 VGND VGND VPWR VPWR
+ _2532_/X sky130_fd_sc_hd__mux4_2
X_5251_ _5500_/CLK _5251_/D VGND VGND VPWR VPWR _5251_/Q sky130_fd_sc_hd__dfxtp_2
XFILLER_87_108 VGND VGND VPWR VPWR sky130_fd_sc_hd__decap_3
X_4202_ _4750_/A1 wire489/X wire269/X _4202_/B2 VGND VGND VPWR VPWR _5276_/D sky130_fd_sc_hd__a22o_2
XFILLER_87_119 VGND VGND VPWR VPWR sky130_fd_sc_hd__decap_3
XFILLER_96_631 VGND VGND VPWR VPWR sky130_fd_sc_hd__decap_3
X_5182_ _5986_/CLK _5182_/D VGND VGND VPWR VPWR _5182_/Q sky130_fd_sc_hd__dfxtp_2
X_4133_ _4986_/A1 _4158_/A2 _4146_/B1 _4133_/B2 VGND VGND VPWR VPWR _5212_/D sky130_fd_sc_hd__a22o_2
XTAP_TAPCELL_ROW_39_715 VGND VPWR sky130_fd_sc_hd__tapvpwrvgnd_1
X_4064_ _5020_/A1 _4089_/A2 _4077_/B1 _4064_/B2 VGND VGND VPWR VPWR _5148_/D sky130_fd_sc_hd__a22o_2
XFILLER_83_347 VGND VGND VPWR VPWR sky130_fd_sc_hd__decap_3
X_3015_ _5422_/Q _5070_/Q _3015_/S VGND VGND VPWR VPWR _3015_/X sky130_fd_sc_hd__mux2_1
XFILLER_36_285 VGND VGND VPWR VPWR sky130_fd_sc_hd__decap_3
XFILLER_91_380 VGND VGND VPWR VPWR sky130_fd_sc_hd__decap_3
XTAP_TAPCELL_ROW_19_472 VGND VPWR sky130_fd_sc_hd__tapvpwrvgnd_1
XTAP_TAPCELL_ROW_19_483 VGND VPWR sky130_fd_sc_hd__tapvpwrvgnd_1
XFILLER_24_458 VGND VGND VPWR VPWR sky130_fd_sc_hd__fill_1
X_4966_ _5000_/A1 _4979_/A2 _4979_/B1 _4966_/B2 VGND VGND VPWR VPWR _5994_/D sky130_fd_sc_hd__a22o_2
X_4897_ _4999_/A1 _4907_/A2 wire139/X _4897_/B2 VGND VGND VPWR VPWR _5929_/D sky130_fd_sc_hd__a22o_2
X_3917_ _5942_/Q _5910_/Q _5878_/Q _5782_/Q _3915_/S _3917_/S1 VGND VGND VPWR VPWR
+ _3918_/B sky130_fd_sc_hd__mux4_2
X_3848_ _3347_/A _3846_/X _3847_/X _3632_/A VGND VGND VPWR VPWR _3848_/X sky130_fd_sc_hd__o22a_2
XFILLER_20_686 VGND VGND VPWR VPWR sky130_fd_sc_hd__fill_2
X_3779_ _5200_/Q _5168_/Q _3779_/S VGND VGND VPWR VPWR _3779_/X sky130_fd_sc_hd__mux2_1
XTAP_TAPCELL_ROW_115_1625 VGND VPWR sky130_fd_sc_hd__tapvpwrvgnd_1
XTAP_TAPCELL_ROW_115_1636 VGND VPWR sky130_fd_sc_hd__tapvpwrvgnd_1
X_5518_ _5838_/CLK _5518_/D VGND VGND VPWR VPWR _5518_/Q sky130_fd_sc_hd__dfxtp_2
XTAP_TAPCELL_ROW_115_1647 VGND VPWR sky130_fd_sc_hd__tapvpwrvgnd_1
X_5449_ _6044_/CLK _5449_/D VGND VGND VPWR VPWR _5449_/Q sky130_fd_sc_hd__dfxtp_2
XFILLER_105_279 VGND VGND VPWR VPWR sky130_fd_sc_hd__fill_1
XFILLER_99_491 VGND VGND VPWR VPWR sky130_fd_sc_hd__decap_3
Xfanout1119 _3943_/S VGND VGND VPWR VPWR _3475_/S sky130_fd_sc_hd__clkbuf_2
Xfanout1108 input11/X VGND VGND VPWR VPWR _3858_/S sky130_fd_sc_hd__clkdlybuf4s25_1
XFILLER_87_642 VGND VGND VPWR VPWR sky130_fd_sc_hd__fill_2
Xfanout165 _4711_/Y VGND VGND VPWR VPWR wire166/A sky130_fd_sc_hd__clkdlybuf4s25_1
Xfanout154 _4811_/Y VGND VGND VPWR VPWR _4841_/B1 sky130_fd_sc_hd__clkdlybuf4s25_1
Xfanout143 _4879_/Y VGND VGND VPWR VPWR wire144/A sky130_fd_sc_hd__clkdlybuf4s25_1
Xfanout132 _4913_/Y VGND VGND VPWR VPWR wire133/A sky130_fd_sc_hd__clkdlybuf4s25_1
Xfanout187 fanout190/A VGND VGND VPWR VPWR _4639_/B1 sky130_fd_sc_hd__clkdlybuf4s25_1
XFILLER_42_200 VGND VGND VPWR VPWR sky130_fd_sc_hd__fill_1
XFILLER_63_44 VGND VGND VPWR VPWR sky130_fd_sc_hd__decap_3
XFILLER_63_55 VGND VGND VPWR VPWR sky130_fd_sc_hd__fill_1
Xwire500 wire500/A VGND VGND VPWR VPWR wire500/X sky130_fd_sc_hd__clkbuf_4
XFILLER_6_101 VGND VGND VPWR VPWR sky130_fd_sc_hd__fill_2
XFILLER_7_602 VGND VGND VPWR VPWR sky130_fd_sc_hd__decap_3
Xwire533 wire533/A VGND VGND VPWR VPWR wire533/X sky130_fd_sc_hd__clkbuf_4
XFILLER_7_679 VGND VGND VPWR VPWR sky130_fd_sc_hd__decap_3
XFILLER_2_351 VGND VGND VPWR VPWR sky130_fd_sc_hd__decap_3
XFILLER_69_119 VGND VGND VPWR VPWR sky130_fd_sc_hd__decap_3
XFILLER_88_85 VGND VGND VPWR VPWR sky130_fd_sc_hd__decap_3
Xload_slew538 _4017_/A2 VGND VGND VPWR VPWR _3988_/B sky130_fd_sc_hd__buf_4
XFILLER_104_290 VGND VGND VPWR VPWR sky130_fd_sc_hd__decap_3
XFILLER_78_631 VGND VGND VPWR VPWR sky130_fd_sc_hd__decap_3
XFILLER_65_314 VGND VGND VPWR VPWR sky130_fd_sc_hd__fill_1
XFILLER_77_152 VGND VGND VPWR VPWR sky130_fd_sc_hd__decap_3
XFILLER_78_686 VGND VGND VPWR VPWR sky130_fd_sc_hd__fill_2
XFILLER_93_634 VGND VGND VPWR VPWR sky130_fd_sc_hd__decap_3
XFILLER_92_177 VGND VGND VPWR VPWR sky130_fd_sc_hd__decap_3
XFILLER_33_222 VGND VGND VPWR VPWR sky130_fd_sc_hd__fill_2
XTAP_TAPCELL_ROW_16_442 VGND VPWR sky130_fd_sc_hd__tapvpwrvgnd_1
X_4820_ _5024_/A1 wire371/A wire153/X _4820_/B2 VGND VGND VPWR VPWR _5856_/D sky130_fd_sc_hd__a22o_2
XTAP_TAPCELL_ROW_44_773 VGND VPWR sky130_fd_sc_hd__tapvpwrvgnd_1
XFILLER_21_439 VGND VGND VPWR VPWR sky130_fd_sc_hd__fill_1
X_4751_ _4751_/A1 _4772_/A2 _4772_/B1 _4751_/B2 VGND VGND VPWR VPWR _5789_/D sky130_fd_sc_hd__a22o_2
X_4682_ _4751_/A1 _4703_/A2 _4703_/B1 _4682_/B2 VGND VGND VPWR VPWR _5725_/D sky130_fd_sc_hd__a22o_2
X_3702_ _3928_/A1 _3699_/X _3701_/X VGND VGND VPWR VPWR _3702_/X sky130_fd_sc_hd__a21o_2
X_3633_ _3347_/A _3630_/X _3341_/A VGND VGND VPWR VPWR _3633_/X sky130_fd_sc_hd__o21a_2
XFILLER_108_18 VGND VGND VPWR VPWR sky130_fd_sc_hd__decap_3
XFILLER_108_29 VGND VGND VPWR VPWR sky130_fd_sc_hd__decap_3
X_3564_ _5190_/Q _5158_/Q _3568_/S VGND VGND VPWR VPWR _3564_/X sky130_fd_sc_hd__mux2_1
XFILLER_115_577 VGND VGND VPWR VPWR sky130_fd_sc_hd__fill_2
X_5303_ _5704_/CLK _5303_/D VGND VGND VPWR VPWR _5303_/Q sky130_fd_sc_hd__dfxtp_2
X_3495_ _5923_/Q _5891_/Q _5859_/Q _5763_/Q _3499_/S0 _3615_/S1 VGND VGND VPWR VPWR
+ _3496_/B sky130_fd_sc_hd__mux4_2
X_2515_ _5400_/Q _5048_/Q _3150_/S VGND VGND VPWR VPWR _2515_/X sky130_fd_sc_hd__mux2_1
X_5234_ _5805_/CLK _5234_/D VGND VGND VPWR VPWR _5234_/Q sky130_fd_sc_hd__dfxtp_2
XTAP_TAPCELL_ROW_110_1566 VGND VPWR sky130_fd_sc_hd__tapvpwrvgnd_1
X_5165_ _6029_/CLK _5165_/D VGND VGND VPWR VPWR _5165_/Q sky130_fd_sc_hd__dfxtp_2
XFILLER_84_612 VGND VGND VPWR VPWR sky130_fd_sc_hd__decap_3
Xhold1803 _5703_/Q VGND VGND VPWR VPWR _4658_/B2 sky130_fd_sc_hd__dlygate4sd3_1
Xhold1814 _5171_/Q VGND VGND VPWR VPWR _4087_/B2 sky130_fd_sc_hd__dlygate4sd3_1
Xhold1825 _5996_/Q VGND VGND VPWR VPWR _4968_/B2 sky130_fd_sc_hd__dlygate4sd3_1
Xhold1836 _5100_/Q VGND VGND VPWR VPWR _4009_/B2 sky130_fd_sc_hd__dlygate4sd3_1
X_4116_ _5003_/A1 wire518/X _4121_/B1 _4116_/B2 VGND VGND VPWR VPWR _5197_/D sky130_fd_sc_hd__a22o_2
XFILLER_29_539 VGND VGND VPWR VPWR sky130_fd_sc_hd__decap_3
XFILLER_84_645 VGND VGND VPWR VPWR sky130_fd_sc_hd__fill_2
XFILLER_96_494 VGND VGND VPWR VPWR sky130_fd_sc_hd__fill_1
Xhold1847 _5556_/Q VGND VGND VPWR VPWR _4500_/B2 sky130_fd_sc_hd__dlygate4sd3_1
Xhold1858 _5346_/Q VGND VGND VPWR VPWR _4276_/B2 sky130_fd_sc_hd__dlygate4sd3_1
Xhold1869 _5361_/Q VGND VGND VPWR VPWR _4291_/B2 sky130_fd_sc_hd__dlygate4sd3_1
X_5096_ _5525_/CLK _5096_/D VGND VGND VPWR VPWR _5096_/Q sky130_fd_sc_hd__dfxtp_2
XFILLER_17_15 VGND VGND VPWR VPWR sky130_fd_sc_hd__decap_3
XFILLER_37_561 VGND VGND VPWR VPWR sky130_fd_sc_hd__fill_2
X_4047_ _5005_/A1 _4052_/A2 _4054_/B1 _4047_/B2 VGND VGND VPWR VPWR _5135_/D sky130_fd_sc_hd__a22o_2
XFILLER_52_542 VGND VGND VPWR VPWR sky130_fd_sc_hd__fill_1
XTAP_TAPCELL_ROW_65_1034 VGND VPWR sky130_fd_sc_hd__tapvpwrvgnd_1
X_5998_ _6030_/CLK _5998_/D VGND VGND VPWR VPWR _5998_/Q sky130_fd_sc_hd__dfxtp_2
XFILLER_52_597 VGND VGND VPWR VPWR sky130_fd_sc_hd__decap_3
X_4949_ _4983_/A1 _4977_/A2 _4977_/B1 _4949_/B2 VGND VGND VPWR VPWR _5977_/D sky130_fd_sc_hd__a22o_2
XFILLER_4_605 VGND VGND VPWR VPWR sky130_fd_sc_hd__decap_3
XFILLER_106_533 VGND VGND VPWR VPWR sky130_fd_sc_hd__decap_3
XFILLER_4_638 VGND VGND VPWR VPWR sky130_fd_sc_hd__decap_3
XPHY_EDGE_ROW_18_Left_134 VGND VGND VPWR VPWR sky130_fd_sc_hd__decap_3
XTAP_TAPCELL_ROW_76_1163 VGND VPWR sky130_fd_sc_hd__tapvpwrvgnd_1
XFILLER_58_11 VGND VGND VPWR VPWR sky130_fd_sc_hd__fill_1
XFILLER_114_50 VGND VGND VPWR VPWR sky130_fd_sc_hd__decap_3
XFILLER_114_83 VGND VGND VPWR VPWR sky130_fd_sc_hd__fill_1
XFILLER_114_94 VGND VGND VPWR VPWR sky130_fd_sc_hd__decap_3
XFILLER_74_155 VGND VGND VPWR VPWR sky130_fd_sc_hd__fill_1
XFILLER_74_32 VGND VGND VPWR VPWR sky130_fd_sc_hd__fill_2
XFILLER_75_667 VGND VGND VPWR VPWR sky130_fd_sc_hd__decap_3
XFILLER_90_648 VGND VGND VPWR VPWR sky130_fd_sc_hd__fill_2
XPHY_EDGE_ROW_27_Left_143 VGND VGND VPWR VPWR sky130_fd_sc_hd__decap_3
XFILLER_15_222 VGND VGND VPWR VPWR sky130_fd_sc_hd__fill_2
XFILLER_74_98 VGND VGND VPWR VPWR sky130_fd_sc_hd__decap_3
XTAP_TAPCELL_ROW_87_1292 VGND VPWR sky130_fd_sc_hd__tapvpwrvgnd_1
XFILLER_43_564 VGND VGND VPWR VPWR sky130_fd_sc_hd__decap_3
XFILLER_30_214 VGND VGND VPWR VPWR sky130_fd_sc_hd__fill_2
XFILLER_43_597 VGND VGND VPWR VPWR sky130_fd_sc_hd__fill_2
XTAP_TAPCELL_ROW_13_401 VGND VPWR sky130_fd_sc_hd__tapvpwrvgnd_1
XTAP_TAPCELL_ROW_41_743 VGND VPWR sky130_fd_sc_hd__tapvpwrvgnd_1
XFILLER_11_494 VGND VGND VPWR VPWR sky130_fd_sc_hd__decap_3
XFILLER_99_40 VGND VGND VPWR VPWR sky130_fd_sc_hd__fill_2
XPHY_EDGE_ROW_36_Left_152 VGND VGND VPWR VPWR sky130_fd_sc_hd__decap_3
Xwire374 _4811_/B VGND VGND VPWR VPWR wire374/X sky130_fd_sc_hd__clkbuf_4
XFILLER_109_393 VGND VGND VPWR VPWR sky130_fd_sc_hd__fill_1
XFILLER_3_671 VGND VGND VPWR VPWR sky130_fd_sc_hd__fill_1
XFILLER_3_682 VGND VGND VPWR VPWR sky130_fd_sc_hd__fill_2
XFILLER_97_214 VGND VGND VPWR VPWR sky130_fd_sc_hd__decap_3
XFILLER_97_225 VGND VGND VPWR VPWR sky130_fd_sc_hd__decap_3
Xload_slew313 _4054_/B1 VGND VGND VPWR VPWR _4052_/B1 sky130_fd_sc_hd__buf_4
Xload_slew302 _4077_/B1 VGND VGND VPWR VPWR _4089_/B1 sky130_fd_sc_hd__buf_6
X_3280_ _3341_/A _3271_/X _3274_/X _3279_/X VGND VGND VPWR VPWR _3280_/X sky130_fd_sc_hd__a31o_2
Xload_slew346 _4976_/A2 VGND VGND VPWR VPWR _4947_/B sky130_fd_sc_hd__buf_4
XFILLER_66_601 VGND VGND VPWR VPWR sky130_fd_sc_hd__decap_3
Xload_slew379 _4745_/B VGND VGND VPWR VPWR _4775_/A2 sky130_fd_sc_hd__clkbuf_4
Xload_slew357 _4902_/A2 VGND VGND VPWR VPWR _4907_/A2 sky130_fd_sc_hd__clkbuf_4
XFILLER_38_336 VGND VGND VPWR VPWR sky130_fd_sc_hd__fill_2
XFILLER_65_111 VGND VGND VPWR VPWR sky130_fd_sc_hd__fill_1
XFILLER_78_494 VGND VGND VPWR VPWR sky130_fd_sc_hd__decap_3
XTAP_TAPCELL_ROW_49_832 VGND VPWR sky130_fd_sc_hd__tapvpwrvgnd_1
XTAP_TAPCELL_ROW_49_843 VGND VPWR sky130_fd_sc_hd__tapvpwrvgnd_1
XFILLER_66_678 VGND VGND VPWR VPWR sky130_fd_sc_hd__decap_3
XFILLER_81_615 VGND VGND VPWR VPWR sky130_fd_sc_hd__fill_1
XPHY_EDGE_ROW_45_Left_161 VGND VGND VPWR VPWR sky130_fd_sc_hd__decap_3
XFILLER_19_572 VGND VGND VPWR VPWR sky130_fd_sc_hd__decap_3
XFILLER_80_103 VGND VGND VPWR VPWR sky130_fd_sc_hd__decap_3
X_5921_ _5932_/CLK _5921_/D VGND VGND VPWR VPWR _5921_/Q sky130_fd_sc_hd__dfxtp_2
XFILLER_34_531 VGND VGND VPWR VPWR sky130_fd_sc_hd__fill_1
X_5852_ _6044_/CLK _5852_/D VGND VGND VPWR VPWR _5852_/Q sky130_fd_sc_hd__dfxtp_2
XFILLER_21_225 VGND VGND VPWR VPWR sky130_fd_sc_hd__decap_3
X_5783_ _5943_/CLK _5783_/D VGND VGND VPWR VPWR _5783_/Q sky130_fd_sc_hd__dfxtp_2
X_4803_ wire1003/X _4803_/B VGND VGND VPWR VPWR _5841_/D sky130_fd_sc_hd__and2b_2
XFILLER_9_60 VGND VGND VPWR VPWR sky130_fd_sc_hd__fill_1
X_4734_ _5038_/A1 wire386/A wire166/X _4734_/B2 VGND VGND VPWR VPWR _5774_/D sky130_fd_sc_hd__a22o_2
X_2995_ _2649_/A _2991_/X _2994_/X wire559/X VGND VGND VPWR VPWR _2995_/X sky130_fd_sc_hd__o211a_2
XPHY_EDGE_ROW_54_Left_170 VGND VGND VPWR VPWR sky130_fd_sc_hd__decap_3
X_4665_ _5038_/A1 wire400/X wire179/X _4665_/B2 VGND VGND VPWR VPWR _5710_/D sky130_fd_sc_hd__a22o_2
X_4596_ _4767_/A1 _4606_/A2 _4606_/B1 _4596_/B2 VGND VGND VPWR VPWR _5645_/D sky130_fd_sc_hd__a22o_2
X_3616_ _5577_/Q _5545_/Q _3616_/S VGND VGND VPWR VPWR _3616_/X sky130_fd_sc_hd__mux2_1
XFILLER_1_608 VGND VGND VPWR VPWR sky130_fd_sc_hd__decap_3
X_3547_ wire591/A _3545_/X _3546_/X _3547_/B2 VGND VGND VPWR VPWR _3547_/X sky130_fd_sc_hd__o22a_2
XFILLER_103_525 VGND VGND VPWR VPWR sky130_fd_sc_hd__decap_3
XFILLER_115_363 VGND VGND VPWR VPWR sky130_fd_sc_hd__fill_1
X_3478_ _5378_/Q _5346_/Q _5314_/Q _5282_/Q _3926_/S _3239_/B VGND VGND VPWR VPWR
+ _3478_/X sky130_fd_sc_hd__mux4_2
XFILLER_103_569 VGND VGND VPWR VPWR sky130_fd_sc_hd__fill_2
Xhold1600 _5761_/Q VGND VGND VPWR VPWR _4721_/B2 sky130_fd_sc_hd__dlygate4sd3_1
X_5217_ _6026_/CLK _5217_/D VGND VGND VPWR VPWR _5217_/Q sky130_fd_sc_hd__dfxtp_2
XFILLER_29_325 VGND VGND VPWR VPWR sky130_fd_sc_hd__fill_1
XFILLER_56_100 VGND VGND VPWR VPWR sky130_fd_sc_hd__fill_2
XFILLER_57_623 VGND VGND VPWR VPWR sky130_fd_sc_hd__decap_3
Xhold1611 _6069_/Q VGND VGND VPWR VPWR _5045_/B2 sky130_fd_sc_hd__dlygate4sd3_1
Xhold1622 _5722_/Q VGND VGND VPWR VPWR _4679_/B2 sky130_fd_sc_hd__dlygate4sd3_1
Xhold1633 _5170_/Q VGND VGND VPWR VPWR _4086_/B2 sky130_fd_sc_hd__dlygate4sd3_1
Xhold1644 _5684_/Q VGND VGND VPWR VPWR _4637_/B2 sky130_fd_sc_hd__dlygate4sd3_1
Xload_slew1107 _3857_/S VGND VGND VPWR VPWR _3863_/S sky130_fd_sc_hd__clkbuf_4
X_5148_ _6067_/CLK _5148_/D VGND VGND VPWR VPWR _5148_/Q sky130_fd_sc_hd__dfxtp_2
XFILLER_72_604 VGND VGND VPWR VPWR sky130_fd_sc_hd__decap_3
Xhold1655 _5955_/Q VGND VGND VPWR VPWR _4925_/B2 sky130_fd_sc_hd__dlygate4sd3_1
Xhold1666 _5375_/Q VGND VGND VPWR VPWR _4307_/B2 sky130_fd_sc_hd__dlygate4sd3_1
Xhold1677 _5213_/Q VGND VGND VPWR VPWR _4134_/B2 sky130_fd_sc_hd__dlygate4sd3_1
Xload_slew1118 _3929_/S0 VGND VGND VPWR VPWR _3926_/S sky130_fd_sc_hd__buf_4
X_5079_ _5799_/CLK _5079_/D VGND VGND VPWR VPWR _5079_/Q sky130_fd_sc_hd__dfxtp_2
XFILLER_72_648 VGND VGND VPWR VPWR sky130_fd_sc_hd__decap_3
XFILLER_84_486 VGND VGND VPWR VPWR sky130_fd_sc_hd__decap_3
Xhold1688 _5902_/Q VGND VGND VPWR VPWR _4868_/B2 sky130_fd_sc_hd__dlygate4sd3_1
Xhold1699 _5054_/Q VGND VGND VPWR VPWR _3958_/B2 sky130_fd_sc_hd__dlygate4sd3_1
XFILLER_25_520 VGND VGND VPWR VPWR sky130_fd_sc_hd__decap_3
XFILLER_44_13 VGND VGND VPWR VPWR sky130_fd_sc_hd__fill_2
XFILLER_71_125 VGND VGND VPWR VPWR sky130_fd_sc_hd__decap_3
XFILLER_71_158 VGND VGND VPWR VPWR sky130_fd_sc_hd__decap_3
XFILLER_44_57 VGND VGND VPWR VPWR sky130_fd_sc_hd__decap_3
XFILLER_71_169 VGND VGND VPWR VPWR sky130_fd_sc_hd__fill_2
XFILLER_100_96 VGND VGND VPWR VPWR sky130_fd_sc_hd__fill_1
XFILLER_60_56 VGND VGND VPWR VPWR sky130_fd_sc_hd__decap_3
XFILLER_5_18 VGND VGND VPWR VPWR sky130_fd_sc_hd__decap_3
XFILLER_109_72 VGND VGND VPWR VPWR sky130_fd_sc_hd__decap_3
XFILLER_79_247 VGND VGND VPWR VPWR sky130_fd_sc_hd__fill_1
XFILLER_0_663 VGND VGND VPWR VPWR sky130_fd_sc_hd__decap_3
XFILLER_94_206 VGND VGND VPWR VPWR sky130_fd_sc_hd__decap_3
XFILLER_0_685 VGND VGND VPWR VPWR sky130_fd_sc_hd__decap_3
XFILLER_48_645 VGND VGND VPWR VPWR sky130_fd_sc_hd__decap_3
XFILLER_75_431 VGND VGND VPWR VPWR sky130_fd_sc_hd__fill_1
XFILLER_85_53 VGND VGND VPWR VPWR sky130_fd_sc_hd__decap_3
XTAP_TAPCELL_ROW_89_1321 VGND VPWR sky130_fd_sc_hd__tapvpwrvgnd_1
XFILLER_47_155 VGND VGND VPWR VPWR sky130_fd_sc_hd__decap_3
XFILLER_87_291 VGND VGND VPWR VPWR sky130_fd_sc_hd__decap_3
XFILLER_47_166 VGND VGND VPWR VPWR sky130_fd_sc_hd__fill_2
XTAP_TAPCELL_ROW_46_802 VGND VPWR sky130_fd_sc_hd__tapvpwrvgnd_1
XFILLER_16_531 VGND VGND VPWR VPWR sky130_fd_sc_hd__fill_1
XFILLER_63_648 VGND VGND VPWR VPWR sky130_fd_sc_hd__decap_3
XFILLER_16_553 VGND VGND VPWR VPWR sky130_fd_sc_hd__fill_2
XFILLER_16_586 VGND VGND VPWR VPWR sky130_fd_sc_hd__fill_2
XFILLER_31_523 VGND VGND VPWR VPWR sky130_fd_sc_hd__decap_3
XFILLER_43_372 VGND VGND VPWR VPWR sky130_fd_sc_hd__fill_1
X_2780_ _3017_/C1 _2763_/X _2779_/X _2700_/A VGND VGND VPWR VPWR _2780_/X sky130_fd_sc_hd__a22o_2
Xwire171 wire171/A VGND VGND VPWR VPWR wire171/X sky130_fd_sc_hd__clkbuf_4
Xwire193 wire193/A VGND VGND VPWR VPWR wire193/X sky130_fd_sc_hd__clkbuf_4
X_4450_ _4994_/A1 _4468_/A2 _4468_/B1 _4450_/B2 VGND VGND VPWR VPWR _5508_/D sky130_fd_sc_hd__a22o_2
X_4381_ _4926_/A1 _4399_/A2 wire238/X _4381_/B2 VGND VGND VPWR VPWR _5444_/D sky130_fd_sc_hd__a22o_2
X_3401_ _5119_/Q _5087_/Q _6015_/Q _5983_/Q _3402_/S _3698_/S1 VGND VGND VPWR VPWR
+ _3401_/X sky130_fd_sc_hd__mux4_2
X_3332_ _5564_/Q _5532_/Q _3847_/S VGND VGND VPWR VPWR _3332_/X sky130_fd_sc_hd__mux2_1
Xload_slew121 _4998_/B1 VGND VGND VPWR VPWR _5011_/B1 sky130_fd_sc_hd__buf_4
Xfanout709 _2494_/Y VGND VGND VPWR VPWR _3597_/S sky130_fd_sc_hd__dlymetal6s2s_1
XFILLER_100_517 VGND VGND VPWR VPWR sky130_fd_sc_hd__fill_2
XFILLER_98_589 VGND VGND VPWR VPWR sky130_fd_sc_hd__decap_3
X_6051_ _6051_/CLK _6051_/D VGND VGND VPWR VPWR _6051_/Q sky130_fd_sc_hd__dfxtp_2
X_3263_ _3258_/X _3909_/B1 _3262_/X _3242_/X wire630/X VGND VGND VPWR VPWR _3263_/X
+ sky130_fd_sc_hd__a32o_2
XFILLER_100_539 VGND VGND VPWR VPWR sky130_fd_sc_hd__decap_3
Xload_slew176 _4693_/B1 VGND VGND VPWR VPWR _4703_/B1 sky130_fd_sc_hd__clkbuf_4
X_5002_ _5002_/A1 _5013_/A2 _5013_/B1 _5002_/B2 VGND VGND VPWR VPWR _6028_/D sky130_fd_sc_hd__a22o_2
X_3194_ _5270_/Q _5238_/Q _3194_/S VGND VGND VPWR VPWR _3194_/X sky130_fd_sc_hd__mux2_1
XFILLER_26_306 VGND VGND VPWR VPWR sky130_fd_sc_hd__fill_2
XFILLER_54_637 VGND VGND VPWR VPWR sky130_fd_sc_hd__decap_3
XFILLER_66_475 VGND VGND VPWR VPWR sky130_fd_sc_hd__fill_1
XFILLER_66_486 VGND VGND VPWR VPWR sky130_fd_sc_hd__fill_1
XFILLER_81_401 VGND VGND VPWR VPWR sky130_fd_sc_hd__fill_2
XFILLER_54_648 VGND VGND VPWR VPWR sky130_fd_sc_hd__fill_2
XFILLER_34_361 VGND VGND VPWR VPWR sky130_fd_sc_hd__decap_3
XFILLER_53_169 VGND VGND VPWR VPWR sky130_fd_sc_hd__decap_3
X_5904_ _6064_/CLK _5904_/D VGND VGND VPWR VPWR _5904_/Q sky130_fd_sc_hd__dfxtp_2
X_5835_ _6059_/CLK _5835_/D VGND VGND VPWR VPWR _5835_/Q sky130_fd_sc_hd__dfxtp_2
XFILLER_22_567 VGND VGND VPWR VPWR sky130_fd_sc_hd__decap_3
X_5766_ _6043_/CLK _5766_/D VGND VGND VPWR VPWR _5766_/Q sky130_fd_sc_hd__dfxtp_2
X_2978_ _3230_/A1 _2969_/X _2972_/X _2977_/X VGND VGND VPWR VPWR _2978_/X sky130_fd_sc_hd__a31o_2
XFILLER_108_606 VGND VGND VPWR VPWR sky130_fd_sc_hd__fill_2
X_5697_ _5825_/CLK _5697_/D VGND VGND VPWR VPWR _5697_/Q sky130_fd_sc_hd__dfxtp_2
X_4717_ _4885_/A1 wire386/X wire166/A _4717_/B2 VGND VGND VPWR VPWR _5757_/D sky130_fd_sc_hd__a22o_2
X_4648_ _4987_/A1 _4674_/A2 _4674_/B1 _4648_/B2 VGND VGND VPWR VPWR _5693_/D sky130_fd_sc_hd__a22o_2
XFILLER_107_138 VGND VGND VPWR VPWR sky130_fd_sc_hd__decap_3
XTAP_TAPCELL_ROW_73_1122 VGND VPWR sky130_fd_sc_hd__tapvpwrvgnd_1
Xmax_cap460 _4367_/Y VGND VGND VPWR VPWR fanout458/A sky130_fd_sc_hd__buf_2
X_4579_ _4750_/A1 wire414/X wire193/A _4579_/B2 VGND VGND VPWR VPWR _5628_/D sky130_fd_sc_hd__a22o_2
XFILLER_115_182 VGND VGND VPWR VPWR sky130_fd_sc_hd__fill_2
XFILLER_1_449 VGND VGND VPWR VPWR sky130_fd_sc_hd__decap_3
XFILLER_39_24 VGND VGND VPWR VPWR sky130_fd_sc_hd__decap_3
XFILLER_103_355 VGND VGND VPWR VPWR sky130_fd_sc_hd__decap_3
XFILLER_39_46 VGND VGND VPWR VPWR sky130_fd_sc_hd__decap_3
XFILLER_39_57 VGND VGND VPWR VPWR sky130_fd_sc_hd__decap_3
Xhold2120 _5838_/Q VGND VGND VPWR VPWR _4800_/B sky130_fd_sc_hd__dlygate4sd3_1
Xhold2131 _5461_/Q VGND VGND VPWR VPWR _4398_/B2 sky130_fd_sc_hd__dlygate4sd3_1
Xhold2142 _5833_/Q VGND VGND VPWR VPWR _4795_/B sky130_fd_sc_hd__dlygate4sd3_1
Xhold2153 _5841_/Q VGND VGND VPWR VPWR _4803_/B sky130_fd_sc_hd__dlygate4sd3_1
Xhold1430 _5635_/Q VGND VGND VPWR VPWR _4586_/B2 sky130_fd_sc_hd__dlygate4sd3_1
Xhold1441 _6031_/Q VGND VGND VPWR VPWR _5005_/B2 sky130_fd_sc_hd__dlygate4sd3_1
Xhold1452 _5314_/Q VGND VGND VPWR VPWR _4242_/B2 sky130_fd_sc_hd__dlygate4sd3_1
XFILLER_29_177 VGND VGND VPWR VPWR sky130_fd_sc_hd__decap_3
XFILLER_44_103 VGND VGND VPWR VPWR sky130_fd_sc_hd__fill_2
XFILLER_84_272 VGND VGND VPWR VPWR sky130_fd_sc_hd__fill_2
XTAP_TAPCELL_ROW_4_298 VGND VPWR sky130_fd_sc_hd__tapvpwrvgnd_1
Xhold1463 _5765_/Q VGND VGND VPWR VPWR _4725_/B2 sky130_fd_sc_hd__dlygate4sd3_1
Xhold1474 _5345_/Q VGND VGND VPWR VPWR _4275_/B2 sky130_fd_sc_hd__dlygate4sd3_1
Xhold1485 _5167_/Q VGND VGND VPWR VPWR _4083_/B2 sky130_fd_sc_hd__dlygate4sd3_1
XFILLER_45_648 VGND VGND VPWR VPWR sky130_fd_sc_hd__fill_1
XFILLER_72_445 VGND VGND VPWR VPWR sky130_fd_sc_hd__decap_3
Xhold1496 _5419_/Q VGND VGND VPWR VPWR _4353_/B2 sky130_fd_sc_hd__dlygate4sd3_1
XFILLER_25_361 VGND VGND VPWR VPWR sky130_fd_sc_hd__decap_3
XFILLER_60_607 VGND VGND VPWR VPWR sky130_fd_sc_hd__fill_2
XFILLER_111_51 VGND VGND VPWR VPWR sky130_fd_sc_hd__decap_3
XFILLER_53_681 VGND VGND VPWR VPWR sky130_fd_sc_hd__decap_3
XTAP_TAPCELL_ROW_84_1262 VGND VPWR sky130_fd_sc_hd__tapvpwrvgnd_1
XFILLER_111_84 VGND VGND VPWR VPWR sky130_fd_sc_hd__decap_3
XFILLER_40_353 VGND VGND VPWR VPWR sky130_fd_sc_hd__decap_3
XFILLER_9_505 VGND VGND VPWR VPWR sky130_fd_sc_hd__decap_3
XFILLER_13_589 VGND VGND VPWR VPWR sky130_fd_sc_hd__decap_3
XTAP_TAPCELL_ROW_51_860 VGND VPWR sky130_fd_sc_hd__tapvpwrvgnd_1
XTAP_TAPCELL_ROW_95_1391 VGND VPWR sky130_fd_sc_hd__tapvpwrvgnd_1
XFILLER_106_171 VGND VGND VPWR VPWR sky130_fd_sc_hd__decap_3
XFILLER_67_206 VGND VGND VPWR VPWR sky130_fd_sc_hd__fill_2
XFILLER_0_471 VGND VGND VPWR VPWR sky130_fd_sc_hd__fill_1
XFILLER_36_604 VGND VGND VPWR VPWR sky130_fd_sc_hd__decap_3
XFILLER_36_626 VGND VGND VPWR VPWR sky130_fd_sc_hd__decap_3
XTAP_TAPCELL_ROW_59_960 VGND VPWR sky130_fd_sc_hd__tapvpwrvgnd_1
XFILLER_35_147 VGND VGND VPWR VPWR sky130_fd_sc_hd__decap_3
XFILLER_90_242 VGND VGND VPWR VPWR sky130_fd_sc_hd__fill_2
XFILLER_90_253 VGND VGND VPWR VPWR sky130_fd_sc_hd__decap_3
X_3950_ _4844_/A _4744_/A VGND VGND VPWR VPWR _3950_/Y sky130_fd_sc_hd__nor2_2
X_2901_ _5577_/Q _5545_/Q _2913_/S VGND VGND VPWR VPWR _2901_/X sky130_fd_sc_hd__mux2_1
XFILLER_31_353 VGND VGND VPWR VPWR sky130_fd_sc_hd__fill_1
X_3881_ _3718_/A _3878_/X _3880_/X _3881_/B2 VGND VGND VPWR VPWR _3881_/X sky130_fd_sc_hd__a22o_2
X_5620_ _6068_/CLK _5620_/D VGND VGND VPWR VPWR _5620_/Q sky130_fd_sc_hd__dfxtp_2
X_2832_ _2830_/X _2831_/X wire559/A VGND VGND VPWR VPWR _2832_/X sky130_fd_sc_hd__o21a_2
X_5551_ _5999_/CLK _5551_/D VGND VGND VPWR VPWR _5551_/Q sky130_fd_sc_hd__dfxtp_2
X_2763_ wire693/X _2760_/X _2762_/X VGND VGND VPWR VPWR _2763_/X sky130_fd_sc_hd__a21o_2
X_4502_ _4776_/A1 wire437/X _4502_/B1 _4502_/B2 VGND VGND VPWR VPWR _5558_/D sky130_fd_sc_hd__a22o_2
XFILLER_6_50 VGND VGND VPWR VPWR sky130_fd_sc_hd__decap_3
X_5482_ _5514_/CLK _5482_/D VGND VGND VPWR VPWR _5482_/Q sky130_fd_sc_hd__dfxtp_2
X_2694_ _2694_/A _2694_/B _3179_/A1 VGND VGND VPWR VPWR _2712_/C sky130_fd_sc_hd__or3b_2
X_4433_ _4535_/A1 _4433_/A2 _4433_/B1 _4433_/B2 VGND VGND VPWR VPWR _5493_/D sky130_fd_sc_hd__a22o_2
XFILLER_113_620 VGND VGND VPWR VPWR sky130_fd_sc_hd__decap_3
X_4364_ _4776_/A1 _4364_/A2 _4364_/B1 _4364_/B2 VGND VGND VPWR VPWR _5430_/D sky130_fd_sc_hd__a22o_2
XFILLER_112_141 VGND VGND VPWR VPWR sky130_fd_sc_hd__decap_3
XFILLER_113_653 VGND VGND VPWR VPWR sky130_fd_sc_hd__decap_3
XFILLER_58_206 VGND VGND VPWR VPWR sky130_fd_sc_hd__decap_3
Xfanout539 _3987_/Y VGND VGND VPWR VPWR wire540/A sky130_fd_sc_hd__clkdlybuf4s25_1
Xfanout517 _4093_/Y VGND VGND VPWR VPWR wire518/A sky130_fd_sc_hd__clkdlybuf4s25_1
X_4295_ _4535_/A1 _4295_/A2 _4295_/B1 _4295_/B2 VGND VGND VPWR VPWR _5365_/D sky130_fd_sc_hd__a22o_2
X_3315_ _3562_/A _3311_/X _3314_/X _3843_/C1 VGND VGND VPWR VPWR _3315_/X sky130_fd_sc_hd__o211a_2
XFILLER_86_526 VGND VGND VPWR VPWR sky130_fd_sc_hd__decap_3
X_6034_ _6034_/CLK _6034_/D VGND VGND VPWR VPWR _6034_/Q sky130_fd_sc_hd__dfxtp_2
X_3246_ _3872_/A _3246_/B VGND VGND VPWR VPWR _3246_/X sky130_fd_sc_hd__or2_2
XFILLER_100_336 VGND VGND VPWR VPWR sky130_fd_sc_hd__fill_1
XFILLER_27_615 VGND VGND VPWR VPWR sky130_fd_sc_hd__fill_1
X_3177_ _5269_/Q _5237_/Q _3182_/S VGND VGND VPWR VPWR _3177_/X sky130_fd_sc_hd__mux2_1
XFILLER_26_125 VGND VGND VPWR VPWR sky130_fd_sc_hd__decap_3
XTAP_TAPCELL_ROW_107_1538 VGND VPWR sky130_fd_sc_hd__tapvpwrvgnd_1
XTAP_TAPCELL_ROW_1_257 VGND VPWR sky130_fd_sc_hd__tapvpwrvgnd_1
XFILLER_14_309 VGND VGND VPWR VPWR sky130_fd_sc_hd__decap_3
XFILLER_42_607 VGND VGND VPWR VPWR sky130_fd_sc_hd__fill_1
XFILLER_41_106 VGND VGND VPWR VPWR sky130_fd_sc_hd__decap_3
XFILLER_81_275 VGND VGND VPWR VPWR sky130_fd_sc_hd__decap_3
XTAP_TAPCELL_ROW_37_698 VGND VPWR sky130_fd_sc_hd__tapvpwrvgnd_1
XFILLER_50_684 VGND VGND VPWR VPWR sky130_fd_sc_hd__decap_3
X_5818_ _5914_/CLK _5818_/D VGND VGND VPWR VPWR _5818_/Q sky130_fd_sc_hd__dfxtp_2
XFILLER_10_548 VGND VGND VPWR VPWR sky130_fd_sc_hd__decap_3
XFILLER_41_47 VGND VGND VPWR VPWR sky130_fd_sc_hd__fill_1
X_5749_ _5813_/CLK _5749_/D VGND VGND VPWR VPWR _5749_/Q sky130_fd_sc_hd__dfxtp_2
XFILLER_104_642 VGND VGND VPWR VPWR sky130_fd_sc_hd__fill_2
XTAP_TAPCELL_ROW_9_357 VGND VPWR sky130_fd_sc_hd__tapvpwrvgnd_1
XFILLER_104_675 VGND VGND VPWR VPWR sky130_fd_sc_hd__decap_3
XFILLER_106_62 VGND VGND VPWR VPWR sky130_fd_sc_hd__decap_3
XFILLER_49_228 VGND VGND VPWR VPWR sky130_fd_sc_hd__decap_3
XFILLER_66_55 VGND VGND VPWR VPWR sky130_fd_sc_hd__decap_3
Xhold1260 _5414_/Q VGND VGND VPWR VPWR _4348_/B2 sky130_fd_sc_hd__dlygate4sd3_1
XFILLER_72_231 VGND VGND VPWR VPWR sky130_fd_sc_hd__decap_3
Xhold1271 _5809_/Q VGND VGND VPWR VPWR _4771_/B2 sky130_fd_sc_hd__dlygate4sd3_1
Xhold1282 _5979_/Q VGND VGND VPWR VPWR _4951_/B2 sky130_fd_sc_hd__dlygate4sd3_1
Xhold1293 _5887_/Q VGND VGND VPWR VPWR _4853_/B2 sky130_fd_sc_hd__dlygate4sd3_1
XFILLER_17_169 VGND VGND VPWR VPWR sky130_fd_sc_hd__fill_2
XFILLER_72_253 VGND VGND VPWR VPWR sky130_fd_sc_hd__fill_2
XFILLER_26_681 VGND VGND VPWR VPWR sky130_fd_sc_hd__decap_3
XFILLER_45_489 VGND VGND VPWR VPWR sky130_fd_sc_hd__decap_3
XFILLER_60_437 VGND VGND VPWR VPWR sky130_fd_sc_hd__decap_3
XFILLER_13_320 VGND VGND VPWR VPWR sky130_fd_sc_hd__decap_3
XFILLER_32_139 VGND VGND VPWR VPWR sky130_fd_sc_hd__fill_1
XFILLER_13_353 VGND VGND VPWR VPWR sky130_fd_sc_hd__decap_3
XFILLER_13_364 VGND VGND VPWR VPWR sky130_fd_sc_hd__decap_3
XFILLER_15_70 VGND VGND VPWR VPWR sky130_fd_sc_hd__fill_1
XFILLER_15_81 VGND VGND VPWR VPWR sky130_fd_sc_hd__decap_3
XFILLER_114_417 VGND VGND VPWR VPWR sky130_fd_sc_hd__decap_3
Xoutput109 _3372_/X VGND VGND VPWR VPWR rd2[5] sky130_fd_sc_hd__clkbuf_2
XFILLER_49_6 VGND VGND VPWR VPWR sky130_fd_sc_hd__fill_2
XFILLER_110_601 VGND VGND VPWR VPWR sky130_fd_sc_hd__decap_3
Xoutput91 _3657_/X VGND VGND VPWR VPWR rd2[18] sky130_fd_sc_hd__clkbuf_4
Xoutput80 _2712_/X VGND VGND VPWR VPWR rd1[8] sky130_fd_sc_hd__dlymetal6s2s_1
X_3100_ _3183_/A1 _3097_/X _3099_/X _2558_/A VGND VGND VPWR VPWR _3100_/X sky130_fd_sc_hd__a22o_2
XFILLER_110_645 VGND VGND VPWR VPWR sky130_fd_sc_hd__decap_3
X_4080_ _5002_/A1 wire524/X wire306/X _4080_/B2 VGND VGND VPWR VPWR _5164_/D sky130_fd_sc_hd__a22o_2
XFILLER_110_678 VGND VGND VPWR VPWR sky130_fd_sc_hd__decap_3
XFILLER_95_389 VGND VGND VPWR VPWR sky130_fd_sc_hd__decap_3
X_3031_ _5935_/Q _5903_/Q _5871_/Q _5775_/Q _3038_/S _3157_/S1 VGND VGND VPWR VPWR
+ _3031_/X sky130_fd_sc_hd__mux4_2
XFILLER_63_220 VGND VGND VPWR VPWR sky130_fd_sc_hd__decap_3
XFILLER_76_592 VGND VGND VPWR VPWR sky130_fd_sc_hd__fill_2
XFILLER_17_670 VGND VGND VPWR VPWR sky130_fd_sc_hd__fill_2
XFILLER_17_681 VGND VGND VPWR VPWR sky130_fd_sc_hd__decap_3
XFILLER_23_106 VGND VGND VPWR VPWR sky130_fd_sc_hd__decap_3
X_4982_ input17/X _5010_/A2 _5010_/B1 _4982_/B2 VGND VGND VPWR VPWR _6008_/D sky130_fd_sc_hd__a22o_2
XFILLER_32_640 VGND VGND VPWR VPWR sky130_fd_sc_hd__decap_3
XTAP_TAPCELL_ROW_34_657 VGND VPWR sky130_fd_sc_hd__tapvpwrvgnd_1
X_3933_ _3694_/A _3931_/X _3932_/X _3944_/A1 VGND VGND VPWR VPWR _3933_/X sky130_fd_sc_hd__o22a_2
XFILLER_31_150 VGND VGND VPWR VPWR sky130_fd_sc_hd__fill_2
XTAP_TAPCELL_ROW_102_1468 VGND VPWR sky130_fd_sc_hd__tapvpwrvgnd_1
XTAP_TAPCELL_ROW_102_1479 VGND VPWR sky130_fd_sc_hd__tapvpwrvgnd_1
XTAP_TAPCELL_ROW_62_988 VGND VPWR sky130_fd_sc_hd__tapvpwrvgnd_1
XTAP_TAPCELL_ROW_62_999 VGND VPWR sky130_fd_sc_hd__tapvpwrvgnd_1
X_3864_ _3872_/A _3862_/X _3863_/X _3763_/A VGND VGND VPWR VPWR _3864_/X sky130_fd_sc_hd__o22a_2
X_5603_ _6048_/CLK _5603_/D VGND VGND VPWR VPWR _5603_/Q sky130_fd_sc_hd__dfxtp_2
X_2815_ _5125_/Q _5093_/Q _6021_/Q _5989_/Q _3193_/S _2979_/S1 VGND VGND VPWR VPWR
+ _2816_/B sky130_fd_sc_hd__mux4_2
X_3795_ _5393_/Q _5361_/Q _5329_/Q _5297_/Q _3810_/S _3808_/S1 VGND VGND VPWR VPWR
+ _3796_/B sky130_fd_sc_hd__mux4_2
XFILLER_11_28 VGND VGND VPWR VPWR sky130_fd_sc_hd__decap_3
X_5534_ _6046_/CLK _5534_/D VGND VGND VPWR VPWR _5534_/Q sky130_fd_sc_hd__dfxtp_2
X_2746_ _5698_/Q _5666_/Q _5634_/Q _5602_/Q _2738_/S _3107_/S1 VGND VGND VPWR VPWR
+ _2747_/B sky130_fd_sc_hd__mux4_2
X_5465_ _5513_/CLK _5465_/D VGND VGND VPWR VPWR _5465_/Q sky130_fd_sc_hd__dfxtp_2
X_2677_ _2730_/A _2677_/B VGND VGND VPWR VPWR _2677_/X sky130_fd_sc_hd__or2_2
XFILLER_105_439 VGND VGND VPWR VPWR sky130_fd_sc_hd__decap_3
X_4416_ _4994_/A1 _4434_/A2 _4434_/B1 _4416_/B2 VGND VGND VPWR VPWR _5476_/D sky130_fd_sc_hd__a22o_2
XTAP_TAPCELL_ROW_6_316 VGND VPWR sky130_fd_sc_hd__tapvpwrvgnd_1
Xfanout314 _4023_/Y VGND VGND VPWR VPWR _4055_/B1 sky130_fd_sc_hd__clkdlybuf4s25_1
Xfanout303 wire306/A VGND VGND VPWR VPWR _4085_/B1 sky130_fd_sc_hd__clkdlybuf4s25_1
X_5396_ _5400_/CLK _5396_/D VGND VGND VPWR VPWR _5396_/Q sky130_fd_sc_hd__dfxtp_2
XFILLER_99_684 VGND VGND VPWR VPWR sky130_fd_sc_hd__decap_3
XTAP_TAPCELL_ROW_6_327 VGND VPWR sky130_fd_sc_hd__tapvpwrvgnd_1
Xfanout347 _4946_/Y VGND VGND VPWR VPWR _4978_/A2 sky130_fd_sc_hd__clkdlybuf4s25_1
X_4347_ _5029_/A1 _4364_/A2 _4364_/B1 _4347_/B2 VGND VGND VPWR VPWR _5413_/D sky130_fd_sc_hd__a22o_2
XFILLER_100_133 VGND VGND VPWR VPWR sky130_fd_sc_hd__decap_3
Xfanout358 _4878_/Y VGND VGND VPWR VPWR _4909_/A2 sky130_fd_sc_hd__clkdlybuf4s25_1
X_4278_ _4312_/A1 wire479/A _4294_/B1 _4278_/B2 VGND VGND VPWR VPWR _5348_/D sky130_fd_sc_hd__a22o_2
XFILLER_67_570 VGND VGND VPWR VPWR sky130_fd_sc_hd__decap_3
X_6017_ _6017_/CLK _6017_/D VGND VGND VPWR VPWR _6017_/Q sky130_fd_sc_hd__dfxtp_2
X_3229_ _3229_/A1 _3226_/X _3228_/X VGND VGND VPWR VPWR _3229_/X sky130_fd_sc_hd__a21o_2
XFILLER_54_253 VGND VGND VPWR VPWR sky130_fd_sc_hd__decap_3
XTAP_TAPCELL_ROW_68_1065 VGND VPWR sky130_fd_sc_hd__tapvpwrvgnd_1
XFILLER_14_106 VGND VGND VPWR VPWR sky130_fd_sc_hd__fill_1
XFILLER_14_139 VGND VGND VPWR VPWR sky130_fd_sc_hd__fill_1
XFILLER_42_459 VGND VGND VPWR VPWR sky130_fd_sc_hd__decap_3
XTAP_TAPCELL_ROW_81_1221 VGND VPWR sky130_fd_sc_hd__tapvpwrvgnd_1
XFILLER_22_150 VGND VGND VPWR VPWR sky130_fd_sc_hd__decap_3
XFILLER_23_673 VGND VGND VPWR VPWR sky130_fd_sc_hd__decap_3
XFILLER_10_312 VGND VGND VPWR VPWR sky130_fd_sc_hd__decap_3
XFILLER_22_183 VGND VGND VPWR VPWR sky130_fd_sc_hd__decap_3
XFILLER_22_194 VGND VGND VPWR VPWR sky130_fd_sc_hd__fill_2
XFILLER_108_211 VGND VGND VPWR VPWR sky130_fd_sc_hd__decap_3
XFILLER_108_222 VGND VGND VPWR VPWR sky130_fd_sc_hd__fill_1
XFILLER_6_338 VGND VGND VPWR VPWR sky130_fd_sc_hd__decap_3
XFILLER_108_277 VGND VGND VPWR VPWR sky130_fd_sc_hd__fill_1
XTAP_TAPCELL_ROW_79_1194 VGND VPWR sky130_fd_sc_hd__tapvpwrvgnd_1
XTAP_TAPCELL_ROW_92_1350 VGND VPWR sky130_fd_sc_hd__tapvpwrvgnd_1
XFILLER_77_345 VGND VGND VPWR VPWR sky130_fd_sc_hd__decap_3
Xfanout870 input47/X VGND VGND VPWR VPWR _4754_/A1 sky130_fd_sc_hd__clkdlybuf4s25_1
Xfanout892 input42/X VGND VGND VPWR VPWR _4509_/A1 sky130_fd_sc_hd__clkdlybuf4s25_1
Xfanout881 input44/X VGND VGND VPWR VPWR _4885_/A1 sky130_fd_sc_hd__clkdlybuf4s25_1
XFILLER_92_348 VGND VGND VPWR VPWR sky130_fd_sc_hd__decap_3
XFILLER_93_86 VGND VGND VPWR VPWR sky130_fd_sc_hd__decap_3
XFILLER_14_640 VGND VGND VPWR VPWR sky130_fd_sc_hd__decap_3
XFILLER_14_651 VGND VGND VPWR VPWR sky130_fd_sc_hd__decap_3
XFILLER_14_684 VGND VGND VPWR VPWR sky130_fd_sc_hd__decap_3
XTAP_TAPCELL_ROW_31_616 VGND VPWR sky130_fd_sc_hd__tapvpwrvgnd_1
XFILLER_9_132 VGND VGND VPWR VPWR sky130_fd_sc_hd__decap_3
XTAP_TAPCELL_ROW_31_627 VGND VPWR sky130_fd_sc_hd__tapvpwrvgnd_1
XFILLER_9_165 VGND VGND VPWR VPWR sky130_fd_sc_hd__decap_3
XFILLER_9_198 VGND VGND VPWR VPWR sky130_fd_sc_hd__decap_3
X_3580_ _5191_/Q _5159_/Q _3580_/S VGND VGND VPWR VPWR _3580_/X sky130_fd_sc_hd__mux2_1
X_2600_ _5788_/Q _5724_/Q _2913_/S VGND VGND VPWR VPWR _2600_/X sky130_fd_sc_hd__mux2_1
XTAP_TAPCELL_ROW_11_384 VGND VPWR sky130_fd_sc_hd__tapvpwrvgnd_1
X_2531_ _2904_/A1 _2528_/X _2530_/X VGND VGND VPWR VPWR _2531_/X sky130_fd_sc_hd__o21a_2
XFILLER_5_382 VGND VGND VPWR VPWR sky130_fd_sc_hd__fill_2
X_5250_ _5799_/CLK _5250_/D VGND VGND VPWR VPWR _5250_/Q sky130_fd_sc_hd__dfxtp_2
XFILLER_47_3 VGND VGND VPWR VPWR sky130_fd_sc_hd__decap_3
XFILLER_5_393 VGND VGND VPWR VPWR sky130_fd_sc_hd__fill_1
X_4201_ _4749_/A1 wire489/X wire269/A _4201_/B2 VGND VGND VPWR VPWR _5275_/D sky130_fd_sc_hd__a22o_2
X_5181_ _5810_/CLK _5181_/D VGND VGND VPWR VPWR _5181_/Q sky130_fd_sc_hd__dfxtp_2
XFILLER_3_51 VGND VGND VPWR VPWR sky130_fd_sc_hd__decap_3
XFILLER_95_131 VGND VGND VPWR VPWR sky130_fd_sc_hd__fill_1
X_4132_ _4985_/A1 _4158_/A2 _4158_/B1 _4132_/B2 VGND VGND VPWR VPWR _5211_/D sky130_fd_sc_hd__a22o_2
XFILLER_113_19 VGND VGND VPWR VPWR sky130_fd_sc_hd__decap_3
XFILLER_28_209 VGND VGND VPWR VPWR sky130_fd_sc_hd__fill_1
XFILLER_95_175 VGND VGND VPWR VPWR sky130_fd_sc_hd__decap_3
XTAP_TAPCELL_ROW_39_716 VGND VPWR sky130_fd_sc_hd__tapvpwrvgnd_1
X_4063_ _5019_/A1 _4089_/A2 _4089_/B1 _4063_/B2 VGND VGND VPWR VPWR _5147_/D sky130_fd_sc_hd__a22o_2
XFILLER_83_337 VGND VGND VPWR VPWR sky130_fd_sc_hd__fill_2
X_3014_ _5806_/Q _5742_/Q _3015_/S VGND VGND VPWR VPWR _3014_/X sky130_fd_sc_hd__mux2_1
XFILLER_36_253 VGND VGND VPWR VPWR sky130_fd_sc_hd__decap_3
XFILLER_64_595 VGND VGND VPWR VPWR sky130_fd_sc_hd__decap_3
XTAP_TAPCELL_ROW_19_473 VGND VPWR sky130_fd_sc_hd__tapvpwrvgnd_1
X_4965_ _5033_/A1 _4977_/A2 _4977_/B1 _4965_/B2 VGND VGND VPWR VPWR _5993_/D sky130_fd_sc_hd__a22o_2
X_3916_ _3916_/A1 _3915_/X _3916_/B1 VGND VGND VPWR VPWR _3916_/X sky130_fd_sc_hd__o21a_2
XFILLER_20_643 VGND VGND VPWR VPWR sky130_fd_sc_hd__fill_1
XFILLER_32_492 VGND VGND VPWR VPWR sky130_fd_sc_hd__decap_3
X_4896_ _5032_/A1 _4879_/B wire144/A _4896_/B2 VGND VGND VPWR VPWR _5928_/D sky130_fd_sc_hd__a22o_2
X_3847_ _5811_/Q _5747_/Q _3847_/S VGND VGND VPWR VPWR _3847_/X sky130_fd_sc_hd__mux2_1
X_3778_ _5264_/Q _5232_/Q _3779_/S VGND VGND VPWR VPWR _3778_/X sky130_fd_sc_hd__mux2_1
XTAP_TAPCELL_ROW_115_1626 VGND VPWR sky130_fd_sc_hd__tapvpwrvgnd_1
X_5517_ _5885_/CLK _5517_/D VGND VGND VPWR VPWR _5517_/Q sky130_fd_sc_hd__dfxtp_2
X_2729_ _5697_/Q _5665_/Q _5633_/Q _5601_/Q _2732_/S _2973_/S1 VGND VGND VPWR VPWR
+ _2730_/B sky130_fd_sc_hd__mux4_2
XTAP_TAPCELL_ROW_115_1637 VGND VPWR sky130_fd_sc_hd__tapvpwrvgnd_1
XFILLER_0_9 VGND VGND VPWR VPWR sky130_fd_sc_hd__decap_3
X_5448_ _5832_/CLK _5448_/D VGND VGND VPWR VPWR _5448_/Q sky130_fd_sc_hd__dfxtp_2
Xfanout122 _4981_/Y VGND VGND VPWR VPWR _5008_/B1 sky130_fd_sc_hd__clkdlybuf4s25_1
X_5379_ _5571_/CLK _5379_/D VGND VGND VPWR VPWR _5379_/Q sky130_fd_sc_hd__dfxtp_2
XFILLER_86_120 VGND VGND VPWR VPWR sky130_fd_sc_hd__decap_3
Xfanout155 fanout157/A VGND VGND VPWR VPWR wire156/A sky130_fd_sc_hd__clkdlybuf4s25_1
XFILLER_101_464 VGND VGND VPWR VPWR sky130_fd_sc_hd__decap_3
XFILLER_47_24 VGND VGND VPWR VPWR sky130_fd_sc_hd__fill_2
XFILLER_86_153 VGND VGND VPWR VPWR sky130_fd_sc_hd__decap_3
XFILLER_87_676 VGND VGND VPWR VPWR sky130_fd_sc_hd__decap_3
Xfanout199 _4540_/Y VGND VGND VPWR VPWR _4570_/B1 sky130_fd_sc_hd__clkdlybuf4s25_1
Xfanout188 _4608_/Y VGND VGND VPWR VPWR _4625_/B1 sky130_fd_sc_hd__clkdlybuf4s25_1
Xfanout177 _4676_/Y VGND VGND VPWR VPWR _4708_/B1 sky130_fd_sc_hd__clkdlybuf4s25_1
XPHY_EDGE_ROW_29_Right_29 VGND VGND VPWR VPWR sky130_fd_sc_hd__decap_3
XFILLER_103_52 VGND VGND VPWR VPWR sky130_fd_sc_hd__decap_3
XFILLER_15_415 VGND VGND VPWR VPWR sky130_fd_sc_hd__decap_3
XFILLER_55_573 VGND VGND VPWR VPWR sky130_fd_sc_hd__decap_3
XFILLER_70_587 VGND VGND VPWR VPWR sky130_fd_sc_hd__fill_1
XFILLER_23_481 VGND VGND VPWR VPWR sky130_fd_sc_hd__fill_2
XFILLER_70_598 VGND VGND VPWR VPWR sky130_fd_sc_hd__decap_3
XFILLER_8_18 VGND VGND VPWR VPWR sky130_fd_sc_hd__decap_3
XFILLER_8_29 VGND VGND VPWR VPWR sky130_fd_sc_hd__decap_3
XFILLER_10_131 VGND VGND VPWR VPWR sky130_fd_sc_hd__decap_3
XFILLER_11_676 VGND VGND VPWR VPWR sky130_fd_sc_hd__decap_3
XFILLER_7_614 VGND VGND VPWR VPWR sky130_fd_sc_hd__fill_2
XPHY_EDGE_ROW_38_Right_38 VGND VGND VPWR VPWR sky130_fd_sc_hd__decap_3
XFILLER_10_197 VGND VGND VPWR VPWR sky130_fd_sc_hd__decap_3
XFILLER_6_168 VGND VGND VPWR VPWR sky130_fd_sc_hd__decap_3
XFILLER_109_586 VGND VGND VPWR VPWR sky130_fd_sc_hd__decap_3
XFILLER_111_228 VGND VGND VPWR VPWR sky130_fd_sc_hd__fill_2
XFILLER_33_9 VGND VGND VPWR VPWR sky130_fd_sc_hd__fill_1
XFILLER_97_418 VGND VGND VPWR VPWR sky130_fd_sc_hd__decap_3
XFILLER_97_429 VGND VGND VPWR VPWR sky130_fd_sc_hd__decap_3
Xload_slew528 _4040_/A2 VGND VGND VPWR VPWR _4053_/A2 sky130_fd_sc_hd__buf_4
Xload_slew506 _4154_/A2 VGND VGND VPWR VPWR _4128_/B sky130_fd_sc_hd__buf_4
XFILLER_111_239 VGND VGND VPWR VPWR sky130_fd_sc_hd__decap_3
XFILLER_78_643 VGND VGND VPWR VPWR sky130_fd_sc_hd__fill_1
XFILLER_38_507 VGND VGND VPWR VPWR sky130_fd_sc_hd__decap_3
XPHY_EDGE_ROW_47_Right_47 VGND VGND VPWR VPWR sky130_fd_sc_hd__decap_3
XFILLER_65_337 VGND VGND VPWR VPWR sky130_fd_sc_hd__fill_1
XFILLER_77_186 VGND VGND VPWR VPWR sky130_fd_sc_hd__fill_2
XFILLER_46_551 VGND VGND VPWR VPWR sky130_fd_sc_hd__fill_1
XTAP_TAPCELL_ROW_16_443 VGND VPWR sky130_fd_sc_hd__tapvpwrvgnd_1
XTAP_TAPCELL_ROW_44_774 VGND VPWR sky130_fd_sc_hd__tapvpwrvgnd_1
XPHY_EDGE_ROW_56_Right_56 VGND VGND VPWR VPWR sky130_fd_sc_hd__decap_3
X_4750_ _4750_/A1 _4775_/A2 _4775_/B1 _4750_/B2 VGND VGND VPWR VPWR _5788_/D sky130_fd_sc_hd__a22o_2
X_4681_ _4750_/A1 _4706_/A2 _4706_/B1 _4681_/B2 VGND VGND VPWR VPWR _5724_/D sky130_fd_sc_hd__a22o_2
X_3701_ _3806_/A _3698_/X _3700_/X _3927_/B2 VGND VGND VPWR VPWR _3701_/X sky130_fd_sc_hd__a22o_2
X_3632_ _3632_/A _3632_/B VGND VGND VPWR VPWR _3632_/X sky130_fd_sc_hd__or2_2
X_5302_ _5797_/CLK _5302_/D VGND VGND VPWR VPWR _5302_/Q sky130_fd_sc_hd__dfxtp_2
X_3563_ _5254_/Q _5222_/Q _3568_/S VGND VGND VPWR VPWR _3563_/X sky130_fd_sc_hd__mux2_1
X_3494_ _3496_/A _3490_/X _3493_/X _3843_/C1 VGND VGND VPWR VPWR _3494_/X sky130_fd_sc_hd__o211a_2
X_2514_ _3198_/A _2514_/B VGND VGND VPWR VPWR _2514_/X sky130_fd_sc_hd__or2_2
XFILLER_102_206 VGND VGND VPWR VPWR sky130_fd_sc_hd__decap_3
XFILLER_115_589 VGND VGND VPWR VPWR sky130_fd_sc_hd__decap_3
XPHY_EDGE_ROW_65_Right_65 VGND VGND VPWR VPWR sky130_fd_sc_hd__decap_3
X_5233_ _5866_/CLK _5233_/D VGND VGND VPWR VPWR _5233_/Q sky130_fd_sc_hd__dfxtp_2
X_5164_ _6023_/CLK _5164_/D VGND VGND VPWR VPWR _5164_/Q sky130_fd_sc_hd__dfxtp_2
XFILLER_110_250 VGND VGND VPWR VPWR sky130_fd_sc_hd__fill_2
XFILLER_69_665 VGND VGND VPWR VPWR sky130_fd_sc_hd__decap_3
XFILLER_69_687 VGND VGND VPWR VPWR sky130_fd_sc_hd__fill_1
XTAP_TAPCELL_ROW_110_1567 VGND VPWR sky130_fd_sc_hd__tapvpwrvgnd_1
Xhold1804 _5292_/Q VGND VGND VPWR VPWR _4218_/B2 sky130_fd_sc_hd__dlygate4sd3_1
Xhold1815 _5282_/Q VGND VGND VPWR VPWR _4208_/B2 sky130_fd_sc_hd__dlygate4sd3_1
Xhold1826 _5259_/Q VGND VGND VPWR VPWR _4182_/B2 sky130_fd_sc_hd__dlygate4sd3_1
X_4115_ _5002_/A1 wire516/X wire298/X _4115_/B2 VGND VGND VPWR VPWR _5196_/D sky130_fd_sc_hd__a22o_2
XFILLER_68_197 VGND VGND VPWR VPWR sky130_fd_sc_hd__decap_3
Xhold1837 _5379_/Q VGND VGND VPWR VPWR _4311_/B2 sky130_fd_sc_hd__dlygate4sd3_1
Xhold1848 _5435_/Q VGND VGND VPWR VPWR _4372_/B2 sky130_fd_sc_hd__dlygate4sd3_1
Xhold1859 _5883_/Q VGND VGND VPWR VPWR _4849_/B2 sky130_fd_sc_hd__dlygate4sd3_1
X_5095_ _6023_/CLK _5095_/D VGND VGND VPWR VPWR _5095_/Q sky130_fd_sc_hd__dfxtp_2
XFILLER_17_27 VGND VGND VPWR VPWR sky130_fd_sc_hd__decap_3
XFILLER_17_38 VGND VGND VPWR VPWR sky130_fd_sc_hd__decap_3
XFILLER_84_679 VGND VGND VPWR VPWR sky130_fd_sc_hd__fill_1
X_4046_ _4528_/A1 _4023_/B _4052_/B1 _4046_/B2 VGND VGND VPWR VPWR _5134_/D sky130_fd_sc_hd__a22o_2
XFILLER_64_370 VGND VGND VPWR VPWR sky130_fd_sc_hd__fill_1
XTAP_TAPCELL_ROW_65_1024 VGND VPWR sky130_fd_sc_hd__tapvpwrvgnd_1
XTAP_TAPCELL_ROW_65_1035 VGND VPWR sky130_fd_sc_hd__tapvpwrvgnd_1
XFILLER_12_418 VGND VGND VPWR VPWR sky130_fd_sc_hd__fill_2
XPHY_EDGE_ROW_74_Right_74 VGND VGND VPWR VPWR sky130_fd_sc_hd__decap_3
X_5997_ _6029_/CLK _5997_/D VGND VGND VPWR VPWR _5997_/Q sky130_fd_sc_hd__dfxtp_2
XFILLER_24_289 VGND VGND VPWR VPWR sky130_fd_sc_hd__fill_2
XFILLER_33_48 VGND VGND VPWR VPWR sky130_fd_sc_hd__decap_3
X_4948_ input17/X _4976_/A2 _4976_/B1 _4948_/B2 VGND VGND VPWR VPWR _5976_/D sky130_fd_sc_hd__a22o_2
X_4879_ _4879_/A _4879_/B VGND VGND VPWR VPWR _4879_/Y sky130_fd_sc_hd__nor2_2
XFILLER_4_617 VGND VGND VPWR VPWR sky130_fd_sc_hd__decap_3
XFILLER_3_116 VGND VGND VPWR VPWR sky130_fd_sc_hd__fill_1
XPHY_EDGE_ROW_83_Right_83 VGND VGND VPWR VPWR sky130_fd_sc_hd__decap_3
XTAP_TAPCELL_ROW_76_1164 VGND VPWR sky130_fd_sc_hd__tapvpwrvgnd_1
XFILLER_58_45 VGND VGND VPWR VPWR sky130_fd_sc_hd__fill_1
Xwire1012 _3745_/A1 VGND VGND VPWR VPWR _3708_/A1 sky130_fd_sc_hd__buf_4
XFILLER_101_272 VGND VGND VPWR VPWR sky130_fd_sc_hd__decap_3
XFILLER_74_101 VGND VGND VPWR VPWR sky130_fd_sc_hd__decap_3
XFILLER_114_62 VGND VGND VPWR VPWR sky130_fd_sc_hd__decap_3
XFILLER_28_551 VGND VGND VPWR VPWR sky130_fd_sc_hd__fill_2
XFILLER_90_627 VGND VGND VPWR VPWR sky130_fd_sc_hd__decap_3
XFILLER_15_234 VGND VGND VPWR VPWR sky130_fd_sc_hd__decap_3
XFILLER_28_595 VGND VGND VPWR VPWR sky130_fd_sc_hd__decap_3
XPHY_EDGE_ROW_92_Right_92 VGND VGND VPWR VPWR sky130_fd_sc_hd__decap_3
XTAP_TAPCELL_ROW_87_1293 VGND VPWR sky130_fd_sc_hd__tapvpwrvgnd_1
XFILLER_43_576 VGND VGND VPWR VPWR sky130_fd_sc_hd__fill_1
XFILLER_90_32 VGND VGND VPWR VPWR sky130_fd_sc_hd__fill_1
XTAP_TAPCELL_ROW_13_402 VGND VPWR sky130_fd_sc_hd__tapvpwrvgnd_1
XTAP_TAPCELL_ROW_41_744 VGND VPWR sky130_fd_sc_hd__tapvpwrvgnd_1
XFILLER_7_411 VGND VGND VPWR VPWR sky130_fd_sc_hd__decap_3
XFILLER_7_466 VGND VGND VPWR VPWR sky130_fd_sc_hd__decap_3
Xwire353 _4913_/B VGND VGND VPWR VPWR wire353/X sky130_fd_sc_hd__clkbuf_4
XFILLER_109_383 VGND VGND VPWR VPWR sky130_fd_sc_hd__decap_3
Xwire386 wire386/A VGND VGND VPWR VPWR wire386/X sky130_fd_sc_hd__buf_4
XFILLER_99_96 VGND VGND VPWR VPWR sky130_fd_sc_hd__decap_3
XFILLER_3_650 VGND VGND VPWR VPWR sky130_fd_sc_hd__decap_3
XFILLER_31_6 VGND VGND VPWR VPWR sky130_fd_sc_hd__decap_3
Xload_slew336 _4998_/A2 VGND VGND VPWR VPWR _5011_/A2 sky130_fd_sc_hd__buf_4
Xload_slew369 _4870_/A2 VGND VGND VPWR VPWR _4876_/A2 sky130_fd_sc_hd__buf_4
XFILLER_38_326 VGND VGND VPWR VPWR sky130_fd_sc_hd__fill_2
XFILLER_78_473 VGND VGND VPWR VPWR sky130_fd_sc_hd__decap_3
XTAP_TAPCELL_ROW_49_833 VGND VPWR sky130_fd_sc_hd__tapvpwrvgnd_1
XFILLER_0_41 VGND VGND VPWR VPWR sky130_fd_sc_hd__decap_3
XFILLER_34_510 VGND VGND VPWR VPWR sky130_fd_sc_hd__decap_3
XFILLER_65_167 VGND VGND VPWR VPWR sky130_fd_sc_hd__fill_1
XFILLER_93_498 VGND VGND VPWR VPWR sky130_fd_sc_hd__decap_3
X_5920_ _6048_/CLK _5920_/D VGND VGND VPWR VPWR _5920_/Q sky130_fd_sc_hd__dfxtp_2
XFILLER_0_63 VGND VGND VPWR VPWR sky130_fd_sc_hd__decap_3
XFILLER_0_85 VGND VGND VPWR VPWR sky130_fd_sc_hd__decap_3
X_5851_ _6042_/CLK _5851_/D VGND VGND VPWR VPWR _5851_/Q sky130_fd_sc_hd__dfxtp_2
XFILLER_21_237 VGND VGND VPWR VPWR sky130_fd_sc_hd__decap_3
XFILLER_34_587 VGND VGND VPWR VPWR sky130_fd_sc_hd__fill_1
XPHY_EDGE_ROW_100_Right_100 VGND VGND VPWR VPWR sky130_fd_sc_hd__decap_3
X_5782_ _6063_/CLK _5782_/D VGND VGND VPWR VPWR _5782_/Q sky130_fd_sc_hd__dfxtp_2
X_4802_ _3948_/B _4802_/B VGND VGND VPWR VPWR _5840_/D sky130_fd_sc_hd__and2b_2
X_2994_ _3105_/A1 _2992_/X _2993_/X _3105_/B2 VGND VGND VPWR VPWR _2994_/X sky130_fd_sc_hd__o22a_2
XFILLER_21_259 VGND VGND VPWR VPWR sky130_fd_sc_hd__decap_3
X_4733_ _5037_/A1 _4741_/A2 _4741_/B1 _4733_/B2 VGND VGND VPWR VPWR _5773_/D sky130_fd_sc_hd__a22o_2
X_4664_ _4767_/A1 _4674_/A2 _4674_/B1 _4664_/B2 VGND VGND VPWR VPWR _5709_/D sky130_fd_sc_hd__a22o_2
X_4595_ _4766_/A1 _4595_/A2 _4600_/B1 _4595_/B2 VGND VGND VPWR VPWR _5644_/D sky130_fd_sc_hd__a22o_2
X_3615_ _5385_/Q _5353_/Q _5321_/Q _5289_/Q _3743_/S _3615_/S1 VGND VGND VPWR VPWR
+ _3615_/X sky130_fd_sc_hd__mux4_2
XFILLER_115_331 VGND VGND VPWR VPWR sky130_fd_sc_hd__decap_3
X_3546_ _5829_/Q _5445_/Q _3802_/S VGND VGND VPWR VPWR _3546_/X sky130_fd_sc_hd__mux2_1
XFILLER_0_119 VGND VGND VPWR VPWR sky130_fd_sc_hd__fill_1
X_5216_ _6056_/CLK _5216_/D VGND VGND VPWR VPWR _5216_/Q sky130_fd_sc_hd__dfxtp_2
X_3477_ _3235_/B _3475_/X _3476_/X _3612_/C1 VGND VGND VPWR VPWR _3483_/A sky130_fd_sc_hd__o211a_2
Xhold1601 _5903_/Q VGND VGND VPWR VPWR _4869_/B2 sky130_fd_sc_hd__dlygate4sd3_1
XFILLER_111_581 VGND VGND VPWR VPWR sky130_fd_sc_hd__decap_3
XFILLER_57_635 VGND VGND VPWR VPWR sky130_fd_sc_hd__decap_3
Xhold1612 _5433_/Q VGND VGND VPWR VPWR _4370_/B2 sky130_fd_sc_hd__dlygate4sd3_1
Xhold1623 _5088_/Q VGND VGND VPWR VPWR _3997_/B2 sky130_fd_sc_hd__dlygate4sd3_1
Xhold1634 _5252_/Q VGND VGND VPWR VPWR _4175_/B2 sky130_fd_sc_hd__dlygate4sd3_1
X_5147_ _5938_/CLK _5147_/D VGND VGND VPWR VPWR _5147_/Q sky130_fd_sc_hd__dfxtp_2
XFILLER_29_348 VGND VGND VPWR VPWR sky130_fd_sc_hd__decap_3
XFILLER_56_134 VGND VGND VPWR VPWR sky130_fd_sc_hd__decap_3
XFILLER_84_432 VGND VGND VPWR VPWR sky130_fd_sc_hd__decap_3
Xhold1645 _5542_/Q VGND VGND VPWR VPWR _4486_/B2 sky130_fd_sc_hd__dlygate4sd3_1
Xhold1656 _5860_/Q VGND VGND VPWR VPWR _4824_/B2 sky130_fd_sc_hd__dlygate4sd3_1
Xhold1667 _5476_/Q VGND VGND VPWR VPWR _4416_/B2 sky130_fd_sc_hd__dlygate4sd3_1
Xhold1678 _5781_/Q VGND VGND VPWR VPWR _4741_/B2 sky130_fd_sc_hd__dlygate4sd3_1
X_5078_ _5925_/CLK _5078_/D VGND VGND VPWR VPWR _5078_/Q sky130_fd_sc_hd__dfxtp_2
XFILLER_72_638 VGND VGND VPWR VPWR sky130_fd_sc_hd__decap_3
Xhold1689 _5128_/Q VGND VGND VPWR VPWR _4040_/B2 sky130_fd_sc_hd__dlygate4sd3_1
X_4029_ _4987_/A1 _4050_/A2 _4050_/B1 _4029_/B2 VGND VGND VPWR VPWR _5117_/D sky130_fd_sc_hd__a22o_2
XFILLER_25_543 VGND VGND VPWR VPWR sky130_fd_sc_hd__decap_3
XFILLER_71_137 VGND VGND VPWR VPWR sky130_fd_sc_hd__decap_3
XFILLER_52_362 VGND VGND VPWR VPWR sky130_fd_sc_hd__fill_2
XFILLER_25_587 VGND VGND VPWR VPWR sky130_fd_sc_hd__decap_3
XFILLER_40_513 VGND VGND VPWR VPWR sky130_fd_sc_hd__fill_1
XFILLER_44_69 VGND VGND VPWR VPWR sky130_fd_sc_hd__fill_2
XFILLER_60_68 VGND VGND VPWR VPWR sky130_fd_sc_hd__fill_1
XFILLER_114_3 VGND VGND VPWR VPWR sky130_fd_sc_hd__decap_3
XFILLER_109_51 VGND VGND VPWR VPWR sky130_fd_sc_hd__decap_3
XFILLER_109_84 VGND VGND VPWR VPWR sky130_fd_sc_hd__decap_3
XFILLER_0_620 VGND VGND VPWR VPWR sky130_fd_sc_hd__fill_1
XFILLER_0_631 VGND VGND VPWR VPWR sky130_fd_sc_hd__decap_3
XFILLER_102_570 VGND VGND VPWR VPWR sky130_fd_sc_hd__fill_1
XFILLER_102_581 VGND VGND VPWR VPWR sky130_fd_sc_hd__decap_3
XFILLER_48_635 VGND VGND VPWR VPWR sky130_fd_sc_hd__fill_2
XFILLER_85_21 VGND VGND VPWR VPWR sky130_fd_sc_hd__decap_3
XFILLER_85_32 VGND VGND VPWR VPWR sky130_fd_sc_hd__decap_3
XFILLER_87_281 VGND VGND VPWR VPWR sky130_fd_sc_hd__fill_2
XTAP_TAPCELL_ROW_89_1322 VGND VPWR sky130_fd_sc_hd__tapvpwrvgnd_1
XFILLER_47_123 VGND VGND VPWR VPWR sky130_fd_sc_hd__decap_3
XFILLER_47_134 VGND VGND VPWR VPWR sky130_fd_sc_hd__decap_3
XFILLER_48_657 VGND VGND VPWR VPWR sky130_fd_sc_hd__decap_3
XFILLER_47_178 VGND VGND VPWR VPWR sky130_fd_sc_hd__decap_3
XFILLER_85_98 VGND VGND VPWR VPWR sky130_fd_sc_hd__decap_3
XFILLER_90_402 VGND VGND VPWR VPWR sky130_fd_sc_hd__decap_3
XTAP_TAPCELL_ROW_46_803 VGND VPWR sky130_fd_sc_hd__tapvpwrvgnd_1
XFILLER_16_598 VGND VGND VPWR VPWR sky130_fd_sc_hd__decap_3
XFILLER_71_682 VGND VGND VPWR VPWR sky130_fd_sc_hd__decap_3
XTAP_TAPCELL_ROW_26_560 VGND VPWR sky130_fd_sc_hd__tapvpwrvgnd_1
XFILLER_34_91 VGND VGND VPWR VPWR sky130_fd_sc_hd__decap_3
XFILLER_11_281 VGND VGND VPWR VPWR sky130_fd_sc_hd__fill_2
XFILLER_79_6 VGND VGND VPWR VPWR sky130_fd_sc_hd__fill_1
X_4380_ _5027_/A1 _4380_/A2 _4396_/B1 _4380_/B2 VGND VGND VPWR VPWR _5443_/D sky130_fd_sc_hd__a22o_2
X_3400_ _3881_/B2 _3397_/X _3399_/X VGND VGND VPWR VPWR _3400_/X sky130_fd_sc_hd__a21o_2
X_3331_ _5372_/Q _5340_/Q _5308_/Q _5276_/Q _3487_/S _3839_/S1 VGND VGND VPWR VPWR
+ _3331_/X sky130_fd_sc_hd__mux4_2
XPHY_EDGE_ROW_0_Left_116 VGND VGND VPWR VPWR sky130_fd_sc_hd__decap_3
X_6050_ _6050_/CLK _6050_/D VGND VGND VPWR VPWR _6050_/Q sky130_fd_sc_hd__dfxtp_2
X_3262_ _3914_/A _3259_/X _3260_/X _3916_/A1 VGND VGND VPWR VPWR _3262_/X sky130_fd_sc_hd__o22a_2
X_5001_ _5001_/A1 _4981_/B _5010_/B1 _5001_/B2 VGND VGND VPWR VPWR _6027_/D sky130_fd_sc_hd__a22o_2
X_3193_ _5206_/Q _5174_/Q _3193_/S VGND VGND VPWR VPWR _3193_/X sky130_fd_sc_hd__mux2_1
XFILLER_66_432 VGND VGND VPWR VPWR sky130_fd_sc_hd__decap_3
XFILLER_81_446 VGND VGND VPWR VPWR sky130_fd_sc_hd__fill_2
XFILLER_93_284 VGND VGND VPWR VPWR sky130_fd_sc_hd__fill_1
X_5903_ _6063_/CLK _5903_/D VGND VGND VPWR VPWR _5903_/Q sky130_fd_sc_hd__dfxtp_2
X_5834_ _6058_/CLK _5834_/D VGND VGND VPWR VPWR _5834_/Q sky130_fd_sc_hd__dfxtp_2
X_5765_ _6070_/CLK _5765_/D VGND VGND VPWR VPWR _5765_/Q sky130_fd_sc_hd__dfxtp_2
X_2977_ _3081_/A _2973_/X _2976_/X _3224_/A1 VGND VGND VPWR VPWR _2977_/X sky130_fd_sc_hd__o211a_2
X_5696_ _5934_/CLK _5696_/D VGND VGND VPWR VPWR _5696_/Q sky130_fd_sc_hd__dfxtp_2
X_4716_ _5020_/A1 wire386/X wire166/X _4716_/B2 VGND VGND VPWR VPWR _5756_/D sky130_fd_sc_hd__a22o_2
XFILLER_30_27 VGND VGND VPWR VPWR sky130_fd_sc_hd__fill_1
X_4647_ _4750_/A1 wire400/X wire179/A _4647_/B2 VGND VGND VPWR VPWR _5692_/D sky130_fd_sc_hd__a22o_2
XFILLER_100_9 VGND VGND VPWR VPWR sky130_fd_sc_hd__decap_3
XTAP_TAPCELL_ROW_73_1123 VGND VPWR sky130_fd_sc_hd__tapvpwrvgnd_1
X_4578_ _4749_/A1 _4591_/A2 _4591_/B1 _4578_/B2 VGND VGND VPWR VPWR _5627_/D sky130_fd_sc_hd__a22o_2
X_3529_ _5381_/Q _5349_/Q _5317_/Q _5285_/Q _3907_/S _3905_/S1 VGND VGND VPWR VPWR
+ _3529_/X sky130_fd_sc_hd__mux4_2
XFILLER_76_207 VGND VGND VPWR VPWR sky130_fd_sc_hd__decap_3
Xhold2110 _5147_/Q VGND VGND VPWR VPWR _4063_/B2 sky130_fd_sc_hd__dlygate4sd3_1
Xhold2121 _5672_/Q VGND VGND VPWR VPWR _4625_/B2 sky130_fd_sc_hd__dlygate4sd3_1
Xhold2132 _5195_/Q VGND VGND VPWR VPWR _4114_/B2 sky130_fd_sc_hd__dlygate4sd3_1
Xhold2143 _5825_/Q VGND VGND VPWR VPWR _4787_/B sky130_fd_sc_hd__dlygate4sd3_1
Xhold2154 _5843_/Q VGND VGND VPWR VPWR _4805_/B sky130_fd_sc_hd__dlygate4sd3_1
XFILLER_29_145 VGND VGND VPWR VPWR sky130_fd_sc_hd__decap_3
Xhold1420 _5106_/Q VGND VGND VPWR VPWR _4015_/B2 sky130_fd_sc_hd__dlygate4sd3_1
Xhold1431 _6009_/Q VGND VGND VPWR VPWR _4983_/B2 sky130_fd_sc_hd__dlygate4sd3_1
Xhold1442 _5692_/Q VGND VGND VPWR VPWR _4647_/B2 sky130_fd_sc_hd__dlygate4sd3_1
XTAP_TAPCELL_ROW_4_299 VGND VPWR sky130_fd_sc_hd__tapvpwrvgnd_1
Xhold1453 _5918_/Q VGND VGND VPWR VPWR _4886_/B2 sky130_fd_sc_hd__dlygate4sd3_1
Xhold1464 _5129_/Q VGND VGND VPWR VPWR _4041_/B2 sky130_fd_sc_hd__dlygate4sd3_1
Xhold1475 _6047_/Q VGND VGND VPWR VPWR _5023_/B2 sky130_fd_sc_hd__dlygate4sd3_1
Xhold1486 _5764_/Q VGND VGND VPWR VPWR _4724_/B2 sky130_fd_sc_hd__dlygate4sd3_1
XFILLER_29_189 VGND VGND VPWR VPWR sky130_fd_sc_hd__decap_3
XFILLER_55_57 VGND VGND VPWR VPWR sky130_fd_sc_hd__decap_3
XFILLER_72_424 VGND VGND VPWR VPWR sky130_fd_sc_hd__decap_3
Xhold1497 _5762_/Q VGND VGND VPWR VPWR _4722_/B2 sky130_fd_sc_hd__dlygate4sd3_1
XFILLER_111_30 VGND VGND VPWR VPWR sky130_fd_sc_hd__decap_3
XTAP_TAPCELL_ROW_84_1252 VGND VPWR sky130_fd_sc_hd__tapvpwrvgnd_1
XFILLER_111_63 VGND VGND VPWR VPWR sky130_fd_sc_hd__decap_3
XTAP_TAPCELL_ROW_84_1263 VGND VPWR sky130_fd_sc_hd__tapvpwrvgnd_1
XFILLER_111_96 VGND VGND VPWR VPWR sky130_fd_sc_hd__decap_3
XTAP_TAPCELL_ROW_23_530 VGND VPWR sky130_fd_sc_hd__tapvpwrvgnd_1
XFILLER_40_365 VGND VGND VPWR VPWR sky130_fd_sc_hd__fill_1
XTAP_TAPCELL_ROW_51_861 VGND VPWR sky130_fd_sc_hd__tapvpwrvgnd_1
XFILLER_4_233 VGND VGND VPWR VPWR sky130_fd_sc_hd__decap_3
XFILLER_106_150 VGND VGND VPWR VPWR sky130_fd_sc_hd__fill_1
XFILLER_107_651 VGND VGND VPWR VPWR sky130_fd_sc_hd__decap_3
XFILLER_107_673 VGND VGND VPWR VPWR sky130_fd_sc_hd__decap_3
XPHY_EDGE_ROW_73_Left_189 VGND VGND VPWR VPWR sky130_fd_sc_hd__decap_3
XTAP_TAPCELL_ROW_95_1392 VGND VPWR sky130_fd_sc_hd__tapvpwrvgnd_1
XFILLER_95_505 VGND VGND VPWR VPWR sky130_fd_sc_hd__decap_3
XFILLER_0_461 VGND VGND VPWR VPWR sky130_fd_sc_hd__fill_2
XFILLER_95_538 VGND VGND VPWR VPWR sky130_fd_sc_hd__decap_3
XTAP_TAPCELL_ROW_59_961 VGND VPWR sky130_fd_sc_hd__tapvpwrvgnd_1
XFILLER_90_210 VGND VGND VPWR VPWR sky130_fd_sc_hd__decap_3
XPHY_EDGE_ROW_82_Left_198 VGND VGND VPWR VPWR sky130_fd_sc_hd__decap_3
X_2900_ _5385_/Q _5353_/Q _5321_/Q _5289_/Q _3026_/S _3024_/S1 VGND VGND VPWR VPWR
+ _2900_/X sky130_fd_sc_hd__mux4_2
Xclkbuf_leaf_70_clk clkload3/A VGND VGND VPWR VPWR _5794_/CLK sky130_fd_sc_hd__clkbuf_8
X_3880_ _5525_/Q _5493_/Q _3880_/S VGND VGND VPWR VPWR _3880_/X sky130_fd_sc_hd__mux2_1
X_2831_ _3183_/A1 _2827_/X _2828_/X _2558_/A VGND VGND VPWR VPWR _2831_/X sky130_fd_sc_hd__a22o_2
XFILLER_77_3 VGND VGND VPWR VPWR sky130_fd_sc_hd__fill_2
X_5550_ _5838_/CLK _5550_/D VGND VGND VPWR VPWR _5550_/Q sky130_fd_sc_hd__dfxtp_2
X_2762_ _2690_/A _2759_/X _2761_/X wire659/X VGND VGND VPWR VPWR _2762_/X sky130_fd_sc_hd__a22o_2
XFILLER_8_550 VGND VGND VPWR VPWR sky130_fd_sc_hd__decap_3
X_5481_ _5513_/CLK _5481_/D VGND VGND VPWR VPWR _5481_/Q sky130_fd_sc_hd__dfxtp_2
X_4501_ _4535_/A1 _4501_/A2 _4501_/B1 _4501_/B2 VGND VGND VPWR VPWR _5557_/D sky130_fd_sc_hd__a22o_2
X_4432_ _4534_/A1 _4434_/A2 _4434_/B1 _4432_/B2 VGND VGND VPWR VPWR _5492_/D sky130_fd_sc_hd__a22o_2
X_2693_ wire693/A _2691_/X _2692_/X wire659/A VGND VGND VPWR VPWR _2694_/B sky130_fd_sc_hd__a22o_2
XFILLER_113_632 VGND VGND VPWR VPWR sky130_fd_sc_hd__decap_3
X_4363_ _4775_/A1 wire462/X wire242/A _4363_/B2 VGND VGND VPWR VPWR _5429_/D sky130_fd_sc_hd__a22o_2
XFILLER_113_665 VGND VGND VPWR VPWR sky130_fd_sc_hd__decap_3
XFILLER_113_676 VGND VGND VPWR VPWR sky130_fd_sc_hd__decap_3
XFILLER_98_365 VGND VGND VPWR VPWR sky130_fd_sc_hd__decap_3
Xfanout529 _4022_/Y VGND VGND VPWR VPWR _4050_/A2 sky130_fd_sc_hd__clkdlybuf4s25_1
Xfanout507 fanout509/X VGND VGND VPWR VPWR wire508/A sky130_fd_sc_hd__clkdlybuf4s25_1
X_4294_ _5010_/A1 wire479/A _4294_/B1 _4294_/B2 VGND VGND VPWR VPWR _5364_/D sky130_fd_sc_hd__a22o_2
X_3314_ _3713_/B2 _3312_/X _3313_/X _3713_/A1 VGND VGND VPWR VPWR _3314_/X sky130_fd_sc_hd__o22a_2
XFILLER_100_315 VGND VGND VPWR VPWR sky130_fd_sc_hd__decap_3
XFILLER_39_410 VGND VGND VPWR VPWR sky130_fd_sc_hd__decap_3
XFILLER_98_387 VGND VGND VPWR VPWR sky130_fd_sc_hd__decap_3
X_6033_ _6033_/CLK _6033_/D VGND VGND VPWR VPWR _6033_/Q sky130_fd_sc_hd__dfxtp_2
X_3245_ _5560_/Q _5528_/Q _3774_/S VGND VGND VPWR VPWR _3246_/B sky130_fd_sc_hd__mux2_1
XFILLER_66_262 VGND VGND VPWR VPWR sky130_fd_sc_hd__decap_3
X_3176_ _5205_/Q _5173_/Q _3182_/S VGND VGND VPWR VPWR _3176_/X sky130_fd_sc_hd__mux2_1
XFILLER_26_115 VGND VGND VPWR VPWR sky130_fd_sc_hd__fill_2
XFILLER_26_137 VGND VGND VPWR VPWR sky130_fd_sc_hd__decap_3
XFILLER_94_582 VGND VGND VPWR VPWR sky130_fd_sc_hd__decap_3
XTAP_TAPCELL_ROW_107_1528 VGND VPWR sky130_fd_sc_hd__tapvpwrvgnd_1
XTAP_TAPCELL_ROW_107_1539 VGND VPWR sky130_fd_sc_hd__tapvpwrvgnd_1
XTAP_TAPCELL_ROW_1_258 VGND VPWR sky130_fd_sc_hd__tapvpwrvgnd_1
XTAP_TAPCELL_ROW_37_688 VGND VPWR sky130_fd_sc_hd__tapvpwrvgnd_1
XTAP_TAPCELL_ROW_37_699 VGND VPWR sky130_fd_sc_hd__tapvpwrvgnd_1
XFILLER_50_630 VGND VGND VPWR VPWR sky130_fd_sc_hd__decap_3
Xclkbuf_leaf_61_clk clkbuf_4_12_0_clk/X VGND VGND VPWR VPWR _5943_/CLK sky130_fd_sc_hd__clkbuf_8
XFILLER_10_505 VGND VGND VPWR VPWR sky130_fd_sc_hd__decap_3
XFILLER_10_516 VGND VGND VPWR VPWR sky130_fd_sc_hd__decap_3
XFILLER_22_365 VGND VGND VPWR VPWR sky130_fd_sc_hd__decap_3
X_5817_ clkload9/A _5817_/D VGND VGND VPWR VPWR _5817_/Q sky130_fd_sc_hd__dfxtp_2
XFILLER_22_398 VGND VGND VPWR VPWR sky130_fd_sc_hd__decap_3
X_5748_ _5812_/CLK _5748_/D VGND VGND VPWR VPWR _5748_/Q sky130_fd_sc_hd__dfxtp_2
XFILLER_108_459 VGND VGND VPWR VPWR sky130_fd_sc_hd__fill_1
X_5679_ _5871_/CLK _5679_/D VGND VGND VPWR VPWR _5679_/Q sky130_fd_sc_hd__dfxtp_2
XFILLER_1_225 VGND VGND VPWR VPWR sky130_fd_sc_hd__decap_3
XFILLER_89_332 VGND VGND VPWR VPWR sky130_fd_sc_hd__decap_3
XFILLER_9_6 VGND VGND VPWR VPWR sky130_fd_sc_hd__decap_3
XTAP_TAPCELL_ROW_9_358 VGND VPWR sky130_fd_sc_hd__tapvpwrvgnd_1
XFILLER_103_175 VGND VGND VPWR VPWR sky130_fd_sc_hd__decap_3
XFILLER_104_687 VGND VGND VPWR VPWR sky130_fd_sc_hd__fill_1
XFILLER_106_41 VGND VGND VPWR VPWR sky130_fd_sc_hd__fill_1
XFILLER_1_269 VGND VGND VPWR VPWR sky130_fd_sc_hd__fill_2
XFILLER_106_74 VGND VGND VPWR VPWR sky130_fd_sc_hd__decap_3
XFILLER_106_85 VGND VGND VPWR VPWR sky130_fd_sc_hd__fill_2
XFILLER_66_78 VGND VGND VPWR VPWR sky130_fd_sc_hd__decap_3
Xhold1250 _5308_/Q VGND VGND VPWR VPWR _4236_/B2 sky130_fd_sc_hd__dlygate4sd3_1
Xhold1261 _5177_/Q VGND VGND VPWR VPWR _4096_/B2 sky130_fd_sc_hd__dlygate4sd3_1
XTAP_TAPCELL_ROW_56_920 VGND VPWR sky130_fd_sc_hd__tapvpwrvgnd_1
Xhold1272 _6070_/Q VGND VGND VPWR VPWR _5046_/B2 sky130_fd_sc_hd__dlygate4sd3_1
Xhold1283 _5591_/Q VGND VGND VPWR VPWR _4537_/B2 sky130_fd_sc_hd__dlygate4sd3_1
Xhold1294 _5358_/Q VGND VGND VPWR VPWR _4288_/B2 sky130_fd_sc_hd__dlygate4sd3_1
XFILLER_45_457 VGND VGND VPWR VPWR sky130_fd_sc_hd__decap_3
XFILLER_13_332 VGND VGND VPWR VPWR sky130_fd_sc_hd__decap_3
XFILLER_41_641 VGND VGND VPWR VPWR sky130_fd_sc_hd__fill_2
Xclkbuf_leaf_52_clk clkload7/A VGND VGND VPWR VPWR _5804_/CLK sky130_fd_sc_hd__clkbuf_8
XFILLER_15_60 VGND VGND VPWR VPWR sky130_fd_sc_hd__fill_2
XFILLER_15_93 VGND VGND VPWR VPWR sky130_fd_sc_hd__decap_3
XFILLER_9_369 VGND VGND VPWR VPWR sky130_fd_sc_hd__decap_3
XTAP_TAPCELL_ROW_97_1410 VGND VPWR sky130_fd_sc_hd__tapvpwrvgnd_1
XFILLER_5_564 VGND VGND VPWR VPWR sky130_fd_sc_hd__decap_3
XFILLER_107_481 VGND VGND VPWR VPWR sky130_fd_sc_hd__decap_3
Xoutput70 _3163_/X VGND VGND VPWR VPWR rd1[28] sky130_fd_sc_hd__clkbuf_2
XFILLER_110_613 VGND VGND VPWR VPWR sky130_fd_sc_hd__decap_3
Xoutput92 _3680_/X VGND VGND VPWR VPWR rd2[19] sky130_fd_sc_hd__clkbuf_2
Xoutput81 _2735_/X VGND VGND VPWR VPWR rd1[9] sky130_fd_sc_hd__clkbuf_2
XFILLER_110_635 VGND VGND VPWR VPWR sky130_fd_sc_hd__decap_3
XFILLER_110_657 VGND VGND VPWR VPWR sky130_fd_sc_hd__decap_3
XFILLER_36_402 VGND VGND VPWR VPWR sky130_fd_sc_hd__fill_1
XFILLER_48_251 VGND VGND VPWR VPWR sky130_fd_sc_hd__fill_1
X_3030_ _3023_/X _3029_/X _2712_/D VGND VGND VPWR VPWR _3030_/X sky130_fd_sc_hd__o21a_2
XPHY_EDGE_ROW_90_Left_206 VGND VGND VPWR VPWR sky130_fd_sc_hd__decap_3
XFILLER_63_232 VGND VGND VPWR VPWR sky130_fd_sc_hd__decap_3
XFILLER_91_596 VGND VGND VPWR VPWR sky130_fd_sc_hd__decap_3
X_4981_ _4981_/A _4981_/B VGND VGND VPWR VPWR _4981_/Y sky130_fd_sc_hd__nor2_2
XTAP_TAPCELL_ROW_34_658 VGND VPWR sky130_fd_sc_hd__tapvpwrvgnd_1
Xclkbuf_leaf_43_clk clkload5/A VGND VGND VPWR VPWR _5713_/CLK sky130_fd_sc_hd__clkbuf_8
X_3932_ _5847_/Q _5463_/Q _3936_/S VGND VGND VPWR VPWR _3932_/X sky130_fd_sc_hd__mux2_1
XTAP_TAPCELL_ROW_102_1469 VGND VPWR sky130_fd_sc_hd__tapvpwrvgnd_1
XTAP_TAPCELL_ROW_62_989 VGND VPWR sky130_fd_sc_hd__tapvpwrvgnd_1
X_3863_ _5812_/Q _5748_/Q _3863_/S VGND VGND VPWR VPWR _3863_/X sky130_fd_sc_hd__mux2_1
X_5602_ _5986_/CLK _5602_/D VGND VGND VPWR VPWR _5602_/Q sky130_fd_sc_hd__dfxtp_2
X_2814_ _3198_/A _2810_/X _2813_/X _3206_/C1 VGND VGND VPWR VPWR _2814_/X sky130_fd_sc_hd__o211a_2
X_5533_ _6050_/CLK _5533_/D VGND VGND VPWR VPWR _5533_/Q sky130_fd_sc_hd__dfxtp_2
X_3794_ _3787_/X _3793_/X wire553/X VGND VGND VPWR VPWR _3794_/X sky130_fd_sc_hd__o21a_2
XFILLER_11_18 VGND VGND VPWR VPWR sky130_fd_sc_hd__fill_2
XFILLER_8_380 VGND VGND VPWR VPWR sky130_fd_sc_hd__fill_1
X_2745_ _3215_/A _2741_/X _2744_/X _3106_/C1 VGND VGND VPWR VPWR _2745_/X sky130_fd_sc_hd__o211a_2
XFILLER_105_418 VGND VGND VPWR VPWR sky130_fd_sc_hd__decap_3
X_5464_ _6036_/CLK _5464_/D VGND VGND VPWR VPWR _5464_/Q sky130_fd_sc_hd__dfxtp_2
X_2676_ _5119_/Q _5087_/Q _6015_/Q _5983_/Q _2678_/S _3086_/S1 VGND VGND VPWR VPWR
+ _2677_/B sky130_fd_sc_hd__mux4_2
X_5395_ _5589_/CLK _5395_/D VGND VGND VPWR VPWR _5395_/Q sky130_fd_sc_hd__dfxtp_2
X_4415_ _4993_/A1 _4426_/A2 _4426_/B1 _4415_/B2 VGND VGND VPWR VPWR _5475_/D sky130_fd_sc_hd__a22o_2
XTAP_TAPCELL_ROW_6_317 VGND VPWR sky130_fd_sc_hd__tapvpwrvgnd_1
X_4346_ _5028_/A1 _4364_/A2 _4364_/B1 _4346_/B2 VGND VGND VPWR VPWR _5412_/D sky130_fd_sc_hd__a22o_2
Xfanout337 _4980_/Y VGND VGND VPWR VPWR _5008_/A2 sky130_fd_sc_hd__clkdlybuf4s25_1
Xfanout326 _3951_/Y VGND VGND VPWR VPWR wire327/A sky130_fd_sc_hd__clkdlybuf4s25_1
Xfanout315 _3988_/Y VGND VGND VPWR VPWR _4005_/B1 sky130_fd_sc_hd__clkdlybuf4s25_1
XFILLER_86_346 VGND VGND VPWR VPWR sky130_fd_sc_hd__decap_3
Xfanout359 _4904_/A2 VGND VGND VPWR VPWR _4879_/B sky130_fd_sc_hd__clkdlybuf4s25_1
X_4277_ _4517_/A1 wire475/X wire255/X _4277_/B2 VGND VGND VPWR VPWR _5347_/D sky130_fd_sc_hd__a22o_2
X_6016_ _6030_/CLK _6016_/D VGND VGND VPWR VPWR _6016_/Q sky130_fd_sc_hd__dfxtp_2
X_3228_ _3228_/A1 _3225_/X _3227_/X _3228_/B2 VGND VGND VPWR VPWR _3228_/X sky130_fd_sc_hd__a22o_2
XFILLER_39_284 VGND VGND VPWR VPWR sky130_fd_sc_hd__fill_2
XFILLER_67_593 VGND VGND VPWR VPWR sky130_fd_sc_hd__decap_3
XFILLER_82_530 VGND VGND VPWR VPWR sky130_fd_sc_hd__fill_2
X_3159_ _5588_/Q _5556_/Q _3159_/S VGND VGND VPWR VPWR _3159_/X sky130_fd_sc_hd__mux2_1
XFILLER_42_416 VGND VGND VPWR VPWR sky130_fd_sc_hd__decap_3
XTAP_TAPCELL_ROW_68_1066 VGND VPWR sky130_fd_sc_hd__tapvpwrvgnd_1
XFILLER_23_630 VGND VGND VPWR VPWR sky130_fd_sc_hd__decap_3
Xclkbuf_leaf_34_clk clkload4/A VGND VGND VPWR VPWR _6031_/CLK sky130_fd_sc_hd__clkbuf_8
XTAP_TAPCELL_ROW_81_1222 VGND VPWR sky130_fd_sc_hd__tapvpwrvgnd_1
XFILLER_23_685 VGND VGND VPWR VPWR sky130_fd_sc_hd__decap_3
XFILLER_22_162 VGND VGND VPWR VPWR sky130_fd_sc_hd__decap_3
Xwire716 _3600_/S VGND VGND VPWR VPWR _3687_/A sky130_fd_sc_hd__clkbuf_4
XFILLER_10_368 VGND VGND VPWR VPWR sky130_fd_sc_hd__decap_3
XFILLER_108_256 VGND VGND VPWR VPWR sky130_fd_sc_hd__decap_3
XTAP_TAPCELL_ROW_79_1195 VGND VPWR sky130_fd_sc_hd__tapvpwrvgnd_1
XFILLER_7_3 VGND VGND VPWR VPWR sky130_fd_sc_hd__decap_3
XTAP_TAPCELL_ROW_92_1351 VGND VPWR sky130_fd_sc_hd__tapvpwrvgnd_1
XFILLER_2_567 VGND VGND VPWR VPWR sky130_fd_sc_hd__decap_3
XFILLER_2_589 VGND VGND VPWR VPWR sky130_fd_sc_hd__decap_3
XFILLER_77_77 VGND VGND VPWR VPWR sky130_fd_sc_hd__fill_2
Xfanout860 fanout863/X VGND VGND VPWR VPWR _2925_/S sky130_fd_sc_hd__clkdlybuf4s25_1
XFILLER_65_508 VGND VGND VPWR VPWR sky130_fd_sc_hd__decap_3
XFILLER_77_357 VGND VGND VPWR VPWR sky130_fd_sc_hd__decap_3
Xfanout893 _5047_/A1 VGND VGND VPWR VPWR _4843_/A1 sky130_fd_sc_hd__clkdlybuf4s25_1
Xfanout882 input44/X VGND VGND VPWR VPWR _5021_/A1 sky130_fd_sc_hd__clkdlybuf4s25_1
Xfanout871 input47/X VGND VGND VPWR VPWR _4514_/A1 sky130_fd_sc_hd__clkdlybuf4s25_1
XFILLER_18_413 VGND VGND VPWR VPWR sky130_fd_sc_hd__decap_3
XFILLER_45_210 VGND VGND VPWR VPWR sky130_fd_sc_hd__decap_3
XFILLER_93_21 VGND VGND VPWR VPWR sky130_fd_sc_hd__decap_3
XFILLER_73_530 VGND VGND VPWR VPWR sky130_fd_sc_hd__decap_3
XFILLER_93_54 VGND VGND VPWR VPWR sky130_fd_sc_hd__fill_2
XFILLER_93_98 VGND VGND VPWR VPWR sky130_fd_sc_hd__fill_2
XFILLER_33_438 VGND VGND VPWR VPWR sky130_fd_sc_hd__fill_1
Xclkbuf_leaf_25_clk clkbuf_4_10_0_clk/X VGND VGND VPWR VPWR _6052_/CLK sky130_fd_sc_hd__clkbuf_8
XFILLER_13_140 VGND VGND VPWR VPWR sky130_fd_sc_hd__decap_3
XFILLER_14_663 VGND VGND VPWR VPWR sky130_fd_sc_hd__decap_3
XTAP_TAPCELL_ROW_31_617 VGND VPWR sky130_fd_sc_hd__tapvpwrvgnd_1
XFILLER_9_144 VGND VGND VPWR VPWR sky130_fd_sc_hd__decap_3
XFILLER_9_177 VGND VGND VPWR VPWR sky130_fd_sc_hd__decap_3
XTAP_TAPCELL_ROW_11_385 VGND VPWR sky130_fd_sc_hd__tapvpwrvgnd_1
X_2530_ _3131_/A _2527_/X _2529_/X _3134_/A1 VGND VGND VPWR VPWR _2530_/X sky130_fd_sc_hd__o22a_2
X_4200_ _4645_/A1 wire489/X wire269/A _4200_/B2 VGND VGND VPWR VPWR _5274_/D sky130_fd_sc_hd__a22o_2
XFILLER_3_30 VGND VGND VPWR VPWR sky130_fd_sc_hd__decap_3
X_5180_ _6067_/CLK _5180_/D VGND VGND VPWR VPWR _5180_/Q sky130_fd_sc_hd__dfxtp_2
XFILLER_3_63 VGND VGND VPWR VPWR sky130_fd_sc_hd__decap_3
X_4131_ _5018_/A1 _4158_/A2 _4158_/B1 _4131_/B2 VGND VGND VPWR VPWR _5210_/D sky130_fd_sc_hd__a22o_2
XFILLER_68_357 VGND VGND VPWR VPWR sky130_fd_sc_hd__fill_1
XTAP_TAPCELL_ROW_39_717 VGND VPWR sky130_fd_sc_hd__tapvpwrvgnd_1
X_4062_ _4984_/A1 _4089_/A2 _4089_/B1 _4062_/B2 VGND VGND VPWR VPWR _5146_/D sky130_fd_sc_hd__a22o_2
XFILLER_95_187 VGND VGND VPWR VPWR sky130_fd_sc_hd__fill_2
X_3013_ _5710_/Q _5678_/Q _5646_/Q _5614_/Q _2708_/S _3013_/S1 VGND VGND VPWR VPWR
+ _3013_/X sky130_fd_sc_hd__mux4_2
XFILLER_36_243 VGND VGND VPWR VPWR sky130_fd_sc_hd__fill_1
XFILLER_64_585 VGND VGND VPWR VPWR sky130_fd_sc_hd__decap_3
XTAP_TAPCELL_ROW_19_474 VGND VPWR sky130_fd_sc_hd__tapvpwrvgnd_1
XFILLER_24_438 VGND VGND VPWR VPWR sky130_fd_sc_hd__decap_3
Xclkbuf_leaf_16_clk clkbuf_4_8_0_clk/X VGND VGND VPWR VPWR _6036_/CLK sky130_fd_sc_hd__clkbuf_8
X_4964_ _4998_/A1 _4964_/A2 _4964_/B1 _4964_/B2 VGND VGND VPWR VPWR _5992_/D sky130_fd_sc_hd__a22o_2
X_3915_ _5814_/Q _5750_/Q _3915_/S VGND VGND VPWR VPWR _3915_/X sky130_fd_sc_hd__mux2_1
X_4895_ _5031_/A1 wire360/X _4895_/B1 _4895_/B2 VGND VGND VPWR VPWR _5927_/D sky130_fd_sc_hd__a22o_2
X_3846_ _5427_/Q _5075_/Q _3847_/S VGND VGND VPWR VPWR _3846_/X sky130_fd_sc_hd__mux2_1
X_3777_ _5136_/Q _5104_/Q _6032_/Q _6000_/Q _3779_/S _3905_/S1 VGND VGND VPWR VPWR
+ _3777_/X sky130_fd_sc_hd__mux4_2
XTAP_TAPCELL_ROW_115_1627 VGND VPWR sky130_fd_sc_hd__tapvpwrvgnd_1
X_5516_ _6017_/CLK _5516_/D VGND VGND VPWR VPWR _5516_/Q sky130_fd_sc_hd__dfxtp_2
X_2728_ _2730_/A _2724_/X _2727_/X _3118_/B2 VGND VGND VPWR VPWR _2728_/X sky130_fd_sc_hd__o211a_2
XTAP_TAPCELL_ROW_115_1638 VGND VPWR sky130_fd_sc_hd__tapvpwrvgnd_1
X_5447_ _6055_/CLK _5447_/D VGND VGND VPWR VPWR _5447_/Q sky130_fd_sc_hd__dfxtp_2
X_2659_ _5374_/Q _5342_/Q _5310_/Q _5278_/Q _2998_/S _3113_/S1 VGND VGND VPWR VPWR
+ _2659_/X sky130_fd_sc_hd__mux4_2
X_5378_ _6046_/CLK _5378_/D VGND VGND VPWR VPWR _5378_/Q sky130_fd_sc_hd__dfxtp_2
XFILLER_113_281 VGND VGND VPWR VPWR sky130_fd_sc_hd__decap_3
XFILLER_99_482 VGND VGND VPWR VPWR sky130_fd_sc_hd__decap_3
Xfanout145 _4845_/Y VGND VGND VPWR VPWR wire146/A sky130_fd_sc_hd__clkdlybuf4s25_1
Xfanout134 _4913_/Y VGND VGND VPWR VPWR _4943_/B1 sky130_fd_sc_hd__clkdlybuf4s25_1
Xfanout123 _4981_/Y VGND VGND VPWR VPWR _5012_/B1 sky130_fd_sc_hd__clkdlybuf4s25_1
X_4329_ _4535_/A1 _4329_/A2 _4329_/B1 _4329_/B2 VGND VGND VPWR VPWR _5397_/D sky130_fd_sc_hd__a22o_2
Xfanout178 _4642_/Y VGND VGND VPWR VPWR wire179/A sky130_fd_sc_hd__clkdlybuf4s25_1
Xfanout167 _4711_/Y VGND VGND VPWR VPWR _4741_/B1 sky130_fd_sc_hd__clkdlybuf4s25_1
XPHY_EDGE_ROW_114_Right_114 VGND VGND VPWR VPWR sky130_fd_sc_hd__decap_3
XFILLER_27_243 VGND VGND VPWR VPWR sky130_fd_sc_hd__fill_2
XFILLER_74_349 VGND VGND VPWR VPWR sky130_fd_sc_hd__decap_3
XFILLER_15_427 VGND VGND VPWR VPWR sky130_fd_sc_hd__fill_2
XFILLER_27_265 VGND VGND VPWR VPWR sky130_fd_sc_hd__fill_2
XFILLER_15_449 VGND VGND VPWR VPWR sky130_fd_sc_hd__decap_3
XFILLER_55_596 VGND VGND VPWR VPWR sky130_fd_sc_hd__decap_3
XFILLER_63_35 VGND VGND VPWR VPWR sky130_fd_sc_hd__decap_3
XFILLER_63_57 VGND VGND VPWR VPWR sky130_fd_sc_hd__decap_3
XFILLER_11_655 VGND VGND VPWR VPWR sky130_fd_sc_hd__decap_3
Xwire524 wire524/A VGND VGND VPWR VPWR wire524/X sky130_fd_sc_hd__buf_4
XFILLER_7_626 VGND VGND VPWR VPWR sky130_fd_sc_hd__decap_3
Xwire546 wire546/A VGND VGND VPWR VPWR wire546/X sky130_fd_sc_hd__clkbuf_4
XFILLER_109_543 VGND VGND VPWR VPWR sky130_fd_sc_hd__fill_2
XFILLER_109_598 VGND VGND VPWR VPWR sky130_fd_sc_hd__decap_3
XFILLER_12_94 VGND VGND VPWR VPWR sky130_fd_sc_hd__decap_3
XFILLER_104_281 VGND VGND VPWR VPWR sky130_fd_sc_hd__fill_1
XFILLER_77_110 VGND VGND VPWR VPWR sky130_fd_sc_hd__fill_2
XFILLER_26_9 VGND VGND VPWR VPWR sky130_fd_sc_hd__decap_3
XFILLER_38_519 VGND VGND VPWR VPWR sky130_fd_sc_hd__decap_3
XFILLER_77_143 VGND VGND VPWR VPWR sky130_fd_sc_hd__decap_3
Xfanout690 _2497_/X VGND VGND VPWR VPWR _3205_/B2 sky130_fd_sc_hd__buf_4
XFILLER_92_168 VGND VGND VPWR VPWR sky130_fd_sc_hd__decap_3
XFILLER_73_393 VGND VGND VPWR VPWR sky130_fd_sc_hd__decap_3
XTAP_TAPCELL_ROW_16_444 VGND VPWR sky130_fd_sc_hd__tapvpwrvgnd_1
XTAP_TAPCELL_ROW_44_775 VGND VPWR sky130_fd_sc_hd__tapvpwrvgnd_1
X_3700_ _5804_/Q _5740_/Q _3700_/S VGND VGND VPWR VPWR _3700_/X sky130_fd_sc_hd__mux2_1
X_4680_ _4749_/A1 _4693_/A2 _4693_/B1 _4680_/B2 VGND VGND VPWR VPWR _5723_/D sky130_fd_sc_hd__a22o_2
X_3631_ _5801_/Q _5737_/Q _3631_/S VGND VGND VPWR VPWR _3632_/B sky130_fd_sc_hd__mux2_1
X_3562_ _3562_/A _3562_/B VGND VGND VPWR VPWR _3562_/X sky130_fd_sc_hd__or2_2
XFILLER_6_681 VGND VGND VPWR VPWR sky130_fd_sc_hd__decap_3
X_5301_ _5525_/CLK _5301_/D VGND VGND VPWR VPWR _5301_/Q sky130_fd_sc_hd__dfxtp_2
X_2513_ _5688_/Q _5656_/Q _5624_/Q _5592_/Q _3150_/S _3153_/S1 VGND VGND VPWR VPWR
+ _2514_/B sky130_fd_sc_hd__mux4_2
XFILLER_115_557 VGND VGND VPWR VPWR sky130_fd_sc_hd__decap_3
XFILLER_115_568 VGND VGND VPWR VPWR sky130_fd_sc_hd__decap_3
X_3493_ _3611_/B2 _3491_/X _3492_/X _3502_/A1 VGND VGND VPWR VPWR _3493_/X sky130_fd_sc_hd__o22a_2
XFILLER_88_419 VGND VGND VPWR VPWR sky130_fd_sc_hd__fill_1
Xclkbuf_leaf_5_clk clkbuf_4_2_0_clk/X VGND VGND VPWR VPWR _5934_/CLK sky130_fd_sc_hd__clkbuf_8
X_5232_ _6032_/CLK _5232_/D VGND VGND VPWR VPWR _5232_/Q sky130_fd_sc_hd__dfxtp_2
XFILLER_96_430 VGND VGND VPWR VPWR sky130_fd_sc_hd__decap_3
X_5163_ _5547_/CLK _5163_/D VGND VGND VPWR VPWR _5163_/Q sky130_fd_sc_hd__dfxtp_2
XFILLER_29_508 VGND VGND VPWR VPWR sky130_fd_sc_hd__fill_2
XFILLER_29_519 VGND VGND VPWR VPWR sky130_fd_sc_hd__decap_3
XTAP_TAPCELL_ROW_110_1568 VGND VPWR sky130_fd_sc_hd__tapvpwrvgnd_1
Xhold1805 _5073_/Q VGND VGND VPWR VPWR _3977_/B2 sky130_fd_sc_hd__dlygate4sd3_1
Xhold1816 _5551_/Q VGND VGND VPWR VPWR _4495_/B2 sky130_fd_sc_hd__dlygate4sd3_1
Xhold1827 _5909_/Q VGND VGND VPWR VPWR _4875_/B2 sky130_fd_sc_hd__dlygate4sd3_1
X_4114_ _4525_/A1 _4094_/B _4123_/B1 _4114_/B2 VGND VGND VPWR VPWR _5195_/D sky130_fd_sc_hd__a22o_2
XFILLER_83_113 VGND VGND VPWR VPWR sky130_fd_sc_hd__decap_3
Xhold1838 _5265_/Q VGND VGND VPWR VPWR _4188_/B2 sky130_fd_sc_hd__dlygate4sd3_1
Xhold1849 _5677_/Q VGND VGND VPWR VPWR _4630_/B2 sky130_fd_sc_hd__dlygate4sd3_1
X_5094_ _6066_/CLK _5094_/D VGND VGND VPWR VPWR _5094_/Q sky130_fd_sc_hd__dfxtp_2
X_4045_ _5037_/A1 _4050_/A2 _4050_/B1 _4045_/B2 VGND VGND VPWR VPWR _5133_/D sky130_fd_sc_hd__a22o_2
XFILLER_71_308 VGND VGND VPWR VPWR sky130_fd_sc_hd__fill_2
XFILLER_52_522 VGND VGND VPWR VPWR sky130_fd_sc_hd__fill_2
XFILLER_52_533 VGND VGND VPWR VPWR sky130_fd_sc_hd__fill_2
XTAP_TAPCELL_ROW_65_1025 VGND VPWR sky130_fd_sc_hd__tapvpwrvgnd_1
X_5996_ _6055_/CLK _5996_/D VGND VGND VPWR VPWR _5996_/Q sky130_fd_sc_hd__dfxtp_2
X_4947_ _4981_/A _4947_/B VGND VGND VPWR VPWR _4947_/Y sky130_fd_sc_hd__nor2_2
X_4878_ _4878_/A _4878_/B VGND VGND VPWR VPWR _4878_/Y sky130_fd_sc_hd__nor2_2
X_3829_ _5426_/Q _5074_/Q _3830_/S VGND VGND VPWR VPWR _3829_/X sky130_fd_sc_hd__mux2_1
XFILLER_106_524 VGND VGND VPWR VPWR sky130_fd_sc_hd__decap_3
XFILLER_3_106 VGND VGND VPWR VPWR sky130_fd_sc_hd__decap_3
XFILLER_4_629 VGND VGND VPWR VPWR sky130_fd_sc_hd__decap_3
XFILLER_109_6 VGND VGND VPWR VPWR sky130_fd_sc_hd__decap_3
XTAP_TAPCELL_ROW_76_1165 VGND VPWR sky130_fd_sc_hd__tapvpwrvgnd_1
XFILLER_58_35 VGND VGND VPWR VPWR sky130_fd_sc_hd__fill_2
XFILLER_59_121 VGND VGND VPWR VPWR sky130_fd_sc_hd__fill_2
XFILLER_99_290 VGND VGND VPWR VPWR sky130_fd_sc_hd__decap_3
XFILLER_58_79 VGND VGND VPWR VPWR sky130_fd_sc_hd__decap_3
XFILLER_114_41 VGND VGND VPWR VPWR sky130_fd_sc_hd__decap_3
XFILLER_47_316 VGND VGND VPWR VPWR sky130_fd_sc_hd__fill_1
XFILLER_75_614 VGND VGND VPWR VPWR sky130_fd_sc_hd__fill_2
XFILLER_75_636 VGND VGND VPWR VPWR sky130_fd_sc_hd__decap_3
Xwire1024 _3275_/S1 VGND VGND VPWR VPWR _3893_/S1 sky130_fd_sc_hd__clkbuf_4
XFILLER_114_74 VGND VGND VPWR VPWR sky130_fd_sc_hd__decap_3
XFILLER_114_85 VGND VGND VPWR VPWR sky130_fd_sc_hd__decap_3
XFILLER_43_500 VGND VGND VPWR VPWR sky130_fd_sc_hd__decap_3
XFILLER_90_617 VGND VGND VPWR VPWR sky130_fd_sc_hd__decap_3
XFILLER_74_78 VGND VGND VPWR VPWR sky130_fd_sc_hd__decap_3
XTAP_TAPCELL_ROW_87_1294 VGND VPWR sky130_fd_sc_hd__tapvpwrvgnd_1
XFILLER_15_279 VGND VGND VPWR VPWR sky130_fd_sc_hd__fill_1
XFILLER_70_396 VGND VGND VPWR VPWR sky130_fd_sc_hd__fill_2
XTAP_TAPCELL_ROW_13_403 VGND VPWR sky130_fd_sc_hd__tapvpwrvgnd_1
XFILLER_23_290 VGND VGND VPWR VPWR sky130_fd_sc_hd__fill_2
XTAP_TAPCELL_ROW_41_745 VGND VPWR sky130_fd_sc_hd__tapvpwrvgnd_1
Xwire332 _5015_/B VGND VGND VPWR VPWR wire332/X sky130_fd_sc_hd__clkbuf_4
XFILLER_99_53 VGND VGND VPWR VPWR sky130_fd_sc_hd__decap_3
Xwire376 wire376/A VGND VGND VPWR VPWR wire376/X sky130_fd_sc_hd__clkbuf_4
XFILLER_3_662 VGND VGND VPWR VPWR sky130_fd_sc_hd__decap_3
XFILLER_3_673 VGND VGND VPWR VPWR sky130_fd_sc_hd__decap_3
Xload_slew304 _4085_/B1 VGND VGND VPWR VPWR _4088_/B1 sky130_fd_sc_hd__buf_4
XFILLER_24_6 VGND VGND VPWR VPWR sky130_fd_sc_hd__decap_3
Xload_slew348 _4978_/A2 VGND VGND VPWR VPWR _4979_/A2 sky130_fd_sc_hd__clkbuf_4
XFILLER_65_113 VGND VGND VPWR VPWR sky130_fd_sc_hd__decap_3
XFILLER_78_485 VGND VGND VPWR VPWR sky130_fd_sc_hd__decap_3
XTAP_TAPCELL_ROW_49_834 VGND VPWR sky130_fd_sc_hd__tapvpwrvgnd_1
XFILLER_0_53 VGND VGND VPWR VPWR sky130_fd_sc_hd__decap_3
XFILLER_19_585 VGND VGND VPWR VPWR sky130_fd_sc_hd__decap_3
XFILLER_34_522 VGND VGND VPWR VPWR sky130_fd_sc_hd__fill_1
XFILLER_0_97 VGND VGND VPWR VPWR sky130_fd_sc_hd__decap_3
X_5850_ _5914_/CLK _5850_/D VGND VGND VPWR VPWR _5850_/Q sky130_fd_sc_hd__dfxtp_2
X_5781_ _6069_/CLK _5781_/D VGND VGND VPWR VPWR _5781_/Q sky130_fd_sc_hd__dfxtp_2
X_4801_ input16/X _4801_/B VGND VGND VPWR VPWR _5839_/D sky130_fd_sc_hd__and2b_2
X_2993_ _5421_/Q _5069_/Q _2993_/S VGND VGND VPWR VPWR _2993_/X sky130_fd_sc_hd__mux2_1
XFILLER_9_51 VGND VGND VPWR VPWR sky130_fd_sc_hd__decap_3
X_4732_ _5036_/A1 wire389/X wire171/X _4732_/B2 VGND VGND VPWR VPWR _5772_/D sky130_fd_sc_hd__a22o_2
XFILLER_9_95 VGND VGND VPWR VPWR sky130_fd_sc_hd__fill_1
X_4663_ _4766_/A1 _4668_/A2 _4668_/B1 _4663_/B2 VGND VGND VPWR VPWR _5708_/D sky130_fd_sc_hd__a22o_2
X_3614_ _3614_/A _3614_/B _3614_/C VGND VGND VPWR VPWR _3614_/X sky130_fd_sc_hd__and3_2
X_4594_ _4899_/A1 _4605_/A2 _4605_/B1 _4594_/B2 VGND VGND VPWR VPWR _5643_/D sky130_fd_sc_hd__a22o_2
X_3545_ _6053_/Q _5957_/Q _3802_/S VGND VGND VPWR VPWR _3545_/X sky130_fd_sc_hd__mux2_1
XFILLER_0_109 VGND VGND VPWR VPWR sky130_fd_sc_hd__decap_3
X_3476_ _3687_/A _3473_/X _3474_/X _3694_/A VGND VGND VPWR VPWR _3476_/X sky130_fd_sc_hd__o22a_2
XFILLER_88_249 VGND VGND VPWR VPWR sky130_fd_sc_hd__decap_3
X_5215_ _5802_/CLK _5215_/D VGND VGND VPWR VPWR _5215_/Q sky130_fd_sc_hd__dfxtp_2
Xclkbuf_4_15_0_clk clkbuf_0_clk/X VGND VGND VPWR VPWR clkload7/A sky130_fd_sc_hd__clkbuf_8
XFILLER_28_27 VGND VGND VPWR VPWR sky130_fd_sc_hd__fill_1
XFILLER_29_316 VGND VGND VPWR VPWR sky130_fd_sc_hd__decap_3
XFILLER_57_614 VGND VGND VPWR VPWR sky130_fd_sc_hd__fill_2
Xhold1602 _5349_/Q VGND VGND VPWR VPWR _4279_/B2 sky130_fd_sc_hd__dlygate4sd3_1
Xhold1613 _5469_/Q VGND VGND VPWR VPWR _4409_/B2 sky130_fd_sc_hd__dlygate4sd3_1
Xhold1624 _5787_/Q VGND VGND VPWR VPWR _4749_/B2 sky130_fd_sc_hd__dlygate4sd3_1
Xhold1635 _5613_/Q VGND VGND VPWR VPWR _4562_/B2 sky130_fd_sc_hd__dlygate4sd3_1
X_5146_ _6010_/CLK _5146_/D VGND VGND VPWR VPWR _5146_/Q sky130_fd_sc_hd__dfxtp_2
XFILLER_111_593 VGND VGND VPWR VPWR sky130_fd_sc_hd__decap_3
Xhold1646 _5904_/Q VGND VGND VPWR VPWR _4870_/B2 sky130_fd_sc_hd__dlygate4sd3_1
Xhold1657 _5785_/Q VGND VGND VPWR VPWR _4747_/B2 sky130_fd_sc_hd__dlygate4sd3_1
Xhold1668 _5404_/Q VGND VGND VPWR VPWR _4338_/B2 sky130_fd_sc_hd__dlygate4sd3_1
Xload_slew1109 _3858_/S VGND VGND VPWR VPWR _3514_/S sky130_fd_sc_hd__buf_2
X_5077_ _5691_/CLK _5077_/D VGND VGND VPWR VPWR _5077_/Q sky130_fd_sc_hd__dfxtp_2
XFILLER_84_477 VGND VGND VPWR VPWR sky130_fd_sc_hd__decap_3
Xhold1679 _5637_/Q VGND VGND VPWR VPWR _4588_/B2 sky130_fd_sc_hd__dlygate4sd3_1
X_4028_ _5020_/A1 _4053_/A2 _4053_/B1 _4028_/B2 VGND VGND VPWR VPWR _5116_/D sky130_fd_sc_hd__a22o_2
XFILLER_37_393 VGND VGND VPWR VPWR sky130_fd_sc_hd__decap_3
XFILLER_44_26 VGND VGND VPWR VPWR sky130_fd_sc_hd__fill_2
XFILLER_71_116 VGND VGND VPWR VPWR sky130_fd_sc_hd__decap_3
XFILLER_71_149 VGND VGND VPWR VPWR sky130_fd_sc_hd__decap_3
XFILLER_44_48 VGND VGND VPWR VPWR sky130_fd_sc_hd__decap_3
XFILLER_40_503 VGND VGND VPWR VPWR sky130_fd_sc_hd__fill_2
XFILLER_52_396 VGND VGND VPWR VPWR sky130_fd_sc_hd__fill_1
X_5979_ _6010_/CLK _5979_/D VGND VGND VPWR VPWR _5979_/Q sky130_fd_sc_hd__dfxtp_2
XFILLER_20_271 VGND VGND VPWR VPWR sky130_fd_sc_hd__fill_2
XFILLER_109_30 VGND VGND VPWR VPWR sky130_fd_sc_hd__decap_3
XFILLER_106_321 VGND VGND VPWR VPWR sky130_fd_sc_hd__decap_3
XFILLER_109_63 VGND VGND VPWR VPWR sky130_fd_sc_hd__decap_3
XFILLER_106_365 VGND VGND VPWR VPWR sky130_fd_sc_hd__decap_3
XFILLER_109_96 VGND VGND VPWR VPWR sky130_fd_sc_hd__decap_3
XFILLER_69_78 VGND VGND VPWR VPWR sky130_fd_sc_hd__fill_2
XFILLER_0_643 VGND VGND VPWR VPWR sky130_fd_sc_hd__fill_1
XFILLER_0_654 VGND VGND VPWR VPWR sky130_fd_sc_hd__decap_3
XFILLER_0_676 VGND VGND VPWR VPWR sky130_fd_sc_hd__decap_3
XFILLER_85_11 VGND VGND VPWR VPWR sky130_fd_sc_hd__fill_2
XTAP_TAPCELL_ROW_89_1312 VGND VPWR sky130_fd_sc_hd__tapvpwrvgnd_1
XTAP_TAPCELL_ROW_89_1323 VGND VPWR sky130_fd_sc_hd__tapvpwrvgnd_1
XFILLER_75_488 VGND VGND VPWR VPWR sky130_fd_sc_hd__decap_3
XTAP_TAPCELL_ROW_46_804 VGND VPWR sky130_fd_sc_hd__tapvpwrvgnd_1
XFILLER_16_533 VGND VGND VPWR VPWR sky130_fd_sc_hd__fill_1
XFILLER_18_82 VGND VGND VPWR VPWR sky130_fd_sc_hd__fill_2
XFILLER_62_127 VGND VGND VPWR VPWR sky130_fd_sc_hd__decap_3
XFILLER_63_639 VGND VGND VPWR VPWR sky130_fd_sc_hd__decap_3
XFILLER_90_425 VGND VGND VPWR VPWR sky130_fd_sc_hd__decap_3
XFILLER_90_436 VGND VGND VPWR VPWR sky130_fd_sc_hd__decap_3
XFILLER_62_149 VGND VGND VPWR VPWR sky130_fd_sc_hd__decap_3
XFILLER_71_661 VGND VGND VPWR VPWR sky130_fd_sc_hd__fill_2
XTAP_TAPCELL_ROW_26_561 VGND VPWR sky130_fd_sc_hd__tapvpwrvgnd_1
XTAP_TAPCELL_ROW_54_892 VGND VPWR sky130_fd_sc_hd__tapvpwrvgnd_1
XFILLER_93_9 VGND VGND VPWR VPWR sky130_fd_sc_hd__decap_3
Xwire151 wire151/A VGND VGND VPWR VPWR wire151/X sky130_fd_sc_hd__clkbuf_4
XFILLER_109_181 VGND VGND VPWR VPWR sky130_fd_sc_hd__decap_3
XFILLER_98_503 VGND VGND VPWR VPWR sky130_fd_sc_hd__decap_3
X_3330_ _3315_/X _3320_/X _3329_/X _3899_/B1 VGND VGND VPWR VPWR _3330_/X sky130_fd_sc_hd__o31a_2
X_5000_ _5000_/A1 _5013_/A2 _5013_/B1 _5000_/B2 VGND VGND VPWR VPWR _6026_/D sky130_fd_sc_hd__a22o_2
X_3261_ _3261_/A _3261_/B VGND VGND VPWR VPWR _3261_/X sky130_fd_sc_hd__and2_2
XFILLER_22_3 VGND VGND VPWR VPWR sky130_fd_sc_hd__fill_1
XFILLER_38_102 VGND VGND VPWR VPWR sky130_fd_sc_hd__decap_3
Xload_slew189 _4625_/B1 VGND VGND VPWR VPWR _4640_/B1 sky130_fd_sc_hd__buf_4
X_3192_ _5142_/Q _5110_/Q _6038_/Q _6006_/Q _2789_/S wire772/X VGND VGND VPWR VPWR
+ _3192_/X sky130_fd_sc_hd__mux4_2
XFILLER_39_647 VGND VGND VPWR VPWR sky130_fd_sc_hd__fill_1
XFILLER_53_105 VGND VGND VPWR VPWR sky130_fd_sc_hd__fill_1
XFILLER_66_477 VGND VGND VPWR VPWR sky130_fd_sc_hd__fill_1
XFILLER_19_393 VGND VGND VPWR VPWR sky130_fd_sc_hd__decap_3
XFILLER_53_138 VGND VGND VPWR VPWR sky130_fd_sc_hd__decap_3
XFILLER_93_296 VGND VGND VPWR VPWR sky130_fd_sc_hd__decap_3
XFILLER_34_352 VGND VGND VPWR VPWR sky130_fd_sc_hd__decap_3
X_5902_ _5934_/CLK _5902_/D VGND VGND VPWR VPWR _5902_/Q sky130_fd_sc_hd__dfxtp_2
X_5833_ clkload8/A _5833_/D VGND VGND VPWR VPWR _5833_/Q sky130_fd_sc_hd__dfxtp_2
XFILLER_14_29 VGND VGND VPWR VPWR sky130_fd_sc_hd__decap_3
XFILLER_22_558 VGND VGND VPWR VPWR sky130_fd_sc_hd__decap_3
XPHY_EDGE_ROW_101_Left_217 VGND VGND VPWR VPWR sky130_fd_sc_hd__decap_3
X_5764_ _6052_/CLK _5764_/D VGND VGND VPWR VPWR _5764_/Q sky130_fd_sc_hd__dfxtp_2
X_2976_ _3218_/A1 _2974_/X _2975_/X _3218_/B2 VGND VGND VPWR VPWR _2976_/X sky130_fd_sc_hd__o22a_2
X_5695_ _5825_/CLK _5695_/D VGND VGND VPWR VPWR _5695_/Q sky130_fd_sc_hd__dfxtp_2
X_4715_ _5019_/A1 wire386/X wire166/A _4715_/B2 VGND VGND VPWR VPWR _5755_/D sky130_fd_sc_hd__a22o_2
X_4646_ _4749_/A1 _4659_/A2 _4659_/B1 _4646_/B2 VGND VGND VPWR VPWR _5691_/D sky130_fd_sc_hd__a22o_2
XFILLER_107_129 VGND VGND VPWR VPWR sky130_fd_sc_hd__decap_3
X_4577_ _4645_/A1 _4591_/A2 _4591_/B1 _4577_/B2 VGND VGND VPWR VPWR _5626_/D sky130_fd_sc_hd__a22o_2
XFILLER_89_503 VGND VGND VPWR VPWR sky130_fd_sc_hd__fill_1
XFILLER_115_173 VGND VGND VPWR VPWR sky130_fd_sc_hd__decap_3
XTAP_TAPCELL_ROW_73_1124 VGND VPWR sky130_fd_sc_hd__tapvpwrvgnd_1
Xmax_cap473 _4298_/Y VGND VGND VPWR VPWR fanout469/A sky130_fd_sc_hd__clkbuf_2
X_3528_ _3526_/X _3527_/X wire553/X VGND VGND VPWR VPWR _3528_/X sky130_fd_sc_hd__o21a_2
XPHY_EDGE_ROW_110_Left_226 VGND VGND VPWR VPWR sky130_fd_sc_hd__decap_3
Xhold2100 _5385_/Q VGND VGND VPWR VPWR _4317_/B2 sky130_fd_sc_hd__dlygate4sd3_1
Xhold2111 _5153_/Q VGND VGND VPWR VPWR _4069_/B2 sky130_fd_sc_hd__dlygate4sd3_1
X_3459_ _3941_/A _3459_/B VGND VGND VPWR VPWR _3459_/X sky130_fd_sc_hd__or2_2
Xhold1410 _5086_/Q VGND VGND VPWR VPWR _3995_/B2 sky130_fd_sc_hd__dlygate4sd3_1
Xhold2122 _5132_/Q VGND VGND VPWR VPWR _4044_/B2 sky130_fd_sc_hd__dlygate4sd3_1
Xhold2133 _5179_/Q VGND VGND VPWR VPWR _4098_/B2 sky130_fd_sc_hd__dlygate4sd3_1
Xhold2144 _5845_/Q VGND VGND VPWR VPWR _4807_/B sky130_fd_sc_hd__dlygate4sd3_1
XFILLER_29_113 VGND VGND VPWR VPWR sky130_fd_sc_hd__decap_3
Xhold1421 _5983_/Q VGND VGND VPWR VPWR _4955_/B2 sky130_fd_sc_hd__dlygate4sd3_1
Xhold1432 _5114_/Q VGND VGND VPWR VPWR _4026_/B2 sky130_fd_sc_hd__dlygate4sd3_1
Xhold1443 _5589_/Q VGND VGND VPWR VPWR _4535_/B2 sky130_fd_sc_hd__dlygate4sd3_1
Xhold2155 _5847_/Q VGND VGND VPWR VPWR _4809_/B sky130_fd_sc_hd__dlygate4sd3_1
X_5129_ _6012_/CLK _5129_/D VGND VGND VPWR VPWR _5129_/Q sky130_fd_sc_hd__dfxtp_2
XFILLER_29_157 VGND VGND VPWR VPWR sky130_fd_sc_hd__fill_2
Xhold1454 _5994_/Q VGND VGND VPWR VPWR _4966_/B2 sky130_fd_sc_hd__dlygate4sd3_1
Xhold1465 _5992_/Q VGND VGND VPWR VPWR _4964_/B2 sky130_fd_sc_hd__dlygate4sd3_1
Xhold1476 _5315_/Q VGND VGND VPWR VPWR _4243_/B2 sky130_fd_sc_hd__dlygate4sd3_1
Xhold1487 _5180_/Q VGND VGND VPWR VPWR _4099_/B2 sky130_fd_sc_hd__dlygate4sd3_1
Xhold1498 _5655_/Q VGND VGND VPWR VPWR _4606_/B2 sky130_fd_sc_hd__dlygate4sd3_1
XFILLER_25_352 VGND VGND VPWR VPWR sky130_fd_sc_hd__decap_3
XFILLER_111_42 VGND VGND VPWR VPWR sky130_fd_sc_hd__decap_3
XFILLER_13_503 VGND VGND VPWR VPWR sky130_fd_sc_hd__fill_1
XTAP_TAPCELL_ROW_84_1253 VGND VPWR sky130_fd_sc_hd__tapvpwrvgnd_1
XFILLER_111_75 VGND VGND VPWR VPWR sky130_fd_sc_hd__decap_3
XFILLER_13_558 VGND VGND VPWR VPWR sky130_fd_sc_hd__fill_2
XTAP_TAPCELL_ROW_23_520 VGND VPWR sky130_fd_sc_hd__tapvpwrvgnd_1
XTAP_TAPCELL_ROW_23_531 VGND VPWR sky130_fd_sc_hd__tapvpwrvgnd_1
XFILLER_71_57 VGND VGND VPWR VPWR sky130_fd_sc_hd__decap_3
XTAP_TAPCELL_ROW_51_862 VGND VPWR sky130_fd_sc_hd__tapvpwrvgnd_1
XFILLER_40_399 VGND VGND VPWR VPWR sky130_fd_sc_hd__decap_3
XFILLER_107_663 VGND VGND VPWR VPWR sky130_fd_sc_hd__decap_3
XFILLER_106_162 VGND VGND VPWR VPWR sky130_fd_sc_hd__decap_3
XFILLER_107_685 VGND VGND VPWR VPWR sky130_fd_sc_hd__decap_3
XFILLER_20_83 VGND VGND VPWR VPWR sky130_fd_sc_hd__fill_1
XTAP_TAPCELL_ROW_95_1393 VGND VPWR sky130_fd_sc_hd__tapvpwrvgnd_1
XFILLER_29_92 VGND VGND VPWR VPWR sky130_fd_sc_hd__decap_3
XTAP_TAPCELL_ROW_59_962 VGND VPWR sky130_fd_sc_hd__tapvpwrvgnd_1
XFILLER_90_222 VGND VGND VPWR VPWR sky130_fd_sc_hd__decap_3
XFILLER_16_374 VGND VGND VPWR VPWR sky130_fd_sc_hd__decap_3
XFILLER_91_6 VGND VGND VPWR VPWR sky130_fd_sc_hd__decap_3
X_2830_ _2830_/A _2830_/B VGND VGND VPWR VPWR _2830_/X sky130_fd_sc_hd__and2_2
XFILLER_31_388 VGND VGND VPWR VPWR sky130_fd_sc_hd__decap_3
XFILLER_31_399 VGND VGND VPWR VPWR sky130_fd_sc_hd__decap_3
X_2761_ _5795_/Q _5731_/Q _2777_/S VGND VGND VPWR VPWR _2761_/X sky130_fd_sc_hd__mux2_1
XFILLER_8_562 VGND VGND VPWR VPWR sky130_fd_sc_hd__decap_3
X_5480_ _6024_/CLK _5480_/D VGND VGND VPWR VPWR _5480_/Q sky130_fd_sc_hd__dfxtp_2
X_4500_ _4534_/A1 wire437/X _4502_/B1 _4500_/B2 VGND VGND VPWR VPWR _5556_/D sky130_fd_sc_hd__a22o_2
X_2692_ _5184_/Q _5152_/Q _2878_/S VGND VGND VPWR VPWR _2692_/X sky130_fd_sc_hd__mux2_1
XANTENNA_1 _2496_/Y VGND VGND VPWR VPWR sky130_fd_sc_hd__diode_2
XFILLER_6_41 VGND VGND VPWR VPWR sky130_fd_sc_hd__decap_3
X_4431_ _4533_/A1 _4431_/A2 _4431_/B1 _4431_/B2 VGND VGND VPWR VPWR _5491_/D sky130_fd_sc_hd__a22o_2
XFILLER_6_85 VGND VGND VPWR VPWR sky130_fd_sc_hd__decap_3
XFILLER_113_611 VGND VGND VPWR VPWR sky130_fd_sc_hd__decap_3
X_4362_ _5044_/A1 _4364_/A2 _4364_/B1 _4362_/B2 VGND VGND VPWR VPWR _5428_/D sky130_fd_sc_hd__a22o_2
XFILLER_113_644 VGND VGND VPWR VPWR sky130_fd_sc_hd__decap_3
Xfanout519 wire526/A VGND VGND VPWR VPWR _4076_/A2 sky130_fd_sc_hd__clkdlybuf4s25_1
X_4293_ _4773_/A1 wire475/X wire255/X _4293_/B2 VGND VGND VPWR VPWR _5363_/D sky130_fd_sc_hd__a22o_2
X_3313_ _5563_/Q _5531_/Q _3317_/S VGND VGND VPWR VPWR _3313_/X sky130_fd_sc_hd__mux2_1
XFILLER_86_517 VGND VGND VPWR VPWR sky130_fd_sc_hd__decap_3
XFILLER_86_539 VGND VGND VPWR VPWR sky130_fd_sc_hd__fill_2
X_6032_ _6032_/CLK _6032_/D VGND VGND VPWR VPWR _6032_/Q sky130_fd_sc_hd__dfxtp_2
X_3244_ _3867_/A _3244_/B VGND VGND VPWR VPWR _3244_/X sky130_fd_sc_hd__or2_2
XFILLER_100_327 VGND VGND VPWR VPWR sky130_fd_sc_hd__decap_3
XFILLER_94_550 VGND VGND VPWR VPWR sky130_fd_sc_hd__decap_3
Xfanout1090 _3830_/S VGND VGND VPWR VPWR _3363_/S sky130_fd_sc_hd__clkbuf_2
X_3175_ _3175_/A _3175_/B VGND VGND VPWR VPWR _3175_/X sky130_fd_sc_hd__or2_2
XFILLER_39_499 VGND VGND VPWR VPWR sky130_fd_sc_hd__decap_3
XTAP_TAPCELL_ROW_107_1529 VGND VPWR sky130_fd_sc_hd__tapvpwrvgnd_1
XTAP_TAPCELL_ROW_1_259 VGND VPWR sky130_fd_sc_hd__tapvpwrvgnd_1
XTAP_TAPCELL_ROW_37_689 VGND VPWR sky130_fd_sc_hd__tapvpwrvgnd_1
XFILLER_50_642 VGND VGND VPWR VPWR sky130_fd_sc_hd__fill_2
XFILLER_22_355 VGND VGND VPWR VPWR sky130_fd_sc_hd__decap_3
X_5816_ _6040_/CLK _5816_/D VGND VGND VPWR VPWR _5816_/Q sky130_fd_sc_hd__dfxtp_2
XFILLER_10_528 VGND VGND VPWR VPWR sky130_fd_sc_hd__decap_3
X_5747_ _5813_/CLK _5747_/D VGND VGND VPWR VPWR _5747_/Q sky130_fd_sc_hd__dfxtp_2
X_2959_ _3055_/A1 _2956_/X _2958_/X _3191_/A1 VGND VGND VPWR VPWR _2959_/X sky130_fd_sc_hd__a22o_2
XFILLER_108_438 VGND VGND VPWR VPWR sky130_fd_sc_hd__decap_3
X_5678_ _5934_/CLK _5678_/D VGND VGND VPWR VPWR _5678_/Q sky130_fd_sc_hd__dfxtp_2
X_4629_ _4766_/A1 _4634_/A2 _4634_/B1 _4629_/B2 VGND VGND VPWR VPWR _5676_/D sky130_fd_sc_hd__a22o_2
XFILLER_104_600 VGND VGND VPWR VPWR sky130_fd_sc_hd__decap_3
XFILLER_1_204 VGND VGND VPWR VPWR sky130_fd_sc_hd__decap_3
XFILLER_104_666 VGND VGND VPWR VPWR sky130_fd_sc_hd__decap_3
XFILLER_89_355 VGND VGND VPWR VPWR sky130_fd_sc_hd__fill_2
XTAP_TAPCELL_ROW_9_359 VGND VPWR sky130_fd_sc_hd__tapvpwrvgnd_1
XFILLER_106_53 VGND VGND VPWR VPWR sky130_fd_sc_hd__decap_3
Xhold1240 _5754_/Q VGND VGND VPWR VPWR _4714_/B2 sky130_fd_sc_hd__dlygate4sd3_1
Xhold1251 _5987_/Q VGND VGND VPWR VPWR _4959_/B2 sky130_fd_sc_hd__dlygate4sd3_1
XFILLER_17_116 VGND VGND VPWR VPWR sky130_fd_sc_hd__fill_2
XFILLER_85_594 VGND VGND VPWR VPWR sky130_fd_sc_hd__fill_1
XTAP_TAPCELL_ROW_56_921 VGND VPWR sky130_fd_sc_hd__tapvpwrvgnd_1
Xhold1262 _5134_/Q VGND VGND VPWR VPWR _4046_/B2 sky130_fd_sc_hd__dlygate4sd3_1
Xhold1273 _5645_/Q VGND VGND VPWR VPWR _4596_/B2 sky130_fd_sc_hd__dlygate4sd3_1
Xhold1284 _5581_/Q VGND VGND VPWR VPWR _4527_/B2 sky130_fd_sc_hd__dlygate4sd3_1
Xhold1295 _5676_/Q VGND VGND VPWR VPWR _4629_/B2 sky130_fd_sc_hd__dlygate4sd3_1
XFILLER_26_672 VGND VGND VPWR VPWR sky130_fd_sc_hd__decap_3
XFILLER_32_108 VGND VGND VPWR VPWR sky130_fd_sc_hd__fill_1
XFILLER_13_311 VGND VGND VPWR VPWR sky130_fd_sc_hd__fill_1
XFILLER_41_620 VGND VGND VPWR VPWR sky130_fd_sc_hd__decap_3
XFILLER_41_686 VGND VGND VPWR VPWR sky130_fd_sc_hd__fill_2
XFILLER_9_337 VGND VGND VPWR VPWR sky130_fd_sc_hd__decap_3
XTAP_TAPCELL_ROW_97_1411 VGND VPWR sky130_fd_sc_hd__tapvpwrvgnd_1
XFILLER_5_543 VGND VGND VPWR VPWR sky130_fd_sc_hd__decap_3
XFILLER_99_108 VGND VGND VPWR VPWR sky130_fd_sc_hd__decap_3
Xoutput60 _2962_/X VGND VGND VPWR VPWR rd1[19] sky130_fd_sc_hd__clkbuf_2
Xoutput93 _3287_/X VGND VGND VPWR VPWR rd2[1] sky130_fd_sc_hd__clkbuf_2
Xoutput82 _3264_/X VGND VGND VPWR VPWR rd2[0] sky130_fd_sc_hd__clkbuf_2
Xoutput71 _3186_/X VGND VGND VPWR VPWR rd1[29] sky130_fd_sc_hd__dlymetal6s2s_1
XFILLER_0_281 VGND VGND VPWR VPWR sky130_fd_sc_hd__fill_1
XFILLER_110_669 VGND VGND VPWR VPWR sky130_fd_sc_hd__decap_3
XFILLER_63_277 VGND VGND VPWR VPWR sky130_fd_sc_hd__decap_3
X_4980_ _4980_/A _5014_/A VGND VGND VPWR VPWR _4980_/Y sky130_fd_sc_hd__nor2_2
XFILLER_16_171 VGND VGND VPWR VPWR sky130_fd_sc_hd__decap_3
XTAP_TAPCELL_ROW_34_659 VGND VPWR sky130_fd_sc_hd__tapvpwrvgnd_1
X_3931_ _6071_/Q _5975_/Q _3936_/S VGND VGND VPWR VPWR _3931_/X sky130_fd_sc_hd__mux2_1
XFILLER_31_141 VGND VGND VPWR VPWR sky130_fd_sc_hd__decap_3
X_3862_ _5428_/Q _5076_/Q _3863_/S VGND VGND VPWR VPWR _3862_/X sky130_fd_sc_hd__mux2_1
XFILLER_31_185 VGND VGND VPWR VPWR sky130_fd_sc_hd__fill_1
X_5601_ _6049_/CLK _5601_/D VGND VGND VPWR VPWR _5601_/Q sky130_fd_sc_hd__dfxtp_2
X_2813_ wire685/X _2811_/X _2812_/X wire651/X VGND VGND VPWR VPWR _2813_/X sky130_fd_sc_hd__o22a_2
X_5532_ _5683_/CLK _5532_/D VGND VGND VPWR VPWR _5532_/Q sky130_fd_sc_hd__dfxtp_2
X_3793_ _3261_/A _3776_/X _3781_/X _3792_/X _3916_/B1 VGND VGND VPWR VPWR _3793_/X
+ sky130_fd_sc_hd__a32o_2
X_2744_ _3218_/B2 _2742_/X _2743_/X _3218_/A1 VGND VGND VPWR VPWR _2744_/X sky130_fd_sc_hd__o22a_2
X_5463_ _6071_/CLK _5463_/D VGND VGND VPWR VPWR _5463_/Q sky130_fd_sc_hd__dfxtp_2
X_2675_ _2730_/A _2671_/X _2674_/X wire559/X VGND VGND VPWR VPWR _2675_/X sky130_fd_sc_hd__o211a_2
X_5394_ _5502_/CLK _5394_/D VGND VGND VPWR VPWR _5394_/Q sky130_fd_sc_hd__dfxtp_2
X_4414_ _4822_/A1 _4425_/A2 _4425_/B1 _4414_/B2 VGND VGND VPWR VPWR _5474_/D sky130_fd_sc_hd__a22o_2
XFILLER_99_631 VGND VGND VPWR VPWR sky130_fd_sc_hd__decap_3
Xfanout305 fanout307/X VGND VGND VPWR VPWR wire306/A sky130_fd_sc_hd__clkdlybuf4s25_1
X_4345_ _5027_/A1 wire462/X wire242/X _4345_/B2 VGND VGND VPWR VPWR _5411_/D sky130_fd_sc_hd__a22o_2
XFILLER_59_517 VGND VGND VPWR VPWR sky130_fd_sc_hd__decap_3
XFILLER_98_141 VGND VGND VPWR VPWR sky130_fd_sc_hd__fill_2
XTAP_TAPCELL_ROW_6_318 VGND VPWR sky130_fd_sc_hd__tapvpwrvgnd_1
Xfanout338 _5012_/A2 VGND VGND VPWR VPWR _5010_/A2 sky130_fd_sc_hd__clkdlybuf4s25_1
Xfanout349 _4912_/Y VGND VGND VPWR VPWR _4936_/A2 sky130_fd_sc_hd__clkdlybuf4s25_1
X_4276_ _4822_/A1 _4292_/A2 _4295_/B1 _4276_/B2 VGND VGND VPWR VPWR _5346_/D sky130_fd_sc_hd__a22o_2
XFILLER_67_561 VGND VGND VPWR VPWR sky130_fd_sc_hd__fill_1
X_6015_ _6026_/CLK _6015_/D VGND VGND VPWR VPWR _6015_/Q sky130_fd_sc_hd__dfxtp_2
X_3227_ _5271_/Q _5239_/Q _3227_/S VGND VGND VPWR VPWR _3227_/X sky130_fd_sc_hd__mux2_1
X_3158_ _5524_/Q _5492_/Q _3159_/S VGND VGND VPWR VPWR _3158_/X sky130_fd_sc_hd__mux2_1
XTAP_TAPCELL_ROW_68_1067 VGND VPWR sky130_fd_sc_hd__tapvpwrvgnd_1
X_3089_ _3094_/B2 _3087_/X _3088_/X _3094_/A1 VGND VGND VPWR VPWR _3089_/X sky130_fd_sc_hd__o22a_2
XFILLER_23_620 VGND VGND VPWR VPWR sky130_fd_sc_hd__fill_2
XTAP_TAPCELL_ROW_81_1223 VGND VPWR sky130_fd_sc_hd__tapvpwrvgnd_1
XFILLER_22_141 VGND VGND VPWR VPWR sky130_fd_sc_hd__decap_3
XFILLER_22_174 VGND VGND VPWR VPWR sky130_fd_sc_hd__decap_3
XFILLER_10_358 VGND VGND VPWR VPWR sky130_fd_sc_hd__decap_3
XFILLER_6_307 VGND VGND VPWR VPWR sky130_fd_sc_hd__fill_1
XFILLER_108_268 VGND VGND VPWR VPWR sky130_fd_sc_hd__decap_3
XTAP_TAPCELL_ROW_79_1196 VGND VPWR sky130_fd_sc_hd__tapvpwrvgnd_1
XFILLER_89_130 VGND VGND VPWR VPWR sky130_fd_sc_hd__fill_2
XTAP_TAPCELL_ROW_92_1352 VGND VPWR sky130_fd_sc_hd__tapvpwrvgnd_1
Xfanout850 _2981_/S VGND VGND VPWR VPWR _3217_/S sky130_fd_sc_hd__clkbuf_2
Xfanout894 _4777_/A1 VGND VGND VPWR VPWR _5013_/A1 sky130_fd_sc_hd__clkdlybuf4s25_1
Xfanout883 input44/X VGND VGND VPWR VPWR _4987_/A1 sky130_fd_sc_hd__clkdlybuf4s25_1
Xfanout872 input47/X VGND VGND VPWR VPWR _4990_/A1 sky130_fd_sc_hd__clkdlybuf4s25_1
XFILLER_58_572 VGND VGND VPWR VPWR sky130_fd_sc_hd__decap_3
XFILLER_73_553 VGND VGND VPWR VPWR sky130_fd_sc_hd__decap_3
XFILLER_14_631 VGND VGND VPWR VPWR sky130_fd_sc_hd__decap_3
XFILLER_60_236 VGND VGND VPWR VPWR sky130_fd_sc_hd__decap_3
XFILLER_14_675 VGND VGND VPWR VPWR sky130_fd_sc_hd__decap_3
XTAP_TAPCELL_ROW_31_618 VGND VPWR sky130_fd_sc_hd__tapvpwrvgnd_1
XFILLER_9_189 VGND VGND VPWR VPWR sky130_fd_sc_hd__decap_3
XFILLER_5_340 VGND VGND VPWR VPWR sky130_fd_sc_hd__fill_1
XTAP_TAPCELL_ROW_11_386 VGND VPWR sky130_fd_sc_hd__tapvpwrvgnd_1
XFILLER_5_351 VGND VGND VPWR VPWR sky130_fd_sc_hd__decap_3
X_4130_ _4983_/A1 _4158_/A2 _4146_/B1 _4130_/B2 VGND VGND VPWR VPWR _5209_/D sky130_fd_sc_hd__a22o_2
XFILLER_3_42 VGND VGND VPWR VPWR sky130_fd_sc_hd__decap_3
XFILLER_95_111 VGND VGND VPWR VPWR sky130_fd_sc_hd__fill_1
XFILLER_96_634 VGND VGND VPWR VPWR sky130_fd_sc_hd__decap_3
XFILLER_96_645 VGND VGND VPWR VPWR sky130_fd_sc_hd__fill_1
XFILLER_1_590 VGND VGND VPWR VPWR sky130_fd_sc_hd__decap_3
X_4061_ _4983_/A1 _4089_/A2 _4077_/B1 _4061_/B2 VGND VGND VPWR VPWR _5145_/D sky130_fd_sc_hd__a22o_2
XFILLER_110_477 VGND VGND VPWR VPWR sky130_fd_sc_hd__fill_1
XFILLER_36_200 VGND VGND VPWR VPWR sky130_fd_sc_hd__decap_3
XTAP_TAPCELL_ROW_39_718 VGND VPWR sky130_fd_sc_hd__tapvpwrvgnd_1
X_3012_ _3028_/A1 _3009_/X _3011_/X VGND VGND VPWR VPWR _3012_/X sky130_fd_sc_hd__a21o_2
XFILLER_36_222 VGND VGND VPWR VPWR sky130_fd_sc_hd__decap_3
XFILLER_24_406 VGND VGND VPWR VPWR sky130_fd_sc_hd__decap_3
XFILLER_24_417 VGND VGND VPWR VPWR sky130_fd_sc_hd__decap_3
XFILLER_17_480 VGND VGND VPWR VPWR sky130_fd_sc_hd__decap_3
XFILLER_36_288 VGND VGND VPWR VPWR sky130_fd_sc_hd__fill_2
XFILLER_91_383 VGND VGND VPWR VPWR sky130_fd_sc_hd__decap_3
XTAP_TAPCELL_ROW_19_475 VGND VPWR sky130_fd_sc_hd__tapvpwrvgnd_1
X_4963_ _4997_/A1 _4979_/A2 _4979_/B1 _4963_/B2 VGND VGND VPWR VPWR _5991_/D sky130_fd_sc_hd__a22o_2
X_3914_ _3914_/A _3914_/B VGND VGND VPWR VPWR _3914_/X sky130_fd_sc_hd__or2_2
XFILLER_32_472 VGND VGND VPWR VPWR sky130_fd_sc_hd__decap_3
X_4894_ _4894_/A1 _4909_/A2 _4909_/B1 _4894_/B2 VGND VGND VPWR VPWR _5926_/D sky130_fd_sc_hd__a22o_2
XFILLER_20_645 VGND VGND VPWR VPWR sky130_fd_sc_hd__decap_3
XFILLER_22_29 VGND VGND VPWR VPWR sky130_fd_sc_hd__fill_2
X_3845_ _3889_/A _3845_/B VGND VGND VPWR VPWR _3845_/X sky130_fd_sc_hd__or2_2
X_3776_ _3784_/A _3773_/X _3775_/X _3261_/B VGND VGND VPWR VPWR _3776_/X sky130_fd_sc_hd__a211o_2
X_5515_ _5547_/CLK _5515_/D VGND VGND VPWR VPWR _5515_/Q sky130_fd_sc_hd__dfxtp_2
X_2727_ _2727_/A1 _2725_/X _2726_/X _2972_/A1 VGND VGND VPWR VPWR _2727_/X sky130_fd_sc_hd__o22a_2
XFILLER_105_205 VGND VGND VPWR VPWR sky130_fd_sc_hd__fill_2
XTAP_TAPCELL_ROW_115_1628 VGND VPWR sky130_fd_sc_hd__tapvpwrvgnd_1
XTAP_TAPCELL_ROW_115_1639 VGND VPWR sky130_fd_sc_hd__tapvpwrvgnd_1
X_5446_ _6043_/CLK _5446_/D VGND VGND VPWR VPWR _5446_/Q sky130_fd_sc_hd__dfxtp_2
X_2658_ wire559/X _2649_/X _2652_/X _2657_/X VGND VGND VPWR VPWR _2658_/X sky130_fd_sc_hd__a31o_2
XFILLER_87_612 VGND VGND VPWR VPWR sky130_fd_sc_hd__decap_3
X_5377_ _5578_/CLK _5377_/D VGND VGND VPWR VPWR _5377_/Q sky130_fd_sc_hd__dfxtp_2
X_2589_ _5563_/Q _5531_/Q _2589_/S VGND VGND VPWR VPWR _2589_/X sky130_fd_sc_hd__mux2_1
XFILLER_86_111 VGND VGND VPWR VPWR sky130_fd_sc_hd__decap_3
XFILLER_99_494 VGND VGND VPWR VPWR sky130_fd_sc_hd__decap_3
Xfanout135 _4913_/Y VGND VGND VPWR VPWR wire136/A sky130_fd_sc_hd__clkdlybuf4s25_1
X_4328_ _5010_/A1 _4328_/A2 _4328_/B1 _4328_/B2 VGND VGND VPWR VPWR _5396_/D sky130_fd_sc_hd__a22o_2
XFILLER_101_444 VGND VGND VPWR VPWR sky130_fd_sc_hd__decap_3
Xfanout168 _4711_/Y VGND VGND VPWR VPWR _4727_/B1 sky130_fd_sc_hd__clkdlybuf4s25_1
Xfanout157 fanout157/A VGND VGND VPWR VPWR _4843_/B1 sky130_fd_sc_hd__clkdlybuf4s25_1
X_4259_ _4773_/A1 wire482/X wire262/X _4259_/B2 VGND VGND VPWR VPWR _5331_/D sky130_fd_sc_hd__a22o_2
XFILLER_42_225 VGND VGND VPWR VPWR sky130_fd_sc_hd__decap_3
XFILLER_63_25 VGND VGND VPWR VPWR sky130_fd_sc_hd__fill_2
XFILLER_70_523 VGND VGND VPWR VPWR sky130_fd_sc_hd__fill_1
XFILLER_42_247 VGND VGND VPWR VPWR sky130_fd_sc_hd__decap_3
XFILLER_23_472 VGND VGND VPWR VPWR sky130_fd_sc_hd__decap_3
XFILLER_70_589 VGND VGND VPWR VPWR sky130_fd_sc_hd__decap_3
XFILLER_11_634 VGND VGND VPWR VPWR sky130_fd_sc_hd__decap_3
XFILLER_7_605 VGND VGND VPWR VPWR sky130_fd_sc_hd__decap_3
XFILLER_109_522 VGND VGND VPWR VPWR sky130_fd_sc_hd__decap_3
XFILLER_10_166 VGND VGND VPWR VPWR sky130_fd_sc_hd__decap_3
XFILLER_109_566 VGND VGND VPWR VPWR sky130_fd_sc_hd__decap_3
XFILLER_10_188 VGND VGND VPWR VPWR sky130_fd_sc_hd__decap_3
XFILLER_12_62 VGND VGND VPWR VPWR sky130_fd_sc_hd__decap_3
XFILLER_2_354 VGND VGND VPWR VPWR sky130_fd_sc_hd__fill_2
XFILLER_88_88 VGND VGND VPWR VPWR sky130_fd_sc_hd__decap_3
XFILLER_78_634 VGND VGND VPWR VPWR sky130_fd_sc_hd__decap_3
XFILLER_78_645 VGND VGND VPWR VPWR sky130_fd_sc_hd__decap_3
XFILLER_77_155 VGND VGND VPWR VPWR sky130_fd_sc_hd__decap_3
XFILLER_46_542 VGND VGND VPWR VPWR sky130_fd_sc_hd__fill_1
XFILLER_61_501 VGND VGND VPWR VPWR sky130_fd_sc_hd__decap_3
XFILLER_73_361 VGND VGND VPWR VPWR sky130_fd_sc_hd__fill_1
XFILLER_33_225 VGND VGND VPWR VPWR sky130_fd_sc_hd__fill_2
XFILLER_61_556 VGND VGND VPWR VPWR sky130_fd_sc_hd__decap_3
XTAP_TAPCELL_ROW_16_445 VGND VPWR sky130_fd_sc_hd__tapvpwrvgnd_1
XTAP_TAPCELL_ROW_44_776 VGND VPWR sky130_fd_sc_hd__tapvpwrvgnd_1
X_3630_ _5417_/Q _5065_/Q _3631_/S VGND VGND VPWR VPWR _3630_/X sky130_fd_sc_hd__mux2_1
X_3561_ _5126_/Q _5094_/Q _6022_/Q _5990_/Q _3712_/S _3717_/S1 VGND VGND VPWR VPWR
+ _3562_/B sky130_fd_sc_hd__mux4_2
XFILLER_6_660 VGND VGND VPWR VPWR sky130_fd_sc_hd__decap_3
X_5300_ _5400_/CLK _5300_/D VGND VGND VPWR VPWR _5300_/Q sky130_fd_sc_hd__dfxtp_2
X_2512_ _3058_/A _2508_/X _2511_/X _3073_/A1 VGND VGND VPWR VPWR _2512_/X sky130_fd_sc_hd__o211a_2
X_3492_ _5571_/Q _5539_/Q _3501_/S VGND VGND VPWR VPWR _3492_/X sky130_fd_sc_hd__mux2_1
X_5231_ _5999_/CLK _5231_/D VGND VGND VPWR VPWR _5231_/Q sky130_fd_sc_hd__dfxtp_2
XFILLER_69_634 VGND VGND VPWR VPWR sky130_fd_sc_hd__decap_3
X_5162_ _5258_/CLK _5162_/D VGND VGND VPWR VPWR _5162_/Q sky130_fd_sc_hd__dfxtp_2
XTAP_TAPCELL_ROW_110_1569 VGND VPWR sky130_fd_sc_hd__tapvpwrvgnd_1
Xhold1806 _5058_/Q VGND VGND VPWR VPWR _3962_/B2 sky130_fd_sc_hd__dlygate4sd3_1
Xhold1817 _5880_/Q VGND VGND VPWR VPWR _4846_/B2 sky130_fd_sc_hd__dlygate4sd3_1
X_5093_ _6021_/CLK _5093_/D VGND VGND VPWR VPWR _5093_/Q sky130_fd_sc_hd__dfxtp_2
X_4113_ _4695_/A1 wire516/X wire298/X _4113_/B2 VGND VGND VPWR VPWR _5194_/D sky130_fd_sc_hd__a22o_2
XFILLER_84_615 VGND VGND VPWR VPWR sky130_fd_sc_hd__decap_3
XFILLER_84_637 VGND VGND VPWR VPWR sky130_fd_sc_hd__decap_3
Xhold1828 _5807_/Q VGND VGND VPWR VPWR _4769_/B2 sky130_fd_sc_hd__dlygate4sd3_1
Xhold1839 _5793_/Q VGND VGND VPWR VPWR _4755_/B2 sky130_fd_sc_hd__dlygate4sd3_1
XFILLER_110_296 VGND VGND VPWR VPWR sky130_fd_sc_hd__decap_3
XFILLER_17_18 VGND VGND VPWR VPWR sky130_fd_sc_hd__decap_3
XFILLER_37_520 VGND VGND VPWR VPWR sky130_fd_sc_hd__decap_3
X_4044_ _4526_/A1 wire533/X _4055_/B1 _4044_/B2 VGND VGND VPWR VPWR _5132_/D sky130_fd_sc_hd__a22o_2
XFILLER_83_169 VGND VGND VPWR VPWR sky130_fd_sc_hd__decap_3
XFILLER_37_597 VGND VGND VPWR VPWR sky130_fd_sc_hd__fill_2
XTAP_TAPCELL_ROW_65_1026 VGND VPWR sky130_fd_sc_hd__tapvpwrvgnd_1
X_5995_ _6027_/CLK _5995_/D VGND VGND VPWR VPWR _5995_/Q sky130_fd_sc_hd__dfxtp_2
XFILLER_33_28 VGND VGND VPWR VPWR sky130_fd_sc_hd__decap_3
X_4946_ _4980_/A _4946_/B VGND VGND VPWR VPWR _4946_/Y sky130_fd_sc_hd__nor2_2
X_4877_ _5047_/A1 wire367/X wire151/X _4877_/B2 VGND VGND VPWR VPWR _5911_/D sky130_fd_sc_hd__a22o_2
X_3828_ _5714_/Q _5682_/Q _5650_/Q _5618_/Q _3363_/S _3828_/S1 VGND VGND VPWR VPWR
+ _3828_/X sky130_fd_sc_hd__mux4_2
XFILLER_4_608 VGND VGND VPWR VPWR sky130_fd_sc_hd__decap_3
X_3759_ _5135_/Q _5103_/Q _6031_/Q _5999_/Q _3873_/S _3917_/S1 VGND VGND VPWR VPWR
+ _3760_/B sky130_fd_sc_hd__mux4_2
XTAP_TAPCELL_ROW_76_1166 VGND VPWR sky130_fd_sc_hd__tapvpwrvgnd_1
X_5429_ _6037_/CLK _5429_/D VGND VGND VPWR VPWR _5429_/Q sky130_fd_sc_hd__dfxtp_2
XFILLER_101_241 VGND VGND VPWR VPWR sky130_fd_sc_hd__fill_1
Xwire1003 wire1003/A VGND VGND VPWR VPWR wire1003/X sky130_fd_sc_hd__clkbuf_4
XFILLER_114_53 VGND VGND VPWR VPWR sky130_fd_sc_hd__decap_3
XFILLER_28_542 VGND VGND VPWR VPWR sky130_fd_sc_hd__decap_3
XFILLER_47_339 VGND VGND VPWR VPWR sky130_fd_sc_hd__fill_1
XFILLER_114_97 VGND VGND VPWR VPWR sky130_fd_sc_hd__decap_3
XFILLER_62_309 VGND VGND VPWR VPWR sky130_fd_sc_hd__fill_1
XFILLER_15_225 VGND VGND VPWR VPWR sky130_fd_sc_hd__decap_3
XFILLER_28_586 VGND VGND VPWR VPWR sky130_fd_sc_hd__fill_2
XFILLER_83_681 VGND VGND VPWR VPWR sky130_fd_sc_hd__decap_3
XTAP_TAPCELL_ROW_87_1295 VGND VPWR sky130_fd_sc_hd__tapvpwrvgnd_1
XFILLER_43_567 VGND VGND VPWR VPWR sky130_fd_sc_hd__fill_1
XFILLER_90_12 VGND VGND VPWR VPWR sky130_fd_sc_hd__decap_3
XTAP_TAPCELL_ROW_13_404 VGND VPWR sky130_fd_sc_hd__tapvpwrvgnd_1
XTAP_TAPCELL_ROW_41_746 VGND VPWR sky130_fd_sc_hd__tapvpwrvgnd_1
XFILLER_7_402 VGND VGND VPWR VPWR sky130_fd_sc_hd__decap_3
Xwire322 wire322/A VGND VGND VPWR VPWR wire322/X sky130_fd_sc_hd__clkbuf_4
XFILLER_11_497 VGND VGND VPWR VPWR sky130_fd_sc_hd__decap_3
Xwire355 wire355/A VGND VGND VPWR VPWR wire355/X sky130_fd_sc_hd__clkbuf_4
XFILLER_109_374 VGND VGND VPWR VPWR sky130_fd_sc_hd__decap_3
XFILLER_3_641 VGND VGND VPWR VPWR sky130_fd_sc_hd__decap_3
XFILLER_97_217 VGND VGND VPWR VPWR sky130_fd_sc_hd__decap_3
XFILLER_97_228 VGND VGND VPWR VPWR sky130_fd_sc_hd__decap_3
Xload_slew316 _4005_/B1 VGND VGND VPWR VPWR _4018_/B1 sky130_fd_sc_hd__buf_4
XFILLER_66_604 VGND VGND VPWR VPWR sky130_fd_sc_hd__decap_3
XFILLER_78_497 VGND VGND VPWR VPWR sky130_fd_sc_hd__fill_1
XFILLER_19_542 VGND VGND VPWR VPWR sky130_fd_sc_hd__fill_2
XFILLER_48_91 VGND VGND VPWR VPWR sky130_fd_sc_hd__decap_3
XTAP_TAPCELL_ROW_49_835 VGND VPWR sky130_fd_sc_hd__tapvpwrvgnd_1
XFILLER_0_21 VGND VGND VPWR VPWR sky130_fd_sc_hd__decap_3
XFILLER_0_32 VGND VGND VPWR VPWR sky130_fd_sc_hd__decap_3
XFILLER_19_575 VGND VGND VPWR VPWR sky130_fd_sc_hd__fill_1
XFILLER_80_106 VGND VGND VPWR VPWR sky130_fd_sc_hd__decap_3
XFILLER_0_76 VGND VGND VPWR VPWR sky130_fd_sc_hd__decap_3
XPHY_EDGE_ROW_14_Left_130 VGND VGND VPWR VPWR sky130_fd_sc_hd__decap_3
XTAP_TAPCELL_ROW_29_592 VGND VPWR sky130_fd_sc_hd__tapvpwrvgnd_1
X_4800_ _3948_/B _4800_/B VGND VGND VPWR VPWR _5838_/D sky130_fd_sc_hd__and2b_2
XFILLER_34_589 VGND VGND VPWR VPWR sky130_fd_sc_hd__decap_3
XFILLER_9_30 VGND VGND VPWR VPWR sky130_fd_sc_hd__decap_3
X_5780_ _6068_/CLK _5780_/D VGND VGND VPWR VPWR _5780_/Q sky130_fd_sc_hd__dfxtp_2
X_2992_ _5805_/Q _5741_/Q _2993_/S VGND VGND VPWR VPWR _2992_/X sky130_fd_sc_hd__mux2_1
XFILLER_14_280 VGND VGND VPWR VPWR sky130_fd_sc_hd__decap_3
X_4731_ _4899_/A1 _4736_/A2 _4740_/B1 _4731_/B2 VGND VGND VPWR VPWR _5771_/D sky130_fd_sc_hd__a22o_2
X_4662_ _4899_/A1 _4673_/A2 _4673_/B1 _4662_/B2 VGND VGND VPWR VPWR _5707_/D sky130_fd_sc_hd__a22o_2
X_3613_ _3613_/A _3613_/B _3261_/A VGND VGND VPWR VPWR _3614_/C sky130_fd_sc_hd__or3b_2
X_4593_ _5000_/A1 _4595_/A2 _4600_/B1 _4593_/B2 VGND VGND VPWR VPWR _5642_/D sky130_fd_sc_hd__a22o_2
X_3544_ _5925_/Q _5893_/Q _5861_/Q _5765_/Q _3913_/S _3917_/S1 VGND VGND VPWR VPWR
+ _3544_/X sky130_fd_sc_hd__mux4_2
X_3475_ _5250_/Q _5218_/Q _3475_/S VGND VGND VPWR VPWR _3475_/X sky130_fd_sc_hd__mux2_1
X_5214_ _5986_/CLK _5214_/D VGND VGND VPWR VPWR _5214_/Q sky130_fd_sc_hd__dfxtp_2
XFILLER_69_431 VGND VGND VPWR VPWR sky130_fd_sc_hd__decap_3
XFILLER_111_572 VGND VGND VPWR VPWR sky130_fd_sc_hd__decap_3
XFILLER_57_626 VGND VGND VPWR VPWR sky130_fd_sc_hd__decap_3
XTAP_TAPCELL_ROW_71_1096 VGND VPWR sky130_fd_sc_hd__tapvpwrvgnd_1
Xhold1603 _5523_/Q VGND VGND VPWR VPWR _4465_/B2 sky130_fd_sc_hd__dlygate4sd3_1
Xhold1614 _5885_/Q VGND VGND VPWR VPWR _4851_/B2 sky130_fd_sc_hd__dlygate4sd3_1
Xhold1625 _5536_/Q VGND VGND VPWR VPWR _4480_/B2 sky130_fd_sc_hd__dlygate4sd3_1
Xload_slew861 _2925_/S VGND VGND VPWR VPWR _2924_/S sky130_fd_sc_hd__clkbuf_4
X_5145_ _6035_/CLK _5145_/D VGND VGND VPWR VPWR _5145_/Q sky130_fd_sc_hd__dfxtp_2
Xhold1636 _5717_/Q VGND VGND VPWR VPWR _4672_/B2 sky130_fd_sc_hd__dlygate4sd3_1
Xhold1647 _5716_/Q VGND VGND VPWR VPWR _4671_/B2 sky130_fd_sc_hd__dlygate4sd3_1
Xhold1658 _5673_/Q VGND VGND VPWR VPWR _4626_/B2 sky130_fd_sc_hd__dlygate4sd3_1
Xhold1669 _5081_/Q VGND VGND VPWR VPWR _3990_/B2 sky130_fd_sc_hd__dlygate4sd3_1
X_5076_ _5812_/CLK _5076_/D VGND VGND VPWR VPWR _5076_/Q sky130_fd_sc_hd__dfxtp_2
XFILLER_25_501 VGND VGND VPWR VPWR sky130_fd_sc_hd__decap_3
XFILLER_72_607 VGND VGND VPWR VPWR sky130_fd_sc_hd__decap_3
XFILLER_72_629 VGND VGND VPWR VPWR sky130_fd_sc_hd__decap_3
XFILLER_84_489 VGND VGND VPWR VPWR sky130_fd_sc_hd__decap_3
X_4027_ _5019_/A1 _4053_/A2 _4053_/B1 _4027_/B2 VGND VGND VPWR VPWR _5115_/D sky130_fd_sc_hd__a22o_2
XFILLER_64_180 VGND VGND VPWR VPWR sky130_fd_sc_hd__decap_3
XFILLER_80_640 VGND VGND VPWR VPWR sky130_fd_sc_hd__decap_3
XFILLER_80_651 VGND VGND VPWR VPWR sky130_fd_sc_hd__decap_3
X_5978_ _6010_/CLK _5978_/D VGND VGND VPWR VPWR _5978_/Q sky130_fd_sc_hd__dfxtp_2
X_4929_ _5031_/A1 wire355/X _4945_/B1 _4929_/B2 VGND VGND VPWR VPWR _5959_/D sky130_fd_sc_hd__a22o_2
XFILLER_20_250 VGND VGND VPWR VPWR sky130_fd_sc_hd__fill_2
XFILLER_60_59 VGND VGND VPWR VPWR sky130_fd_sc_hd__fill_1
XFILLER_109_42 VGND VGND VPWR VPWR sky130_fd_sc_hd__decap_3
XFILLER_109_75 VGND VGND VPWR VPWR sky130_fd_sc_hd__decap_3
XFILLER_69_57 VGND VGND VPWR VPWR sky130_fd_sc_hd__decap_3
XFILLER_0_666 VGND VGND VPWR VPWR sky130_fd_sc_hd__decap_3
XFILLER_102_561 VGND VGND VPWR VPWR sky130_fd_sc_hd__decap_3
XFILLER_48_604 VGND VGND VPWR VPWR sky130_fd_sc_hd__decap_3
XFILLER_48_626 VGND VGND VPWR VPWR sky130_fd_sc_hd__decap_3
XFILLER_75_401 VGND VGND VPWR VPWR sky130_fd_sc_hd__decap_3
XFILLER_94_209 VGND VGND VPWR VPWR sky130_fd_sc_hd__decap_3
XTAP_TAPCELL_ROW_89_1313 VGND VPWR sky130_fd_sc_hd__tapvpwrvgnd_1
XFILLER_48_648 VGND VGND VPWR VPWR sky130_fd_sc_hd__fill_1
XFILLER_87_294 VGND VGND VPWR VPWR sky130_fd_sc_hd__decap_3
XFILLER_47_169 VGND VGND VPWR VPWR sky130_fd_sc_hd__decap_3
XTAP_TAPCELL_ROW_46_805 VGND VPWR sky130_fd_sc_hd__tapvpwrvgnd_1
XFILLER_16_589 VGND VGND VPWR VPWR sky130_fd_sc_hd__decap_3
XFILLER_31_526 VGND VGND VPWR VPWR sky130_fd_sc_hd__decap_3
XTAP_TAPCELL_ROW_26_562 VGND VPWR sky130_fd_sc_hd__tapvpwrvgnd_1
XFILLER_34_71 VGND VGND VPWR VPWR sky130_fd_sc_hd__decap_3
XFILLER_43_397 VGND VGND VPWR VPWR sky130_fd_sc_hd__fill_1
XFILLER_70_194 VGND VGND VPWR VPWR sky130_fd_sc_hd__fill_2
XTAP_TAPCELL_ROW_54_893 VGND VPWR sky130_fd_sc_hd__tapvpwrvgnd_1
XFILLER_50_70 VGND VGND VPWR VPWR sky130_fd_sc_hd__decap_3
XFILLER_50_81 VGND VGND VPWR VPWR sky130_fd_sc_hd__decap_3
Xload_slew124 _5012_/B1 VGND VGND VPWR VPWR _5010_/B1 sky130_fd_sc_hd__buf_4
X_3260_ _5176_/Q _5144_/Q _3508_/S VGND VGND VPWR VPWR _3260_/X sky130_fd_sc_hd__mux2_1
XFILLER_78_261 VGND VGND VPWR VPWR sky130_fd_sc_hd__decap_3
XFILLER_78_272 VGND VGND VPWR VPWR sky130_fd_sc_hd__decap_3
X_3191_ _3191_/A1 _3188_/X _3190_/X VGND VGND VPWR VPWR _3191_/X sky130_fd_sc_hd__a21o_2
XFILLER_15_3 VGND VGND VPWR VPWR sky130_fd_sc_hd__decap_3
XFILLER_38_136 VGND VGND VPWR VPWR sky130_fd_sc_hd__decap_3
XFILLER_26_309 VGND VGND VPWR VPWR sky130_fd_sc_hd__decap_3
XFILLER_93_253 VGND VGND VPWR VPWR sky130_fd_sc_hd__fill_1
XFILLER_19_361 VGND VGND VPWR VPWR sky130_fd_sc_hd__decap_3
XFILLER_81_437 VGND VGND VPWR VPWR sky130_fd_sc_hd__fill_1
XTAP_TAPCELL_ROW_109_1560 VGND VPWR sky130_fd_sc_hd__tapvpwrvgnd_1
X_5901_ _6043_/CLK _5901_/D VGND VGND VPWR VPWR _5901_/Q sky130_fd_sc_hd__dfxtp_2
X_5832_ _5832_/CLK _5832_/D VGND VGND VPWR VPWR _5832_/Q sky130_fd_sc_hd__dfxtp_2
X_5763_ _6051_/CLK _5763_/D VGND VGND VPWR VPWR _5763_/Q sky130_fd_sc_hd__dfxtp_2
X_4714_ _5018_/A1 wire386/X wire166/A _4714_/B2 VGND VGND VPWR VPWR _5754_/D sky130_fd_sc_hd__a22o_2
X_2975_ _5804_/Q _5740_/Q _2975_/S VGND VGND VPWR VPWR _2975_/X sky130_fd_sc_hd__mux2_1
X_5694_ _6013_/CLK _5694_/D VGND VGND VPWR VPWR _5694_/Q sky130_fd_sc_hd__dfxtp_2
XFILLER_30_29 VGND VGND VPWR VPWR sky130_fd_sc_hd__fill_2
X_4645_ _4645_/A1 _4659_/A2 _4659_/B1 _4645_/B2 VGND VGND VPWR VPWR _5690_/D sky130_fd_sc_hd__a22o_2
X_4576_ _4747_/A1 wire414/X wire193/X _4576_/B2 VGND VGND VPWR VPWR _5625_/D sky130_fd_sc_hd__a22o_2
XFILLER_115_141 VGND VGND VPWR VPWR sky130_fd_sc_hd__decap_3
X_3527_ _3922_/B1 _3522_/X _3525_/X _3516_/X VGND VGND VPWR VPWR _3527_/X sky130_fd_sc_hd__a31o_2
XFILLER_103_314 VGND VGND VPWR VPWR sky130_fd_sc_hd__fill_2
XTAP_TAPCELL_ROW_73_1125 VGND VPWR sky130_fd_sc_hd__tapvpwrvgnd_1
XFILLER_39_27 VGND VGND VPWR VPWR sky130_fd_sc_hd__decap_3
Xhold2101 _5829_/Q VGND VGND VPWR VPWR _4791_/B sky130_fd_sc_hd__dlygate4sd3_1
Xhold2112 _5220_/Q VGND VGND VPWR VPWR _4141_/B2 sky130_fd_sc_hd__dlygate4sd3_1
X_3458_ _5921_/Q _5889_/Q _5857_/Q _5761_/Q _3683_/S _3698_/S1 VGND VGND VPWR VPWR
+ _3459_/B sky130_fd_sc_hd__mux4_2
XFILLER_39_49 VGND VGND VPWR VPWR sky130_fd_sc_hd__decap_3
XFILLER_57_401 VGND VGND VPWR VPWR sky130_fd_sc_hd__fill_1
Xhold1400 _5561_/Q VGND VGND VPWR VPWR _4507_/B2 sky130_fd_sc_hd__dlygate4sd3_1
Xhold2123 _5157_/Q VGND VGND VPWR VPWR _4073_/B2 sky130_fd_sc_hd__dlygate4sd3_1
Xhold2134 _5098_/Q VGND VGND VPWR VPWR _4007_/B2 sky130_fd_sc_hd__dlygate4sd3_1
Xhold2145 _5416_/Q VGND VGND VPWR VPWR _4350_/B2 sky130_fd_sc_hd__dlygate4sd3_1
X_3389_ _5694_/Q _5662_/Q _5630_/Q _5598_/Q _3821_/S _3828_/S1 VGND VGND VPWR VPWR
+ _3389_/X sky130_fd_sc_hd__mux4_2
XFILLER_57_445 VGND VGND VPWR VPWR sky130_fd_sc_hd__decap_3
XFILLER_97_592 VGND VGND VPWR VPWR sky130_fd_sc_hd__fill_1
Xhold1411 _5867_/Q VGND VGND VPWR VPWR _4831_/B2 sky130_fd_sc_hd__dlygate4sd3_1
Xhold1422 _5127_/Q VGND VGND VPWR VPWR _4039_/B2 sky130_fd_sc_hd__dlygate4sd3_1
Xhold1433 _5401_/Q VGND VGND VPWR VPWR _4335_/B2 sky130_fd_sc_hd__dlygate4sd3_1
Xhold2156 _5844_/Q VGND VGND VPWR VPWR _4806_/B sky130_fd_sc_hd__dlygate4sd3_1
Xload_slew691 _3205_/B2 VGND VGND VPWR VPWR _3222_/B2 sky130_fd_sc_hd__buf_4
Xload_slew680 _3004_/B2 VGND VGND VPWR VPWR _3105_/B2 sky130_fd_sc_hd__clkbuf_4
X_5128_ _6024_/CLK _5128_/D VGND VGND VPWR VPWR _5128_/Q sky130_fd_sc_hd__dfxtp_2
XFILLER_84_253 VGND VGND VPWR VPWR sky130_fd_sc_hd__decap_3
Xhold1444 _5279_/Q VGND VGND VPWR VPWR _4205_/B2 sky130_fd_sc_hd__dlygate4sd3_1
Xhold1455 _5212_/Q VGND VGND VPWR VPWR _4133_/B2 sky130_fd_sc_hd__dlygate4sd3_1
Xhold1466 _6068_/Q VGND VGND VPWR VPWR _5044_/B2 sky130_fd_sc_hd__dlygate4sd3_1
Xhold1477 _6016_/Q VGND VGND VPWR VPWR _4990_/B2 sky130_fd_sc_hd__dlygate4sd3_1
XFILLER_84_297 VGND VGND VPWR VPWR sky130_fd_sc_hd__fill_2
Xhold1488 _5156_/Q VGND VGND VPWR VPWR _4072_/B2 sky130_fd_sc_hd__dlygate4sd3_1
Xhold1499 _5855_/Q VGND VGND VPWR VPWR _4819_/B2 sky130_fd_sc_hd__dlygate4sd3_1
X_5059_ _5824_/CLK _5059_/D VGND VGND VPWR VPWR _5059_/Q sky130_fd_sc_hd__dfxtp_2
XFILLER_111_21 VGND VGND VPWR VPWR sky130_fd_sc_hd__decap_3
XFILLER_111_54 VGND VGND VPWR VPWR sky130_fd_sc_hd__fill_2
XFILLER_25_364 VGND VGND VPWR VPWR sky130_fd_sc_hd__decap_3
XFILLER_53_684 VGND VGND VPWR VPWR sky130_fd_sc_hd__decap_3
XTAP_TAPCELL_ROW_84_1254 VGND VPWR sky130_fd_sc_hd__tapvpwrvgnd_1
XFILLER_111_87 VGND VGND VPWR VPWR sky130_fd_sc_hd__decap_3
XFILLER_40_323 VGND VGND VPWR VPWR sky130_fd_sc_hd__decap_3
XTAP_TAPCELL_ROW_23_521 VGND VPWR sky130_fd_sc_hd__tapvpwrvgnd_1
XFILLER_40_345 VGND VGND VPWR VPWR sky130_fd_sc_hd__fill_1
XTAP_TAPCELL_ROW_51_863 VGND VPWR sky130_fd_sc_hd__tapvpwrvgnd_1
XFILLER_21_570 VGND VGND VPWR VPWR sky130_fd_sc_hd__decap_3
XPHY_EDGE_ROW_109_Right_109 VGND VGND VPWR VPWR sky130_fd_sc_hd__decap_3
XFILLER_4_202 VGND VGND VPWR VPWR sky130_fd_sc_hd__fill_2
XFILLER_106_130 VGND VGND VPWR VPWR sky130_fd_sc_hd__decap_3
XFILLER_106_141 VGND VGND VPWR VPWR sky130_fd_sc_hd__decap_3
XFILLER_107_642 VGND VGND VPWR VPWR sky130_fd_sc_hd__decap_3
XFILLER_106_174 VGND VGND VPWR VPWR sky130_fd_sc_hd__decap_3
XTAP_TAPCELL_ROW_95_1394 VGND VPWR sky130_fd_sc_hd__tapvpwrvgnd_1
XFILLER_48_401 VGND VGND VPWR VPWR sky130_fd_sc_hd__decap_3
XFILLER_96_55 VGND VGND VPWR VPWR sky130_fd_sc_hd__decap_3
XFILLER_29_60 VGND VGND VPWR VPWR sky130_fd_sc_hd__decap_3
XFILLER_88_592 VGND VGND VPWR VPWR sky130_fd_sc_hd__fill_2
XFILLER_29_82 VGND VGND VPWR VPWR sky130_fd_sc_hd__fill_2
XFILLER_36_607 VGND VGND VPWR VPWR sky130_fd_sc_hd__fill_2
XTAP_TAPCELL_ROW_59_952 VGND VPWR sky130_fd_sc_hd__tapvpwrvgnd_1
XTAP_TAPCELL_ROW_59_963 VGND VPWR sky130_fd_sc_hd__tapvpwrvgnd_1
XFILLER_36_629 VGND VGND VPWR VPWR sky130_fd_sc_hd__decap_3
XFILLER_28_191 VGND VGND VPWR VPWR sky130_fd_sc_hd__decap_3
XFILLER_90_256 VGND VGND VPWR VPWR sky130_fd_sc_hd__decap_3
XTAP_TAPCELL_ROW_3_290 VGND VPWR sky130_fd_sc_hd__tapvpwrvgnd_1
XFILLER_45_81 VGND VGND VPWR VPWR sky130_fd_sc_hd__decap_3
XFILLER_90_267 VGND VGND VPWR VPWR sky130_fd_sc_hd__decap_3
Xclkbuf_4_14_0_clk clkbuf_0_clk/X VGND VGND VPWR VPWR clkbuf_4_14_0_clk/X sky130_fd_sc_hd__clkbuf_8
X_2760_ _5411_/Q _5059_/Q _2760_/S VGND VGND VPWR VPWR _2760_/X sky130_fd_sc_hd__mux2_1
XFILLER_8_541 VGND VGND VPWR VPWR sky130_fd_sc_hd__fill_1
X_2691_ _5248_/Q _5216_/Q _2878_/S VGND VGND VPWR VPWR _2691_/X sky130_fd_sc_hd__mux2_1
XANTENNA_2 _3235_/X VGND VGND VPWR VPWR sky130_fd_sc_hd__diode_2
X_4430_ _4738_/A1 _4433_/A2 _4433_/B1 _4430_/B2 VGND VGND VPWR VPWR _5490_/D sky130_fd_sc_hd__a22o_2
XFILLER_6_53 VGND VGND VPWR VPWR sky130_fd_sc_hd__decap_3
XFILLER_112_100 VGND VGND VPWR VPWR sky130_fd_sc_hd__decap_3
XFILLER_113_623 VGND VGND VPWR VPWR sky130_fd_sc_hd__decap_3
X_4361_ _5009_/A1 wire462/X wire242/A _4361_/B2 VGND VGND VPWR VPWR _5427_/D sky130_fd_sc_hd__a22o_2
XFILLER_113_656 VGND VGND VPWR VPWR sky130_fd_sc_hd__decap_3
Xfanout509 _4127_/Y VGND VGND VPWR VPWR fanout509/X sky130_fd_sc_hd__clkdlybuf4s25_1
X_4292_ _4738_/A1 _4292_/A2 _4295_/B1 _4292_/B2 VGND VGND VPWR VPWR _5362_/D sky130_fd_sc_hd__a22o_2
X_3312_ _5499_/Q _5467_/Q _3317_/S VGND VGND VPWR VPWR _3312_/X sky130_fd_sc_hd__mux2_1
XFILLER_39_401 VGND VGND VPWR VPWR sky130_fd_sc_hd__decap_3
XFILLER_58_209 VGND VGND VPWR VPWR sky130_fd_sc_hd__fill_1
XFILLER_86_529 VGND VGND VPWR VPWR sky130_fd_sc_hd__decap_3
XFILLER_98_378 VGND VGND VPWR VPWR sky130_fd_sc_hd__decap_3
X_6031_ _6031_/CLK _6031_/D VGND VGND VPWR VPWR _6031_/Q sky130_fd_sc_hd__dfxtp_2
X_3243_ _5368_/Q _5336_/Q _5304_/Q _5272_/Q _3774_/S _3772_/S1 VGND VGND VPWR VPWR
+ _3244_/B sky130_fd_sc_hd__mux4_2
XFILLER_66_253 VGND VGND VPWR VPWR sky130_fd_sc_hd__fill_1
Xfanout1080 _3818_/S VGND VGND VPWR VPWR _3326_/S sky130_fd_sc_hd__dlymetal6s2s_1
X_3174_ _5141_/Q _5109_/Q _6037_/Q _6005_/Q _2534_/S _3180_/S1 VGND VGND VPWR VPWR
+ _3175_/B sky130_fd_sc_hd__mux4_2
XFILLER_26_128 VGND VGND VPWR VPWR sky130_fd_sc_hd__decap_3
XFILLER_54_459 VGND VGND VPWR VPWR sky130_fd_sc_hd__fill_1
XFILLER_35_673 VGND VGND VPWR VPWR sky130_fd_sc_hd__decap_3
XFILLER_41_109 VGND VGND VPWR VPWR sky130_fd_sc_hd__decap_3
XFILLER_81_278 VGND VGND VPWR VPWR sky130_fd_sc_hd__fill_2
X_5815_ _5815_/CLK _5815_/D VGND VGND VPWR VPWR _5815_/Q sky130_fd_sc_hd__dfxtp_2
XFILLER_50_665 VGND VGND VPWR VPWR sky130_fd_sc_hd__fill_2
XFILLER_50_687 VGND VGND VPWR VPWR sky130_fd_sc_hd__fill_1
X_5746_ _5810_/CLK _5746_/D VGND VGND VPWR VPWR _5746_/Q sky130_fd_sc_hd__dfxtp_2
X_2958_ _5579_/Q _5547_/Q _3069_/S VGND VGND VPWR VPWR _2958_/X sky130_fd_sc_hd__mux2_1
X_5677_ _6034_/CLK _5677_/D VGND VGND VPWR VPWR _5677_/Q sky130_fd_sc_hd__dfxtp_2
X_4628_ _4899_/A1 _4639_/A2 _4639_/B1 _4628_/B2 VGND VGND VPWR VPWR _5675_/D sky130_fd_sc_hd__a22o_2
X_2889_ _5256_/Q _5224_/Q _2889_/S VGND VGND VPWR VPWR _2889_/X sky130_fd_sc_hd__mux2_1
XFILLER_103_100 VGND VGND VPWR VPWR sky130_fd_sc_hd__decap_3
X_4559_ _5000_/A1 _4566_/A2 _4566_/B1 _4559_/B2 VGND VGND VPWR VPWR _5610_/D sky130_fd_sc_hd__a22o_2
XFILLER_103_111 VGND VGND VPWR VPWR sky130_fd_sc_hd__fill_1
XFILLER_103_122 VGND VGND VPWR VPWR sky130_fd_sc_hd__decap_3
XFILLER_104_678 VGND VGND VPWR VPWR sky130_fd_sc_hd__decap_3
XFILLER_106_21 VGND VGND VPWR VPWR sky130_fd_sc_hd__decap_3
XFILLER_106_32 VGND VGND VPWR VPWR sky130_fd_sc_hd__decap_3
XFILLER_49_209 VGND VGND VPWR VPWR sky130_fd_sc_hd__decap_3
XFILLER_106_65 VGND VGND VPWR VPWR sky130_fd_sc_hd__decap_3
XFILLER_57_242 VGND VGND VPWR VPWR sky130_fd_sc_hd__decap_3
XFILLER_66_58 VGND VGND VPWR VPWR sky130_fd_sc_hd__decap_3
Xhold1230 _5972_/Q VGND VGND VPWR VPWR _4942_/B2 sky130_fd_sc_hd__dlygate4sd3_1
Xhold1241 _5636_/Q VGND VGND VPWR VPWR _4587_/B2 sky130_fd_sc_hd__dlygate4sd3_1
Xhold1252 _5422_/Q VGND VGND VPWR VPWR _4356_/B2 sky130_fd_sc_hd__dlygate4sd3_1
XTAP_TAPCELL_ROW_56_922 VGND VPWR sky130_fd_sc_hd__tapvpwrvgnd_1
Xhold1263 _5300_/Q VGND VGND VPWR VPWR _4226_/B2 sky130_fd_sc_hd__dlygate4sd3_1
Xhold1274 _6051_/Q VGND VGND VPWR VPWR _5027_/B2 sky130_fd_sc_hd__dlygate4sd3_1
Xhold1285 _5714_/Q VGND VGND VPWR VPWR _4669_/B2 sky130_fd_sc_hd__dlygate4sd3_1
XFILLER_72_234 VGND VGND VPWR VPWR sky130_fd_sc_hd__fill_1
Xhold1296 _5409_/Q VGND VGND VPWR VPWR _4343_/B2 sky130_fd_sc_hd__dlygate4sd3_1
XFILLER_26_684 VGND VGND VPWR VPWR sky130_fd_sc_hd__decap_3
XFILLER_41_632 VGND VGND VPWR VPWR sky130_fd_sc_hd__decap_3
XFILLER_15_84 VGND VGND VPWR VPWR sky130_fd_sc_hd__decap_3
XFILLER_40_131 VGND VGND VPWR VPWR sky130_fd_sc_hd__fill_1
XFILLER_40_197 VGND VGND VPWR VPWR sky130_fd_sc_hd__decap_3
XTAP_TAPCELL_ROW_97_1412 VGND VPWR sky130_fd_sc_hd__tapvpwrvgnd_1
XFILLER_5_522 VGND VGND VPWR VPWR sky130_fd_sc_hd__decap_3
Xoutput61 _2550_/X VGND VGND VPWR VPWR rd1[1] sky130_fd_sc_hd__dlymetal6s2s_1
Xoutput50 _2526_/X VGND VGND VPWR VPWR rd1[0] sky130_fd_sc_hd__clkbuf_2
XFILLER_110_604 VGND VGND VPWR VPWR sky130_fd_sc_hd__decap_3
Xoutput94 _3704_/X VGND VGND VPWR VPWR rd2[20] sky130_fd_sc_hd__dlymetal6s2s_1
Xoutput83 _3484_/X VGND VGND VPWR VPWR rd2[10] sky130_fd_sc_hd__clkbuf_2
Xoutput72 _2574_/X VGND VGND VPWR VPWR rd1[2] sky130_fd_sc_hd__buf_4
XFILLER_110_648 VGND VGND VPWR VPWR sky130_fd_sc_hd__decap_3
XFILLER_48_253 VGND VGND VPWR VPWR sky130_fd_sc_hd__decap_3
XFILLER_36_448 VGND VGND VPWR VPWR sky130_fd_sc_hd__decap_3
XFILLER_56_91 VGND VGND VPWR VPWR sky130_fd_sc_hd__decap_3
XFILLER_63_223 VGND VGND VPWR VPWR sky130_fd_sc_hd__fill_1
XFILLER_16_150 VGND VGND VPWR VPWR sky130_fd_sc_hd__decap_3
XFILLER_23_109 VGND VGND VPWR VPWR sky130_fd_sc_hd__decap_3
XFILLER_91_587 VGND VGND VPWR VPWR sky130_fd_sc_hd__decap_3
X_3930_ _3941_/A _3930_/B VGND VGND VPWR VPWR _3930_/X sky130_fd_sc_hd__or2_2
XFILLER_17_684 VGND VGND VPWR VPWR sky130_fd_sc_hd__decap_3
XFILLER_32_643 VGND VGND VPWR VPWR sky130_fd_sc_hd__fill_1
X_3861_ _5716_/Q _5684_/Q _5652_/Q _5620_/Q _3863_/S _3866_/S1 VGND VGND VPWR VPWR
+ _3861_/X sky130_fd_sc_hd__mux4_2
XFILLER_32_687 VGND VGND VPWR VPWR sky130_fd_sc_hd__fill_1
X_5600_ _5934_/CLK _5600_/D VGND VGND VPWR VPWR _5600_/Q sky130_fd_sc_hd__dfxtp_2
X_3792_ _3784_/A _3789_/X _3791_/X VGND VGND VPWR VPWR _3792_/X sky130_fd_sc_hd__a21o_2
X_2812_ _6053_/Q _5957_/Q _3088_/S VGND VGND VPWR VPWR _2812_/X sky130_fd_sc_hd__mux2_1
X_5531_ _5659_/CLK _5531_/D VGND VGND VPWR VPWR _5531_/Q sky130_fd_sc_hd__dfxtp_2
X_2743_ _5250_/Q _5218_/Q _2743_/S VGND VGND VPWR VPWR _2743_/X sky130_fd_sc_hd__mux2_1
XFILLER_8_371 VGND VGND VPWR VPWR sky130_fd_sc_hd__decap_3
X_5462_ _5925_/CLK _5462_/D VGND VGND VPWR VPWR _5462_/Q sky130_fd_sc_hd__dfxtp_2
X_2674_ _2727_/A1 _2672_/X _2673_/X _2972_/A1 VGND VGND VPWR VPWR _2674_/X sky130_fd_sc_hd__o22a_2
X_5393_ _5713_/CLK _5393_/D VGND VGND VPWR VPWR _5393_/Q sky130_fd_sc_hd__dfxtp_2
X_4413_ _4515_/A1 _4434_/A2 _4419_/B1 _4413_/B2 VGND VGND VPWR VPWR _5473_/D sky130_fd_sc_hd__a22o_2
XFILLER_98_131 VGND VGND VPWR VPWR sky130_fd_sc_hd__decap_3
X_4344_ _4653_/A1 wire465/X _4360_/B1 _4344_/B2 VGND VGND VPWR VPWR _5410_/D sky130_fd_sc_hd__a22o_2
XFILLER_99_687 VGND VGND VPWR VPWR sky130_fd_sc_hd__fill_1
XTAP_TAPCELL_ROW_6_319 VGND VPWR sky130_fd_sc_hd__tapvpwrvgnd_1
Xfanout328 _5014_/Y VGND VGND VPWR VPWR _5038_/A2 sky130_fd_sc_hd__clkdlybuf4s25_1
Xfanout317 _3988_/Y VGND VGND VPWR VPWR _4015_/B1 sky130_fd_sc_hd__clkdlybuf4s25_1
X_6014_ _6050_/CLK _6014_/D VGND VGND VPWR VPWR _6014_/Q sky130_fd_sc_hd__dfxtp_2
X_4275_ _4515_/A1 _4265_/B _4284_/B1 _4275_/B2 VGND VGND VPWR VPWR _5345_/D sky130_fd_sc_hd__a22o_2
XFILLER_39_242 VGND VGND VPWR VPWR sky130_fd_sc_hd__decap_3
X_3226_ _5207_/Q _5175_/Q _3227_/S VGND VGND VPWR VPWR _3226_/X sky130_fd_sc_hd__mux2_1
X_3157_ _5396_/Q _5364_/Q _5332_/Q _5300_/Q _2800_/S _3157_/S1 VGND VGND VPWR VPWR
+ _3157_/X sky130_fd_sc_hd__mux4_2
XFILLER_54_234 VGND VGND VPWR VPWR sky130_fd_sc_hd__fill_2
XFILLER_94_381 VGND VGND VPWR VPWR sky130_fd_sc_hd__decap_3
XPHY_EDGE_ROW_6_Left_122 VGND VGND VPWR VPWR sky130_fd_sc_hd__decap_3
XTAP_TAPCELL_ROW_68_1068 VGND VPWR sky130_fd_sc_hd__tapvpwrvgnd_1
X_3088_ _6065_/Q _5969_/Q _3088_/S VGND VGND VPWR VPWR _3088_/X sky130_fd_sc_hd__mux2_1
XTAP_TAPCELL_ROW_81_1224 VGND VPWR sky130_fd_sc_hd__tapvpwrvgnd_1
XFILLER_23_676 VGND VGND VPWR VPWR sky130_fd_sc_hd__decap_3
XFILLER_50_451 VGND VGND VPWR VPWR sky130_fd_sc_hd__fill_1
XFILLER_10_315 VGND VGND VPWR VPWR sky130_fd_sc_hd__fill_1
XFILLER_22_153 VGND VGND VPWR VPWR sky130_fd_sc_hd__decap_3
XTAP_TAPCELL_ROW_61_980 VGND VPWR sky130_fd_sc_hd__tapvpwrvgnd_1
XFILLER_22_197 VGND VGND VPWR VPWR sky130_fd_sc_hd__fill_2
X_5729_ _5825_/CLK _5729_/D VGND VGND VPWR VPWR _5729_/Q sky130_fd_sc_hd__dfxtp_2
XFILLER_108_214 VGND VGND VPWR VPWR sky130_fd_sc_hd__fill_2
XTAP_TAPCELL_ROW_79_1197 VGND VPWR sky130_fd_sc_hd__tapvpwrvgnd_1
XTAP_TAPCELL_ROW_92_1353 VGND VPWR sky130_fd_sc_hd__tapvpwrvgnd_1
XFILLER_77_57 VGND VGND VPWR VPWR sky130_fd_sc_hd__decap_3
Xfanout851 fanout863/X VGND VGND VPWR VPWR _2981_/S sky130_fd_sc_hd__clkbuf_2
XFILLER_77_348 VGND VGND VPWR VPWR sky130_fd_sc_hd__decap_3
Xfanout884 input44/X VGND VGND VPWR VPWR _4751_/A1 sky130_fd_sc_hd__clkdlybuf4s25_1
Xfanout873 input46/X VGND VGND VPWR VPWR _4719_/A1 sky130_fd_sc_hd__clkdlybuf4s25_1
Xfanout862 fanout863/X VGND VGND VPWR VPWR _2732_/S sky130_fd_sc_hd__clkdlybuf4s25_1
XFILLER_93_12 VGND VGND VPWR VPWR sky130_fd_sc_hd__decap_3
Xfanout895 _5047_/A1 VGND VGND VPWR VPWR _4777_/A1 sky130_fd_sc_hd__clkdlybuf4s25_1
XFILLER_60_204 VGND VGND VPWR VPWR sky130_fd_sc_hd__decap_3
XFILLER_93_89 VGND VGND VPWR VPWR sky130_fd_sc_hd__decap_3
XFILLER_33_429 VGND VGND VPWR VPWR sky130_fd_sc_hd__decap_3
XFILLER_73_598 VGND VGND VPWR VPWR sky130_fd_sc_hd__decap_3
XFILLER_14_643 VGND VGND VPWR VPWR sky130_fd_sc_hd__fill_1
XFILLER_14_654 VGND VGND VPWR VPWR sky130_fd_sc_hd__decap_3
XFILLER_26_94 VGND VGND VPWR VPWR sky130_fd_sc_hd__decap_3
XFILLER_14_687 VGND VGND VPWR VPWR sky130_fd_sc_hd__fill_1
XFILLER_9_113 VGND VGND VPWR VPWR sky130_fd_sc_hd__decap_3
XTAP_TAPCELL_ROW_101_1460 VGND VPWR sky130_fd_sc_hd__tapvpwrvgnd_1
XTAP_TAPCELL_ROW_31_619 VGND VPWR sky130_fd_sc_hd__tapvpwrvgnd_1
XFILLER_9_135 VGND VGND VPWR VPWR sky130_fd_sc_hd__decap_3
XTAP_TAPCELL_ROW_11_376 VGND VPWR sky130_fd_sc_hd__tapvpwrvgnd_1
XTAP_TAPCELL_ROW_11_387 VGND VPWR sky130_fd_sc_hd__tapvpwrvgnd_1
Xclkbuf_leaf_102_clk clkbuf_4_0_0_clk/X VGND VGND VPWR VPWR clkload9/A sky130_fd_sc_hd__clkbuf_8
XFILLER_47_6 VGND VGND VPWR VPWR sky130_fd_sc_hd__fill_1
XFILLER_3_21 VGND VGND VPWR VPWR sky130_fd_sc_hd__decap_3
XFILLER_3_54 VGND VGND VPWR VPWR sky130_fd_sc_hd__fill_2
XFILLER_68_315 VGND VGND VPWR VPWR sky130_fd_sc_hd__fill_2
XFILLER_110_467 VGND VGND VPWR VPWR sky130_fd_sc_hd__fill_1
XPHY_EDGE_ROW_79_Left_195 VGND VGND VPWR VPWR sky130_fd_sc_hd__decap_3
X_4060_ _4506_/A1 _4085_/A2 _4088_/B1 _4060_/B2 VGND VGND VPWR VPWR _5144_/D sky130_fd_sc_hd__a22o_2
XFILLER_83_329 VGND VGND VPWR VPWR sky130_fd_sc_hd__decap_3
XFILLER_95_178 VGND VGND VPWR VPWR sky130_fd_sc_hd__decap_3
XTAP_TAPCELL_ROW_39_719 VGND VPWR sky130_fd_sc_hd__tapvpwrvgnd_1
X_3011_ _3027_/A1 _3008_/X _3010_/X _3027_/B2 VGND VGND VPWR VPWR _3011_/X sky130_fd_sc_hd__a22o_2
XFILLER_36_256 VGND VGND VPWR VPWR sky130_fd_sc_hd__decap_3
XFILLER_36_267 VGND VGND VPWR VPWR sky130_fd_sc_hd__decap_3
XFILLER_91_340 VGND VGND VPWR VPWR sky130_fd_sc_hd__decap_3
XFILLER_17_492 VGND VGND VPWR VPWR sky130_fd_sc_hd__decap_3
XFILLER_24_429 VGND VGND VPWR VPWR sky130_fd_sc_hd__decap_3
XTAP_TAPCELL_ROW_19_476 VGND VPWR sky130_fd_sc_hd__tapvpwrvgnd_1
X_4962_ _5030_/A1 _4974_/A2 _4974_/B1 _4962_/B2 VGND VGND VPWR VPWR _5990_/D sky130_fd_sc_hd__a22o_2
X_4893_ _4927_/A1 wire360/X _4895_/B1 _4893_/B2 VGND VGND VPWR VPWR _5925_/D sky130_fd_sc_hd__a22o_2
X_3913_ _5430_/Q _5078_/Q _3913_/S VGND VGND VPWR VPWR _3914_/B sky130_fd_sc_hd__mux2_1
XFILLER_20_613 VGND VGND VPWR VPWR sky130_fd_sc_hd__decap_3
X_3844_ _5715_/Q _5683_/Q _5651_/Q _5619_/Q _3847_/S _3893_/S1 VGND VGND VPWR VPWR
+ _3845_/B sky130_fd_sc_hd__mux4_2
XFILLER_32_495 VGND VGND VPWR VPWR sky130_fd_sc_hd__decap_3
X_3775_ _3791_/A1 _3772_/X _3774_/X _3791_/B2 VGND VGND VPWR VPWR _3775_/X sky130_fd_sc_hd__a22o_2
X_5514_ _5514_/CLK _5514_/D VGND VGND VPWR VPWR _5514_/Q sky130_fd_sc_hd__dfxtp_2
X_2726_ _5569_/Q _5537_/Q _2975_/S VGND VGND VPWR VPWR _2726_/X sky130_fd_sc_hd__mux2_1
XTAP_TAPCELL_ROW_115_1629 VGND VPWR sky130_fd_sc_hd__tapvpwrvgnd_1
X_5445_ _6053_/CLK _5445_/D VGND VGND VPWR VPWR _5445_/Q sky130_fd_sc_hd__dfxtp_2
X_2657_ _3108_/A _2653_/X _2656_/X _3106_/C1 VGND VGND VPWR VPWR _2657_/X sky130_fd_sc_hd__o211a_2
X_5376_ _5500_/CLK _5376_/D VGND VGND VPWR VPWR _5376_/Q sky130_fd_sc_hd__dfxtp_2
X_2588_ _5499_/Q _5467_/Q _2589_/S VGND VGND VPWR VPWR _2588_/X sky130_fd_sc_hd__mux2_1
XFILLER_59_337 VGND VGND VPWR VPWR sky130_fd_sc_hd__decap_3
Xfanout147 _4845_/Y VGND VGND VPWR VPWR _4875_/B1 sky130_fd_sc_hd__clkdlybuf4s25_1
Xfanout125 _4981_/Y VGND VGND VPWR VPWR _5013_/B1 sky130_fd_sc_hd__clkdlybuf4s25_1
Xfanout114 _5015_/Y VGND VGND VPWR VPWR wire115/A sky130_fd_sc_hd__clkdlybuf4s25_1
X_4327_ _4773_/A1 _4327_/A2 wire248/X _4327_/B2 VGND VGND VPWR VPWR _5395_/D sky130_fd_sc_hd__a22o_2
XFILLER_86_156 VGND VGND VPWR VPWR sky130_fd_sc_hd__decap_3
XFILLER_87_679 VGND VGND VPWR VPWR sky130_fd_sc_hd__fill_1
X_4258_ _4738_/A1 _4258_/A2 _4261_/B1 _4258_/B2 VGND VGND VPWR VPWR _5330_/D sky130_fd_sc_hd__a22o_2
XFILLER_101_478 VGND VGND VPWR VPWR sky130_fd_sc_hd__decap_3
X_3209_ _5943_/Q _5911_/Q _5879_/Q _5783_/Q _3209_/S0 _3225_/S1 VGND VGND VPWR VPWR
+ _3209_/X sky130_fd_sc_hd__mux4_2
X_4189_ _5008_/A1 _4189_/A2 wire283/X _4189_/B2 VGND VGND VPWR VPWR _5266_/D sky130_fd_sc_hd__a22o_2
XFILLER_103_55 VGND VGND VPWR VPWR sky130_fd_sc_hd__fill_1
XFILLER_15_418 VGND VGND VPWR VPWR sky130_fd_sc_hd__decap_3
XFILLER_55_576 VGND VGND VPWR VPWR sky130_fd_sc_hd__decap_3
XFILLER_82_362 VGND VGND VPWR VPWR sky130_fd_sc_hd__fill_2
XFILLER_55_587 VGND VGND VPWR VPWR sky130_fd_sc_hd__decap_3
XFILLER_23_440 VGND VGND VPWR VPWR sky130_fd_sc_hd__fill_2
XFILLER_23_462 VGND VGND VPWR VPWR sky130_fd_sc_hd__decap_3
XFILLER_10_134 VGND VGND VPWR VPWR sky130_fd_sc_hd__fill_1
XFILLER_50_270 VGND VGND VPWR VPWR sky130_fd_sc_hd__decap_3
XFILLER_109_501 VGND VGND VPWR VPWR sky130_fd_sc_hd__decap_3
XFILLER_11_679 VGND VGND VPWR VPWR sky130_fd_sc_hd__decap_3
XFILLER_7_617 VGND VGND VPWR VPWR sky130_fd_sc_hd__decap_3
Xwire526 wire526/A VGND VGND VPWR VPWR wire526/X sky130_fd_sc_hd__clkbuf_4
Xwire548 wire548/A VGND VGND VPWR VPWR wire548/X sky130_fd_sc_hd__buf_4
XFILLER_109_534 VGND VGND VPWR VPWR sky130_fd_sc_hd__decap_3
Xwire559 wire559/A VGND VGND VPWR VPWR wire559/X sky130_fd_sc_hd__clkbuf_4
XFILLER_109_589 VGND VGND VPWR VPWR sky130_fd_sc_hd__fill_1
XFILLER_12_85 VGND VGND VPWR VPWR sky130_fd_sc_hd__decap_3
XFILLER_2_322 VGND VGND VPWR VPWR sky130_fd_sc_hd__fill_2
XFILLER_77_101 VGND VGND VPWR VPWR sky130_fd_sc_hd__decap_3
Xfanout692 _3028_/A1 VGND VGND VPWR VPWR wire693/A sky130_fd_sc_hd__clkdlybuf4s25_1
Xfanout681 _2497_/X VGND VGND VPWR VPWR _3111_/B2 sky130_fd_sc_hd__buf_2
XFILLER_37_82 VGND VGND VPWR VPWR sky130_fd_sc_hd__decap_3
XFILLER_92_159 VGND VGND VPWR VPWR sky130_fd_sc_hd__fill_1
XPHY_EDGE_ROW_16_Right_16 VGND VGND VPWR VPWR sky130_fd_sc_hd__decap_3
XTAP_TAPCELL_ROW_16_446 VGND VPWR sky130_fd_sc_hd__tapvpwrvgnd_1
XFILLER_14_473 VGND VGND VPWR VPWR sky130_fd_sc_hd__decap_3
XTAP_TAPCELL_ROW_44_777 VGND VPWR sky130_fd_sc_hd__tapvpwrvgnd_1
XFILLER_41_292 VGND VGND VPWR VPWR sky130_fd_sc_hd__fill_2
XPHY_EDGE_ROW_25_Right_25 VGND VGND VPWR VPWR sky130_fd_sc_hd__decap_3
X_3560_ _3562_/A _3556_/X _3559_/X _3832_/C1 VGND VGND VPWR VPWR _3560_/X sky130_fd_sc_hd__o211a_2
XFILLER_6_672 VGND VGND VPWR VPWR sky130_fd_sc_hd__decap_3
X_2511_ _3195_/A1 _2509_/X _2510_/X _2499_/A VGND VGND VPWR VPWR _2511_/X sky130_fd_sc_hd__o22a_2
X_5230_ _6030_/CLK _5230_/D VGND VGND VPWR VPWR _5230_/Q sky130_fd_sc_hd__dfxtp_2
X_3491_ _5507_/Q _5475_/Q _3501_/S VGND VGND VPWR VPWR _3491_/X sky130_fd_sc_hd__mux2_1
XFILLER_45_3 VGND VGND VPWR VPWR sky130_fd_sc_hd__decap_3
XFILLER_68_112 VGND VGND VPWR VPWR sky130_fd_sc_hd__fill_2
XFILLER_96_421 VGND VGND VPWR VPWR sky130_fd_sc_hd__decap_3
XPHY_EDGE_ROW_87_Left_203 VGND VGND VPWR VPWR sky130_fd_sc_hd__decap_3
X_5161_ _6012_/CLK _5161_/D VGND VGND VPWR VPWR _5161_/Q sky130_fd_sc_hd__dfxtp_2
XFILLER_110_220 VGND VGND VPWR VPWR sky130_fd_sc_hd__fill_2
XFILLER_69_668 VGND VGND VPWR VPWR sky130_fd_sc_hd__decap_3
Xhold1807 _5694_/Q VGND VGND VPWR VPWR _4649_/B2 sky130_fd_sc_hd__dlygate4sd3_1
Xhold1818 _5230_/Q VGND VGND VPWR VPWR _4151_/B2 sky130_fd_sc_hd__dlygate4sd3_1
X_5092_ _6036_/CLK _5092_/D VGND VGND VPWR VPWR _5092_/Q sky130_fd_sc_hd__dfxtp_2
X_4112_ _5033_/A1 _4124_/A2 _4112_/B1 _4112_/B2 VGND VGND VPWR VPWR _5193_/D sky130_fd_sc_hd__a22o_2
XFILLER_110_253 VGND VGND VPWR VPWR sky130_fd_sc_hd__fill_2
Xhold1829 _5479_/Q VGND VGND VPWR VPWR _4419_/B2 sky130_fd_sc_hd__dlygate4sd3_1
X_4043_ _4525_/A1 _4023_/B _4052_/B1 _4043_/B2 VGND VGND VPWR VPWR _5131_/D sky130_fd_sc_hd__a22o_2
XPHY_EDGE_ROW_34_Right_34 VGND VGND VPWR VPWR sky130_fd_sc_hd__decap_3
XFILLER_52_502 VGND VGND VPWR VPWR sky130_fd_sc_hd__decap_3
XFILLER_24_215 VGND VGND VPWR VPWR sky130_fd_sc_hd__decap_3
XFILLER_52_513 VGND VGND VPWR VPWR sky130_fd_sc_hd__decap_3
XTAP_TAPCELL_ROW_65_1027 VGND VPWR sky130_fd_sc_hd__tapvpwrvgnd_1
X_5994_ _6023_/CLK _5994_/D VGND VGND VPWR VPWR _5994_/Q sky130_fd_sc_hd__dfxtp_2
XPHY_EDGE_ROW_96_Left_212 VGND VGND VPWR VPWR sky130_fd_sc_hd__decap_3
X_4945_ _5047_/A1 wire355/X _4945_/B1 _4945_/B2 VGND VGND VPWR VPWR _5975_/D sky130_fd_sc_hd__a22o_2
XFILLER_33_18 VGND VGND VPWR VPWR sky130_fd_sc_hd__fill_2
XFILLER_20_410 VGND VGND VPWR VPWR sky130_fd_sc_hd__fill_2
X_4876_ _5046_/A1 _4876_/A2 wire151/X _4876_/B2 VGND VGND VPWR VPWR _5910_/D sky130_fd_sc_hd__a22o_2
XPHY_EDGE_ROW_43_Right_43 VGND VGND VPWR VPWR sky130_fd_sc_hd__decap_3
X_3827_ _3825_/X _3826_/X _3827_/S VGND VGND VPWR VPWR _3827_/X sky130_fd_sc_hd__mux2_1
X_3758_ _3918_/A _3754_/X _3757_/X _3916_/B1 VGND VGND VPWR VPWR _3758_/X sky130_fd_sc_hd__o211a_2
X_2709_ _3019_/A _2706_/X _2708_/X wire641/X VGND VGND VPWR VPWR _2709_/X sky130_fd_sc_hd__o22a_2
XTAP_TAPCELL_ROW_76_1156 VGND VPWR sky130_fd_sc_hd__tapvpwrvgnd_1
XTAP_TAPCELL_ROW_76_1167 VGND VPWR sky130_fd_sc_hd__tapvpwrvgnd_1
X_3689_ _5516_/Q _5484_/Q _3689_/S VGND VGND VPWR VPWR _3689_/X sky130_fd_sc_hd__mux2_1
X_5428_ _5812_/CLK _5428_/D VGND VGND VPWR VPWR _5428_/Q sky130_fd_sc_hd__dfxtp_2
XFILLER_99_270 VGND VGND VPWR VPWR sky130_fd_sc_hd__decap_3
XFILLER_99_281 VGND VGND VPWR VPWR sky130_fd_sc_hd__decap_3
X_5359_ _5999_/CLK _5359_/D VGND VGND VPWR VPWR _5359_/Q sky130_fd_sc_hd__dfxtp_2
XFILLER_114_592 VGND VGND VPWR VPWR sky130_fd_sc_hd__decap_3
XFILLER_101_275 VGND VGND VPWR VPWR sky130_fd_sc_hd__decap_3
XFILLER_114_21 VGND VGND VPWR VPWR sky130_fd_sc_hd__decap_3
XFILLER_114_32 VGND VGND VPWR VPWR sky130_fd_sc_hd__decap_3
XFILLER_74_104 VGND VGND VPWR VPWR sky130_fd_sc_hd__decap_3
XFILLER_75_627 VGND VGND VPWR VPWR sky130_fd_sc_hd__fill_1
XPHY_EDGE_ROW_52_Right_52 VGND VGND VPWR VPWR sky130_fd_sc_hd__decap_3
XFILLER_114_65 VGND VGND VPWR VPWR sky130_fd_sc_hd__decap_3
XFILLER_74_137 VGND VGND VPWR VPWR sky130_fd_sc_hd__decap_3
XFILLER_28_598 VGND VGND VPWR VPWR sky130_fd_sc_hd__decap_3
XFILLER_43_513 VGND VGND VPWR VPWR sky130_fd_sc_hd__decap_3
XTAP_TAPCELL_ROW_87_1296 VGND VPWR sky130_fd_sc_hd__tapvpwrvgnd_1
XFILLER_15_237 VGND VGND VPWR VPWR sky130_fd_sc_hd__decap_3
XTAP_TAPCELL_ROW_13_405 VGND VPWR sky130_fd_sc_hd__tapvpwrvgnd_1
XFILLER_11_421 VGND VGND VPWR VPWR sky130_fd_sc_hd__fill_1
XFILLER_23_270 VGND VGND VPWR VPWR sky130_fd_sc_hd__fill_1
XPHY_EDGE_ROW_61_Right_61 VGND VGND VPWR VPWR sky130_fd_sc_hd__decap_3
XTAP_TAPCELL_ROW_41_736 VGND VPWR sky130_fd_sc_hd__tapvpwrvgnd_1
XTAP_TAPCELL_ROW_41_747 VGND VPWR sky130_fd_sc_hd__tapvpwrvgnd_1
XFILLER_7_414 VGND VGND VPWR VPWR sky130_fd_sc_hd__decap_3
XFILLER_7_447 VGND VGND VPWR VPWR sky130_fd_sc_hd__fill_1
Xwire334 wire334/A VGND VGND VPWR VPWR wire334/X sky130_fd_sc_hd__clkbuf_4
XFILLER_7_469 VGND VGND VPWR VPWR sky130_fd_sc_hd__decap_3
Xwire367 _4845_/B VGND VGND VPWR VPWR wire367/X sky130_fd_sc_hd__buf_4
Xwire389 _4711_/B VGND VGND VPWR VPWR wire389/X sky130_fd_sc_hd__buf_4
XFILLER_109_386 VGND VGND VPWR VPWR sky130_fd_sc_hd__decap_3
XFILLER_3_620 VGND VGND VPWR VPWR sky130_fd_sc_hd__decap_3
XFILLER_3_653 VGND VGND VPWR VPWR sky130_fd_sc_hd__decap_3
XFILLER_99_99 VGND VGND VPWR VPWR sky130_fd_sc_hd__decap_3
XFILLER_2_141 VGND VGND VPWR VPWR sky130_fd_sc_hd__fill_2
XFILLER_31_9 VGND VGND VPWR VPWR sky130_fd_sc_hd__decap_3
XPHY_EDGE_ROW_70_Right_70 VGND VGND VPWR VPWR sky130_fd_sc_hd__decap_3
Xload_slew339 _5010_/A2 VGND VGND VPWR VPWR _4981_/B sky130_fd_sc_hd__buf_4
XFILLER_19_521 VGND VGND VPWR VPWR sky130_fd_sc_hd__fill_1
XTAP_TAPCELL_ROW_49_836 VGND VPWR sky130_fd_sc_hd__tapvpwrvgnd_1
XFILLER_0_44 VGND VGND VPWR VPWR sky130_fd_sc_hd__decap_3
XFILLER_0_66 VGND VGND VPWR VPWR sky130_fd_sc_hd__fill_1
XFILLER_34_513 VGND VGND VPWR VPWR sky130_fd_sc_hd__decap_3
XFILLER_0_88 VGND VGND VPWR VPWR sky130_fd_sc_hd__decap_3
XFILLER_64_80 VGND VGND VPWR VPWR sky130_fd_sc_hd__decap_3
XTAP_TAPCELL_ROW_29_593 VGND VPWR sky130_fd_sc_hd__tapvpwrvgnd_1
X_2991_ _5709_/Q _5677_/Q _5645_/Q _5613_/Q _2993_/S _3102_/S1 VGND VGND VPWR VPWR
+ _2991_/X sky130_fd_sc_hd__mux4_2
XFILLER_14_292 VGND VGND VPWR VPWR sky130_fd_sc_hd__decap_3
XFILLER_9_42 VGND VGND VPWR VPWR sky130_fd_sc_hd__decap_3
X_4730_ _4830_/A1 wire389/X wire171/X _4730_/B2 VGND VGND VPWR VPWR _5770_/D sky130_fd_sc_hd__a22o_2
X_4661_ _4695_/A1 _4668_/A2 _4668_/B1 _4661_/B2 VGND VGND VPWR VPWR _5706_/D sky130_fd_sc_hd__a22o_2
X_3612_ _3896_/B2 _3609_/X _3611_/X _3612_/C1 VGND VGND VPWR VPWR _3613_/B sky130_fd_sc_hd__o211a_2
X_4592_ _4660_/A1 wire414/X wire193/X _4592_/B2 VGND VGND VPWR VPWR _5641_/D sky130_fd_sc_hd__a22o_2
XFILLER_115_312 VGND VGND VPWR VPWR sky130_fd_sc_hd__fill_2
XFILLER_115_334 VGND VGND VPWR VPWR sky130_fd_sc_hd__fill_2
X_3543_ _3235_/B _3541_/X _3542_/X _3543_/B2 VGND VGND VPWR VPWR _3543_/X sky130_fd_sc_hd__o22a_2
X_3474_ _5186_/Q _5154_/Q _3475_/S VGND VGND VPWR VPWR _3474_/X sky130_fd_sc_hd__mux2_1
X_5213_ _5810_/CLK _5213_/D VGND VGND VPWR VPWR _5213_/Q sky130_fd_sc_hd__dfxtp_2
Xload_slew840 _3199_/S VGND VGND VPWR VPWR _3038_/S sky130_fd_sc_hd__buf_2
X_5144_ _6036_/CLK _5144_/D VGND VGND VPWR VPWR _5144_/Q sky130_fd_sc_hd__dfxtp_2
XFILLER_28_18 VGND VGND VPWR VPWR sky130_fd_sc_hd__decap_3
XFILLER_28_29 VGND VGND VPWR VPWR sky130_fd_sc_hd__decap_3
XFILLER_29_307 VGND VGND VPWR VPWR sky130_fd_sc_hd__decap_3
XFILLER_96_251 VGND VGND VPWR VPWR sky130_fd_sc_hd__fill_1
XTAP_TAPCELL_ROW_71_1097 VGND VPWR sky130_fd_sc_hd__tapvpwrvgnd_1
Xhold1604 _5557_/Q VGND VGND VPWR VPWR _4501_/B2 sky130_fd_sc_hd__dlygate4sd3_1
Xhold1615 _6001_/Q VGND VGND VPWR VPWR _4973_/B2 sky130_fd_sc_hd__dlygate4sd3_1
Xhold1626 _5107_/Q VGND VGND VPWR VPWR _4016_/B2 sky130_fd_sc_hd__dlygate4sd3_1
XFILLER_111_584 VGND VGND VPWR VPWR sky130_fd_sc_hd__decap_3
XFILLER_56_137 VGND VGND VPWR VPWR sky130_fd_sc_hd__decap_3
XFILLER_57_638 VGND VGND VPWR VPWR sky130_fd_sc_hd__decap_3
XFILLER_84_435 VGND VGND VPWR VPWR sky130_fd_sc_hd__decap_3
Xhold1637 _5549_/Q VGND VGND VPWR VPWR _4493_/B2 sky130_fd_sc_hd__dlygate4sd3_1
Xhold1648 _5417_/Q VGND VGND VPWR VPWR _4351_/B2 sky130_fd_sc_hd__dlygate4sd3_1
Xhold1659 _5266_/Q VGND VGND VPWR VPWR _4189_/B2 sky130_fd_sc_hd__dlygate4sd3_1
X_5075_ _6037_/CLK _5075_/D VGND VGND VPWR VPWR _5075_/Q sky130_fd_sc_hd__dfxtp_2
XFILLER_72_619 VGND VGND VPWR VPWR sky130_fd_sc_hd__fill_2
XFILLER_84_457 VGND VGND VPWR VPWR sky130_fd_sc_hd__fill_1
X_4026_ _4984_/A1 _4053_/A2 _4053_/B1 _4026_/B2 VGND VGND VPWR VPWR _5114_/D sky130_fd_sc_hd__a22o_2
XFILLER_65_671 VGND VGND VPWR VPWR sky130_fd_sc_hd__fill_1
XFILLER_25_546 VGND VGND VPWR VPWR sky130_fd_sc_hd__decap_3
XFILLER_64_192 VGND VGND VPWR VPWR sky130_fd_sc_hd__decap_3
Xclkbuf_leaf_91_clk clkload1/A VGND VGND VPWR VPWR _5589_/CLK sky130_fd_sc_hd__clkbuf_8
XFILLER_100_12 VGND VGND VPWR VPWR sky130_fd_sc_hd__decap_3
XFILLER_80_685 VGND VGND VPWR VPWR sky130_fd_sc_hd__decap_3
X_5977_ clkload8/A _5977_/D VGND VGND VPWR VPWR _5977_/Q sky130_fd_sc_hd__dfxtp_2
X_4928_ _5030_/A1 _4943_/A2 _4943_/B1 _4928_/B2 VGND VGND VPWR VPWR _5958_/D sky130_fd_sc_hd__a22o_2
XFILLER_20_240 VGND VGND VPWR VPWR sky130_fd_sc_hd__fill_2
XFILLER_20_262 VGND VGND VPWR VPWR sky130_fd_sc_hd__decap_3
X_4859_ _4927_/A1 wire367/X _4861_/B1 _4859_/B2 VGND VGND VPWR VPWR _5893_/D sky130_fd_sc_hd__a22o_2
XFILLER_109_21 VGND VGND VPWR VPWR sky130_fd_sc_hd__decap_3
XFILLER_114_6 VGND VGND VPWR VPWR sky130_fd_sc_hd__decap_3
XFILLER_106_301 VGND VGND VPWR VPWR sky130_fd_sc_hd__fill_1
XFILLER_106_312 VGND VGND VPWR VPWR sky130_fd_sc_hd__decap_3
XFILLER_109_54 VGND VGND VPWR VPWR sky130_fd_sc_hd__fill_2
XFILLER_109_87 VGND VGND VPWR VPWR sky130_fd_sc_hd__decap_3
XFILLER_0_601 VGND VGND VPWR VPWR sky130_fd_sc_hd__decap_3
XFILLER_0_612 VGND VGND VPWR VPWR sky130_fd_sc_hd__decap_3
XFILLER_0_634 VGND VGND VPWR VPWR sky130_fd_sc_hd__decap_3
XFILLER_0_645 VGND VGND VPWR VPWR sky130_fd_sc_hd__decap_3
XFILLER_48_616 VGND VGND VPWR VPWR sky130_fd_sc_hd__fill_2
XFILLER_85_35 VGND VGND VPWR VPWR sky130_fd_sc_hd__fill_2
XFILLER_102_584 VGND VGND VPWR VPWR sky130_fd_sc_hd__decap_3
XFILLER_47_126 VGND VGND VPWR VPWR sky130_fd_sc_hd__fill_2
XFILLER_47_137 VGND VGND VPWR VPWR sky130_fd_sc_hd__decap_3
XFILLER_85_57 VGND VGND VPWR VPWR sky130_fd_sc_hd__decap_3
XTAP_TAPCELL_ROW_89_1314 VGND VPWR sky130_fd_sc_hd__tapvpwrvgnd_1
XFILLER_18_51 VGND VGND VPWR VPWR sky130_fd_sc_hd__decap_3
XFILLER_28_351 VGND VGND VPWR VPWR sky130_fd_sc_hd__decap_3
XFILLER_75_457 VGND VGND VPWR VPWR sky130_fd_sc_hd__decap_3
XFILLER_90_405 VGND VGND VPWR VPWR sky130_fd_sc_hd__fill_1
XTAP_TAPCELL_ROW_46_806 VGND VPWR sky130_fd_sc_hd__tapvpwrvgnd_1
Xclkbuf_leaf_82_clk clkbuf_4_4_0_clk/X VGND VGND VPWR VPWR _5914_/CLK sky130_fd_sc_hd__clkbuf_8
XFILLER_31_505 VGND VGND VPWR VPWR sky130_fd_sc_hd__decap_3
XFILLER_71_685 VGND VGND VPWR VPWR sky130_fd_sc_hd__decap_3
XTAP_TAPCELL_ROW_26_563 VGND VPWR sky130_fd_sc_hd__tapvpwrvgnd_1
XFILLER_31_549 VGND VGND VPWR VPWR sky130_fd_sc_hd__decap_3
XTAP_TAPCELL_ROW_54_894 VGND VPWR sky130_fd_sc_hd__tapvpwrvgnd_1
XFILLER_34_94 VGND VGND VPWR VPWR sky130_fd_sc_hd__fill_2
XFILLER_7_233 VGND VGND VPWR VPWR sky130_fd_sc_hd__decap_3
Xwire153 wire153/A VGND VGND VPWR VPWR wire153/X sky130_fd_sc_hd__clkbuf_4
XFILLER_109_172 VGND VGND VPWR VPWR sky130_fd_sc_hd__fill_1
Xwire186 wire186/A VGND VGND VPWR VPWR wire186/X sky130_fd_sc_hd__clkbuf_4
Xload_slew169 _4727_/B1 VGND VGND VPWR VPWR _4740_/B1 sky130_fd_sc_hd__clkbuf_4
X_3190_ _3228_/A1 _3187_/X _3189_/X _3229_/A1 VGND VGND VPWR VPWR _3190_/X sky130_fd_sc_hd__a22o_2
XFILLER_19_340 VGND VGND VPWR VPWR sky130_fd_sc_hd__decap_3
XFILLER_19_373 VGND VGND VPWR VPWR sky130_fd_sc_hd__decap_3
XFILLER_47_671 VGND VGND VPWR VPWR sky130_fd_sc_hd__fill_1
XTAP_TAPCELL_ROW_109_1561 VGND VPWR sky130_fd_sc_hd__tapvpwrvgnd_1
X_5900_ _5932_/CLK _5900_/D VGND VGND VPWR VPWR _5900_/Q sky130_fd_sc_hd__dfxtp_2
XFILLER_62_641 VGND VGND VPWR VPWR sky130_fd_sc_hd__decap_3
Xclkbuf_leaf_73_clk clkload2/A VGND VGND VPWR VPWR _5790_/CLK sky130_fd_sc_hd__clkbuf_8
XFILLER_34_365 VGND VGND VPWR VPWR sky130_fd_sc_hd__decap_3
XFILLER_62_674 VGND VGND VPWR VPWR sky130_fd_sc_hd__fill_1
X_5831_ _6017_/CLK _5831_/D VGND VGND VPWR VPWR _5831_/Q sky130_fd_sc_hd__dfxtp_2
X_5762_ _5922_/CLK _5762_/D VGND VGND VPWR VPWR _5762_/Q sky130_fd_sc_hd__dfxtp_2
X_2974_ _5420_/Q _5068_/Q _2975_/S VGND VGND VPWR VPWR _2974_/X sky130_fd_sc_hd__mux2_1
X_4713_ _5017_/A1 wire386/A wire166/X _4713_/B2 VGND VGND VPWR VPWR _5753_/D sky130_fd_sc_hd__a22o_2
X_5693_ _5794_/CLK _5693_/D VGND VGND VPWR VPWR _5693_/Q sky130_fd_sc_hd__dfxtp_2
X_4644_ _4747_/A1 wire400/X wire179/X _4644_/B2 VGND VGND VPWR VPWR _5689_/D sky130_fd_sc_hd__a22o_2
X_4575_ _4880_/A1 wire414/A wire193/X _4575_/B2 VGND VGND VPWR VPWR _5624_/D sky130_fd_sc_hd__a22o_2
X_3526_ wire630/X _3518_/X _3520_/X _3909_/B1 _3510_/X VGND VGND VPWR VPWR _3526_/X
+ sky130_fd_sc_hd__a32o_2
XFILLER_115_164 VGND VGND VPWR VPWR sky130_fd_sc_hd__decap_3
XTAP_TAPCELL_ROW_73_1126 VGND VPWR sky130_fd_sc_hd__tapvpwrvgnd_1
XFILLER_115_197 VGND VGND VPWR VPWR sky130_fd_sc_hd__decap_3
Xhold2102 _5828_/Q VGND VGND VPWR VPWR _4790_/B sky130_fd_sc_hd__dlygate4sd3_1
X_3457_ _3414_/A _3455_/X _3456_/X _3404_/A VGND VGND VPWR VPWR _3457_/X sky130_fd_sc_hd__o22a_2
Xhold1401 _5924_/Q VGND VGND VPWR VPWR _4892_/B2 sky130_fd_sc_hd__dlygate4sd3_1
Xhold2113 _5355_/Q VGND VGND VPWR VPWR _4285_/B2 sky130_fd_sc_hd__dlygate4sd3_1
Xhold2124 _5360_/Q VGND VGND VPWR VPWR _4290_/B2 sky130_fd_sc_hd__dlygate4sd3_1
Xhold2135 _5169_/Q VGND VGND VPWR VPWR _4085_/B2 sky130_fd_sc_hd__dlygate4sd3_1
X_3388_ _3385_/X _3387_/X _3833_/B2 VGND VGND VPWR VPWR _3388_/X sky130_fd_sc_hd__o21a_2
Xhold1412 _5657_/Q VGND VGND VPWR VPWR _4610_/B2 sky130_fd_sc_hd__dlygate4sd3_1
Xhold1423 _5376_/Q VGND VGND VPWR VPWR _4308_/B2 sky130_fd_sc_hd__dlygate4sd3_1
Xhold1434 _5632_/Q VGND VGND VPWR VPWR _4583_/B2 sky130_fd_sc_hd__dlygate4sd3_1
Xhold2146 _5846_/Q VGND VGND VPWR VPWR _4808_/B sky130_fd_sc_hd__dlygate4sd3_1
Xhold2157 _5837_/Q VGND VGND VPWR VPWR _4799_/B sky130_fd_sc_hd__dlygate4sd3_1
Xload_slew670 _3073_/A1 VGND VGND VPWR VPWR _3206_/C1 sky130_fd_sc_hd__clkbuf_4
X_5127_ _5258_/CLK _5127_/D VGND VGND VPWR VPWR _5127_/Q sky130_fd_sc_hd__dfxtp_2
XFILLER_29_148 VGND VGND VPWR VPWR sky130_fd_sc_hd__fill_1
XPHY_EDGE_ROW_2_Right_2 VGND VGND VPWR VPWR sky130_fd_sc_hd__decap_3
Xhold1445 _5772_/Q VGND VGND VPWR VPWR _4732_/B2 sky130_fd_sc_hd__dlygate4sd3_1
Xhold1456 _5161_/Q VGND VGND VPWR VPWR _4077_/B2 sky130_fd_sc_hd__dlygate4sd3_1
Xhold1467 _6018_/Q VGND VGND VPWR VPWR _4992_/B2 sky130_fd_sc_hd__dlygate4sd3_1
X_5058_ _5794_/CLK _5058_/D VGND VGND VPWR VPWR _5058_/Q sky130_fd_sc_hd__dfxtp_2
XFILLER_72_427 VGND VGND VPWR VPWR sky130_fd_sc_hd__fill_1
Xhold1478 _6003_/Q VGND VGND VPWR VPWR _4975_/B2 sky130_fd_sc_hd__dlygate4sd3_1
Xhold1489 _5804_/Q VGND VGND VPWR VPWR _4766_/B2 sky130_fd_sc_hd__dlygate4sd3_1
X_4009_ _4526_/A1 wire540/X _4020_/B1 _4009_/B2 VGND VGND VPWR VPWR _5100_/D sky130_fd_sc_hd__a22o_2
XFILLER_53_630 VGND VGND VPWR VPWR sky130_fd_sc_hd__fill_2
XFILLER_53_641 VGND VGND VPWR VPWR sky130_fd_sc_hd__decap_3
Xclkbuf_leaf_64_clk clkbuf_4_12_0_clk/X VGND VGND VPWR VPWR _6046_/CLK sky130_fd_sc_hd__clkbuf_8
XFILLER_111_33 VGND VGND VPWR VPWR sky130_fd_sc_hd__decap_3
XFILLER_13_505 VGND VGND VPWR VPWR sky130_fd_sc_hd__decap_3
XTAP_TAPCELL_ROW_84_1255 VGND VPWR sky130_fd_sc_hd__tapvpwrvgnd_1
XFILLER_111_66 VGND VGND VPWR VPWR sky130_fd_sc_hd__decap_3
XTAP_TAPCELL_ROW_23_522 VGND VPWR sky130_fd_sc_hd__tapvpwrvgnd_1
XFILLER_111_99 VGND VGND VPWR VPWR sky130_fd_sc_hd__decap_3
XTAP_TAPCELL_ROW_51_864 VGND VPWR sky130_fd_sc_hd__tapvpwrvgnd_1
XPHY_EDGE_ROW_33_Left_149 VGND VGND VPWR VPWR sky130_fd_sc_hd__decap_3
XFILLER_107_654 VGND VGND VPWR VPWR sky130_fd_sc_hd__decap_3
XFILLER_107_676 VGND VGND VPWR VPWR sky130_fd_sc_hd__decap_3
XFILLER_20_85 VGND VGND VPWR VPWR sky130_fd_sc_hd__decap_3
XTAP_TAPCELL_ROW_95_1395 VGND VPWR sky130_fd_sc_hd__tapvpwrvgnd_1
XTAP_TAPCELL_ROW_95_1384 VGND VPWR sky130_fd_sc_hd__tapvpwrvgnd_1
XFILLER_106_197 VGND VGND VPWR VPWR sky130_fd_sc_hd__fill_2
XFILLER_95_508 VGND VGND VPWR VPWR sky130_fd_sc_hd__decap_3
XFILLER_88_582 VGND VGND VPWR VPWR sky130_fd_sc_hd__decap_3
XPHY_EDGE_ROW_42_Left_158 VGND VGND VPWR VPWR sky130_fd_sc_hd__decap_3
XFILLER_48_457 VGND VGND VPWR VPWR sky130_fd_sc_hd__fill_2
XTAP_TAPCELL_ROW_59_953 VGND VPWR sky130_fd_sc_hd__tapvpwrvgnd_1
XFILLER_90_213 VGND VGND VPWR VPWR sky130_fd_sc_hd__decap_3
XTAP_TAPCELL_ROW_3_280 VGND VPWR sky130_fd_sc_hd__tapvpwrvgnd_1
Xhold1990 _5283_/Q VGND VGND VPWR VPWR _4209_/B2 sky130_fd_sc_hd__dlygate4sd3_1
XFILLER_63_438 VGND VGND VPWR VPWR sky130_fd_sc_hd__fill_2
XFILLER_63_449 VGND VGND VPWR VPWR sky130_fd_sc_hd__fill_2
XTAP_TAPCELL_ROW_3_291 VGND VPWR sky130_fd_sc_hd__tapvpwrvgnd_1
Xclkbuf_leaf_55_clk clkload6/A VGND VGND VPWR VPWR _5258_/CLK sky130_fd_sc_hd__clkbuf_8
XFILLER_16_365 VGND VGND VPWR VPWR sky130_fd_sc_hd__decap_3
XFILLER_44_685 VGND VGND VPWR VPWR sky130_fd_sc_hd__decap_3
XFILLER_31_313 VGND VGND VPWR VPWR sky130_fd_sc_hd__decap_3
XPHY_EDGE_ROW_51_Left_167 VGND VGND VPWR VPWR sky130_fd_sc_hd__decap_3
XFILLER_8_553 VGND VGND VPWR VPWR sky130_fd_sc_hd__decap_3
X_2690_ _2690_/A _2690_/B VGND VGND VPWR VPWR _2694_/A sky130_fd_sc_hd__and2_2
XANTENNA_3 _3238_/X VGND VGND VPWR VPWR sky130_fd_sc_hd__diode_2
XFILLER_6_21 VGND VGND VPWR VPWR sky130_fd_sc_hd__decap_3
XFILLER_6_32 VGND VGND VPWR VPWR sky130_fd_sc_hd__decap_3
X_4360_ _5008_/A1 wire465/X _4360_/B1 _4360_/B2 VGND VGND VPWR VPWR _5426_/D sky130_fd_sc_hd__a22o_2
XFILLER_113_602 VGND VGND VPWR VPWR sky130_fd_sc_hd__decap_3
XFILLER_6_98 VGND VGND VPWR VPWR sky130_fd_sc_hd__decap_3
X_3311_ _5371_/Q _5339_/Q _5307_/Q _5275_/Q _3317_/S _3566_/S1 VGND VGND VPWR VPWR
+ _3311_/X sky130_fd_sc_hd__mux4_2
XFILLER_113_635 VGND VGND VPWR VPWR sky130_fd_sc_hd__decap_3
XFILLER_98_357 VGND VGND VPWR VPWR sky130_fd_sc_hd__decap_3
X_4291_ _5007_/A1 _4297_/A2 _4297_/B1 _4291_/B2 VGND VGND VPWR VPWR _5361_/D sky130_fd_sc_hd__a22o_2
XFILLER_113_668 VGND VGND VPWR VPWR sky130_fd_sc_hd__decap_3
XFILLER_113_679 VGND VGND VPWR VPWR sky130_fd_sc_hd__decap_3
XFILLER_98_368 VGND VGND VPWR VPWR sky130_fd_sc_hd__fill_2
XPHY_EDGE_ROW_60_Left_176 VGND VGND VPWR VPWR sky130_fd_sc_hd__decap_3
X_6030_ _6030_/CLK _6030_/D VGND VGND VPWR VPWR _6030_/Q sky130_fd_sc_hd__dfxtp_2
X_3242_ _3784_/A _3237_/X _3241_/X VGND VGND VPWR VPWR _3242_/X sky130_fd_sc_hd__a21o_2
XFILLER_100_318 VGND VGND VPWR VPWR sky130_fd_sc_hd__decap_3
XFILLER_112_178 VGND VGND VPWR VPWR sky130_fd_sc_hd__fill_1
XFILLER_39_413 VGND VGND VPWR VPWR sky130_fd_sc_hd__decap_3
XFILLER_79_582 VGND VGND VPWR VPWR sky130_fd_sc_hd__decap_3
X_3173_ _3175_/A _3169_/X _3172_/X _2572_/A VGND VGND VPWR VPWR _3173_/X sky130_fd_sc_hd__o211a_2
XFILLER_94_541 VGND VGND VPWR VPWR sky130_fd_sc_hd__decap_3
Xfanout1092 fanout1094/X VGND VGND VPWR VPWR _3830_/S sky130_fd_sc_hd__clkdlybuf4s25_1
Xfanout1081 _3818_/S VGND VGND VPWR VPWR _3721_/S sky130_fd_sc_hd__clkdlybuf4s25_1
Xfanout1070 _3880_/S VGND VGND VPWR VPWR _3841_/S sky130_fd_sc_hd__dlymetal6s4s_1
XFILLER_66_265 VGND VGND VPWR VPWR sky130_fd_sc_hd__fill_1
XFILLER_94_585 VGND VGND VPWR VPWR sky130_fd_sc_hd__decap_3
XFILLER_35_641 VGND VGND VPWR VPWR sky130_fd_sc_hd__decap_3
Xclkbuf_leaf_46_clk clkbuf_4_14_0_clk/X VGND VGND VPWR VPWR _5932_/CLK sky130_fd_sc_hd__clkbuf_8
XFILLER_50_600 VGND VGND VPWR VPWR sky130_fd_sc_hd__decap_3
XFILLER_50_633 VGND VGND VPWR VPWR sky130_fd_sc_hd__decap_3
XFILLER_62_493 VGND VGND VPWR VPWR sky130_fd_sc_hd__fill_1
X_5814_ _5925_/CLK _5814_/D VGND VGND VPWR VPWR _5814_/Q sky130_fd_sc_hd__dfxtp_2
XFILLER_22_368 VGND VGND VPWR VPWR sky130_fd_sc_hd__decap_3
XFILLER_10_519 VGND VGND VPWR VPWR sky130_fd_sc_hd__decap_3
X_5745_ _6065_/CLK _5745_/D VGND VGND VPWR VPWR _5745_/Q sky130_fd_sc_hd__dfxtp_2
X_2957_ _5515_/Q _5483_/Q _3069_/S VGND VGND VPWR VPWR _2957_/X sky130_fd_sc_hd__mux2_1
X_5676_ _6049_/CLK _5676_/D VGND VGND VPWR VPWR _5676_/Q sky130_fd_sc_hd__dfxtp_2
X_2888_ _5128_/Q _5096_/Q _6024_/Q _5992_/Q _3166_/S _3164_/S1 VGND VGND VPWR VPWR
+ _2888_/X sky130_fd_sc_hd__mux4_2
XFILLER_108_429 VGND VGND VPWR VPWR sky130_fd_sc_hd__decap_3
X_4627_ _5000_/A1 _4634_/A2 _4634_/B1 _4627_/B2 VGND VGND VPWR VPWR _5674_/D sky130_fd_sc_hd__a22o_2
X_4558_ _4660_/A1 wire421/X _4563_/B1 _4558_/B2 VGND VGND VPWR VPWR _5609_/D sky130_fd_sc_hd__a22o_2
XFILLER_89_335 VGND VGND VPWR VPWR sky130_fd_sc_hd__fill_1
XFILLER_9_9 VGND VGND VPWR VPWR sky130_fd_sc_hd__decap_3
X_4489_ input25/X _4501_/A2 _4501_/B1 _4489_/B2 VGND VGND VPWR VPWR _5545_/D sky130_fd_sc_hd__a22o_2
X_3509_ _3509_/A1 _3506_/X _3508_/X _3753_/A1 VGND VGND VPWR VPWR _3509_/X sky130_fd_sc_hd__a22o_2
XFILLER_103_178 VGND VGND VPWR VPWR sky130_fd_sc_hd__fill_1
XFILLER_106_77 VGND VGND VPWR VPWR sky130_fd_sc_hd__decap_3
XFILLER_57_221 VGND VGND VPWR VPWR sky130_fd_sc_hd__decap_3
Xhold1220 _5688_/Q VGND VGND VPWR VPWR _4643_/B2 sky130_fd_sc_hd__dlygate4sd3_1
Xhold1231 _5335_/Q VGND VGND VPWR VPWR _4263_/B2 sky130_fd_sc_hd__dlygate4sd3_1
Xhold1242 _5516_/Q VGND VGND VPWR VPWR _4458_/B2 sky130_fd_sc_hd__dlygate4sd3_1
XTAP_TAPCELL_ROW_56_923 VGND VPWR sky130_fd_sc_hd__tapvpwrvgnd_1
Xhold1253 _5984_/Q VGND VGND VPWR VPWR _4956_/B2 sky130_fd_sc_hd__dlygate4sd3_1
Xhold1264 _5639_/Q VGND VGND VPWR VPWR _4590_/B2 sky130_fd_sc_hd__dlygate4sd3_1
Xhold1275 _5430_/Q VGND VGND VPWR VPWR _4364_/B2 sky130_fd_sc_hd__dlygate4sd3_1
XFILLER_26_630 VGND VGND VPWR VPWR sky130_fd_sc_hd__decap_3
Xhold1286 _5652_/Q VGND VGND VPWR VPWR _4603_/B2 sky130_fd_sc_hd__dlygate4sd3_1
Xhold1297 _5865_/Q VGND VGND VPWR VPWR _4829_/B2 sky130_fd_sc_hd__dlygate4sd3_1
Xclkbuf_leaf_37_clk clkload4/A VGND VGND VPWR VPWR _6000_/CLK sky130_fd_sc_hd__clkbuf_8
XTAP_TAPCELL_ROW_0_250 VGND VPWR sky130_fd_sc_hd__tapvpwrvgnd_1
XFILLER_41_611 VGND VGND VPWR VPWR sky130_fd_sc_hd__decap_3
XTAP_TAPCELL_ROW_36_680 VGND VPWR sky130_fd_sc_hd__tapvpwrvgnd_1
XFILLER_13_335 VGND VGND VPWR VPWR sky130_fd_sc_hd__fill_1
XFILLER_15_52 VGND VGND VPWR VPWR sky130_fd_sc_hd__decap_3
XFILLER_41_677 VGND VGND VPWR VPWR sky130_fd_sc_hd__fill_1
XFILLER_15_96 VGND VGND VPWR VPWR sky130_fd_sc_hd__decap_3
XTAP_TAPCELL_ROW_97_1413 VGND VPWR sky130_fd_sc_hd__tapvpwrvgnd_1
XFILLER_5_567 VGND VGND VPWR VPWR sky130_fd_sc_hd__decap_3
XFILLER_107_484 VGND VGND VPWR VPWR sky130_fd_sc_hd__decap_3
XFILLER_107_495 VGND VGND VPWR VPWR sky130_fd_sc_hd__fill_1
Xoutput51 _2758_/X VGND VGND VPWR VPWR rd1[10] sky130_fd_sc_hd__dlymetal6s2s_1
XFILLER_110_616 VGND VGND VPWR VPWR sky130_fd_sc_hd__decap_3
Xoutput84 _3505_/X VGND VGND VPWR VPWR rd2[11] sky130_fd_sc_hd__clkbuf_2
Xoutput73 _3208_/X VGND VGND VPWR VPWR rd1[30] sky130_fd_sc_hd__clkbuf_2
Xoutput62 _2985_/X VGND VGND VPWR VPWR rd1[20] sky130_fd_sc_hd__clkbuf_2
XTAP_TAPCELL_ROW_8_350 VGND VPWR sky130_fd_sc_hd__tapvpwrvgnd_1
XFILLER_110_638 VGND VGND VPWR VPWR sky130_fd_sc_hd__decap_3
Xoutput95 _3725_/X VGND VGND VPWR VPWR rd2[21] sky130_fd_sc_hd__dlymetal6s2s_1
XFILLER_76_585 VGND VGND VPWR VPWR sky130_fd_sc_hd__decap_3
XFILLER_36_438 VGND VGND VPWR VPWR sky130_fd_sc_hd__fill_1
XTAP_TAPCELL_ROW_106_1520 VGND VPWR sky130_fd_sc_hd__tapvpwrvgnd_1
Xclkbuf_leaf_28_clk clkbuf_4_10_0_clk/X VGND VGND VPWR VPWR _5871_/CLK sky130_fd_sc_hd__clkbuf_8
XFILLER_44_471 VGND VGND VPWR VPWR sky130_fd_sc_hd__decap_3
XFILLER_91_599 VGND VGND VPWR VPWR sky130_fd_sc_hd__fill_2
X_3860_ _3238_/X _3857_/X _3859_/X VGND VGND VPWR VPWR _3860_/X sky130_fd_sc_hd__a21o_2
XFILLER_72_91 VGND VGND VPWR VPWR sky130_fd_sc_hd__decap_3
X_3791_ _3791_/A1 _3788_/X _3790_/X _3791_/B2 VGND VGND VPWR VPWR _3791_/X sky130_fd_sc_hd__a22o_2
X_2811_ _5829_/Q _5445_/Q _3088_/S VGND VGND VPWR VPWR _2811_/X sky130_fd_sc_hd__mux2_1
XFILLER_75_3 VGND VGND VPWR VPWR sky130_fd_sc_hd__decap_3
X_5530_ _5658_/CLK _5530_/D VGND VGND VPWR VPWR _5530_/Q sky130_fd_sc_hd__dfxtp_2
X_2742_ _5186_/Q _5154_/Q _2743_/S VGND VGND VPWR VPWR _2742_/X sky130_fd_sc_hd__mux2_1
XFILLER_8_361 VGND VGND VPWR VPWR sky130_fd_sc_hd__decap_3
X_5461_ _6069_/CLK _5461_/D VGND VGND VPWR VPWR _5461_/Q sky130_fd_sc_hd__dfxtp_2
X_4412_ _4514_/A1 _4431_/A2 _4431_/B1 _4412_/B2 VGND VGND VPWR VPWR _5472_/D sky130_fd_sc_hd__a22o_2
X_2673_ _5407_/Q _5055_/Q _2924_/S VGND VGND VPWR VPWR _2673_/X sky130_fd_sc_hd__mux2_1
X_5392_ _6059_/CLK _5392_/D VGND VGND VPWR VPWR _5392_/Q sky130_fd_sc_hd__dfxtp_2
XFILLER_98_121 VGND VGND VPWR VPWR sky130_fd_sc_hd__decap_3
XFILLER_99_644 VGND VGND VPWR VPWR sky130_fd_sc_hd__decap_3
XPHY_EDGE_ROW_99_Right_99 VGND VGND VPWR VPWR sky130_fd_sc_hd__decap_3
X_4343_ _5025_/A1 _4365_/A2 _4360_/B1 _4343_/B2 VGND VGND VPWR VPWR _5409_/D sky130_fd_sc_hd__a22o_2
XFILLER_98_165 VGND VGND VPWR VPWR sky130_fd_sc_hd__decap_3
Xfanout318 _3988_/Y VGND VGND VPWR VPWR _4019_/B1 sky130_fd_sc_hd__clkdlybuf4s25_1
Xfanout307 _4059_/Y VGND VGND VPWR VPWR fanout307/X sky130_fd_sc_hd__clkdlybuf4s25_1
X_4274_ _4514_/A1 wire475/X wire255/X _4274_/B2 VGND VGND VPWR VPWR _5344_/D sky130_fd_sc_hd__a22o_2
X_6013_ _6013_/CLK _6013_/D VGND VGND VPWR VPWR _6013_/Q sky130_fd_sc_hd__dfxtp_2
X_3225_ _5143_/Q _5111_/Q _6039_/Q _6007_/Q _3227_/S _3225_/S1 VGND VGND VPWR VPWR
+ _3225_/X sky130_fd_sc_hd__mux4_2
XFILLER_67_552 VGND VGND VPWR VPWR sky130_fd_sc_hd__decap_3
XFILLER_86_349 VGND VGND VPWR VPWR sky130_fd_sc_hd__decap_3
X_3156_ input8/X _3156_/B VGND VGND VPWR VPWR _3156_/X sky130_fd_sc_hd__or2_2
XFILLER_27_427 VGND VGND VPWR VPWR sky130_fd_sc_hd__decap_3
XFILLER_27_449 VGND VGND VPWR VPWR sky130_fd_sc_hd__fill_1
XFILLER_67_596 VGND VGND VPWR VPWR sky130_fd_sc_hd__decap_3
XFILLER_82_533 VGND VGND VPWR VPWR sky130_fd_sc_hd__fill_1
Xclkbuf_leaf_19_clk clkbuf_4_8_0_clk/X VGND VGND VPWR VPWR _5867_/CLK sky130_fd_sc_hd__clkbuf_8
X_3087_ _5841_/Q _5457_/Q _3088_/S VGND VGND VPWR VPWR _3087_/X sky130_fd_sc_hd__mux2_1
XFILLER_42_419 VGND VGND VPWR VPWR sky130_fd_sc_hd__fill_1
XTAP_TAPCELL_ROW_68_1069 VGND VPWR sky130_fd_sc_hd__tapvpwrvgnd_1
XFILLER_23_633 VGND VGND VPWR VPWR sky130_fd_sc_hd__decap_3
XTAP_TAPCELL_ROW_81_1225 VGND VPWR sky130_fd_sc_hd__tapvpwrvgnd_1
XFILLER_23_644 VGND VGND VPWR VPWR sky130_fd_sc_hd__decap_3
XFILLER_22_165 VGND VGND VPWR VPWR sky130_fd_sc_hd__decap_3
XFILLER_50_485 VGND VGND VPWR VPWR sky130_fd_sc_hd__fill_1
XTAP_TAPCELL_ROW_33_650 VGND VPWR sky130_fd_sc_hd__tapvpwrvgnd_1
XTAP_TAPCELL_ROW_61_981 VGND VPWR sky130_fd_sc_hd__tapvpwrvgnd_1
X_5728_ _6062_/CLK _5728_/D VGND VGND VPWR VPWR _5728_/Q sky130_fd_sc_hd__dfxtp_2
X_3989_ _4506_/A1 _4017_/A2 _4017_/B1 _3989_/B2 VGND VGND VPWR VPWR _5080_/D sky130_fd_sc_hd__a22o_2
XFILLER_6_309 VGND VGND VPWR VPWR sky130_fd_sc_hd__decap_3
XFILLER_108_259 VGND VGND VPWR VPWR sky130_fd_sc_hd__decap_3
XPHY_EDGE_ROW_107_Left_223 VGND VGND VPWR VPWR sky130_fd_sc_hd__decap_3
X_5659_ _5659_/CLK _5659_/D VGND VGND VPWR VPWR _5659_/Q sky130_fd_sc_hd__dfxtp_2
XTAP_TAPCELL_ROW_79_1198 VGND VPWR sky130_fd_sc_hd__tapvpwrvgnd_1
XFILLER_7_6 VGND VGND VPWR VPWR sky130_fd_sc_hd__decap_3
XTAP_TAPCELL_ROW_92_1354 VGND VPWR sky130_fd_sc_hd__tapvpwrvgnd_1
Xfanout852 _2724_/S0 VGND VGND VPWR VPWR _3093_/S sky130_fd_sc_hd__dlymetal6s2s_1
Xfanout841 _3155_/S0 VGND VGND VPWR VPWR _3204_/S sky130_fd_sc_hd__clkbuf_2
Xfanout885 input43/X VGND VGND VPWR VPWR _5020_/A1 sky130_fd_sc_hd__clkdlybuf4s25_1
Xfanout874 input46/X VGND VGND VPWR VPWR _5023_/A1 sky130_fd_sc_hd__clkdlybuf4s25_1
Xfanout863 input6/X VGND VGND VPWR VPWR fanout863/X sky130_fd_sc_hd__buf_6
Xclkbuf_4_13_0_clk clkbuf_0_clk/X VGND VGND VPWR VPWR clkload6/A sky130_fd_sc_hd__clkbuf_8
XFILLER_18_416 VGND VGND VPWR VPWR sky130_fd_sc_hd__decap_3
XFILLER_58_585 VGND VGND VPWR VPWR sky130_fd_sc_hd__decap_3
XFILLER_93_24 VGND VGND VPWR VPWR sky130_fd_sc_hd__fill_2
Xfanout896 input41/X VGND VGND VPWR VPWR _5047_/A1 sky130_fd_sc_hd__clkdlybuf4s25_1
XFILLER_73_533 VGND VGND VPWR VPWR sky130_fd_sc_hd__fill_1
XFILLER_93_57 VGND VGND VPWR VPWR sky130_fd_sc_hd__decap_3
XFILLER_14_622 VGND VGND VPWR VPWR sky130_fd_sc_hd__decap_3
XFILLER_14_666 VGND VGND VPWR VPWR sky130_fd_sc_hd__decap_3
XFILLER_13_143 VGND VGND VPWR VPWR sky130_fd_sc_hd__decap_3
XFILLER_41_452 VGND VGND VPWR VPWR sky130_fd_sc_hd__decap_3
XFILLER_9_147 VGND VGND VPWR VPWR sky130_fd_sc_hd__fill_2
XTAP_TAPCELL_ROW_101_1461 VGND VPWR sky130_fd_sc_hd__tapvpwrvgnd_1
XTAP_TAPCELL_ROW_11_377 VGND VPWR sky130_fd_sc_hd__tapvpwrvgnd_1
XFILLER_107_270 VGND VGND VPWR VPWR sky130_fd_sc_hd__decap_3
XFILLER_107_281 VGND VGND VPWR VPWR sky130_fd_sc_hd__decap_3
XFILLER_3_33 VGND VGND VPWR VPWR sky130_fd_sc_hd__decap_3
XFILLER_68_305 VGND VGND VPWR VPWR sky130_fd_sc_hd__decap_3
XFILLER_95_113 VGND VGND VPWR VPWR sky130_fd_sc_hd__decap_3
XFILLER_96_625 VGND VGND VPWR VPWR sky130_fd_sc_hd__decap_3
XFILLER_1_581 VGND VGND VPWR VPWR sky130_fd_sc_hd__decap_3
XFILLER_3_66 VGND VGND VPWR VPWR sky130_fd_sc_hd__decap_3
XFILLER_49_541 VGND VGND VPWR VPWR sky130_fd_sc_hd__fill_1
XTAP_TAPCELL_ROW_112_1590 VGND VPWR sky130_fd_sc_hd__tapvpwrvgnd_1
XFILLER_67_91 VGND VGND VPWR VPWR sky130_fd_sc_hd__decap_3
X_3010_ _6062_/Q _5966_/Q _3015_/S VGND VGND VPWR VPWR _3010_/X sky130_fd_sc_hd__mux2_1
XFILLER_36_213 VGND VGND VPWR VPWR sky130_fd_sc_hd__fill_1
XFILLER_64_533 VGND VGND VPWR VPWR sky130_fd_sc_hd__fill_1
XFILLER_36_279 VGND VGND VPWR VPWR sky130_fd_sc_hd__decap_3
XFILLER_51_205 VGND VGND VPWR VPWR sky130_fd_sc_hd__decap_3
XTAP_TAPCELL_ROW_19_477 VGND VPWR sky130_fd_sc_hd__tapvpwrvgnd_1
Xload_slew1091 _3363_/S VGND VGND VPWR VPWR _3821_/S sky130_fd_sc_hd__clkbuf_4
X_4961_ _4995_/A1 _4947_/B _4978_/B1 _4961_/B2 VGND VGND VPWR VPWR _5989_/D sky130_fd_sc_hd__a22o_2
X_4892_ _4926_/A1 _4910_/A2 _4908_/B1 _4892_/B2 VGND VGND VPWR VPWR _5924_/D sky130_fd_sc_hd__a22o_2
X_3912_ _3918_/A _3912_/B VGND VGND VPWR VPWR _3912_/X sky130_fd_sc_hd__or2_2
X_3843_ _2494_/Y _3839_/X _3842_/X _3843_/C1 VGND VGND VPWR VPWR _3843_/X sky130_fd_sc_hd__o211a_2
X_3774_ _5520_/Q _5488_/Q _3774_/S VGND VGND VPWR VPWR _3774_/X sky130_fd_sc_hd__mux2_1
XFILLER_8_180 VGND VGND VPWR VPWR sky130_fd_sc_hd__decap_3
X_5513_ _5513_/CLK _5513_/D VGND VGND VPWR VPWR _5513_/Q sky130_fd_sc_hd__dfxtp_2
X_2725_ _5505_/Q _5473_/Q _2975_/S VGND VGND VPWR VPWR _2725_/X sky130_fd_sc_hd__mux2_1
Xclkbuf_leaf_8_clk clkbuf_4_2_0_clk/X VGND VGND VPWR VPWR _5571_/CLK sky130_fd_sc_hd__clkbuf_8
X_5444_ _5956_/CLK _5444_/D VGND VGND VPWR VPWR _5444_/Q sky130_fd_sc_hd__dfxtp_2
X_2656_ wire647/X _2654_/X _2655_/X _3111_/B2 VGND VGND VPWR VPWR _2656_/X sky130_fd_sc_hd__o22a_2
X_5375_ _5578_/CLK _5375_/D VGND VGND VPWR VPWR _5375_/Q sky130_fd_sc_hd__dfxtp_2
X_2587_ _2987_/A _2587_/B VGND VGND VPWR VPWR _2587_/X sky130_fd_sc_hd__or2_2
XFILLER_59_316 VGND VGND VPWR VPWR sky130_fd_sc_hd__decap_3
XFILLER_86_102 VGND VGND VPWR VPWR sky130_fd_sc_hd__decap_3
XFILLER_99_485 VGND VGND VPWR VPWR sky130_fd_sc_hd__decap_3
Xfanout137 _4913_/Y VGND VGND VPWR VPWR _4945_/B1 sky130_fd_sc_hd__clkdlybuf4s25_1
Xfanout126 _4947_/Y VGND VGND VPWR VPWR _4964_/B1 sky130_fd_sc_hd__clkdlybuf4s25_1
X_4326_ _4738_/A1 _4329_/A2 _4329_/B1 _4326_/B2 VGND VGND VPWR VPWR _5394_/D sky130_fd_sc_hd__a22o_2
XFILLER_113_284 VGND VGND VPWR VPWR sky130_fd_sc_hd__fill_2
XFILLER_87_669 VGND VGND VPWR VPWR sky130_fd_sc_hd__decap_3
Xfanout159 _4745_/Y VGND VGND VPWR VPWR _4775_/B1 sky130_fd_sc_hd__clkdlybuf4s25_1
Xfanout148 _4845_/Y VGND VGND VPWR VPWR _4861_/B1 sky130_fd_sc_hd__clkdlybuf4s25_1
X_4257_ _5007_/A1 _4263_/A2 _4263_/B1 _4257_/B2 VGND VGND VPWR VPWR _5329_/D sky130_fd_sc_hd__a22o_2
X_4188_ _4531_/A1 _4188_/A2 _4191_/B1 _4188_/B2 VGND VGND VPWR VPWR _5265_/D sky130_fd_sc_hd__a22o_2
X_3208_ _3196_/X _3206_/X _3207_/X wire570/X VGND VGND VPWR VPWR _3208_/X sky130_fd_sc_hd__o31a_2
XFILLER_103_12 VGND VGND VPWR VPWR sky130_fd_sc_hd__decap_3
X_3139_ _2611_/A _3136_/X _3138_/X wire659/X VGND VGND VPWR VPWR _3139_/X sky130_fd_sc_hd__a22o_2
XFILLER_27_279 VGND VGND VPWR VPWR sky130_fd_sc_hd__fill_1
XFILLER_55_599 VGND VGND VPWR VPWR sky130_fd_sc_hd__decap_3
XFILLER_63_38 VGND VGND VPWR VPWR sky130_fd_sc_hd__decap_3
XFILLER_70_558 VGND VGND VPWR VPWR sky130_fd_sc_hd__decap_3
XFILLER_23_452 VGND VGND VPWR VPWR sky130_fd_sc_hd__fill_2
XFILLER_11_658 VGND VGND VPWR VPWR sky130_fd_sc_hd__decap_3
XFILLER_7_629 VGND VGND VPWR VPWR sky130_fd_sc_hd__decap_3
Xwire516 wire516/A VGND VGND VPWR VPWR wire516/X sky130_fd_sc_hd__buf_4
XFILLER_12_53 VGND VGND VPWR VPWR sky130_fd_sc_hd__decap_3
XFILLER_12_97 VGND VGND VPWR VPWR sky130_fd_sc_hd__fill_1
XFILLER_2_345 VGND VGND VPWR VPWR sky130_fd_sc_hd__decap_3
XFILLER_5_3 VGND VGND VPWR VPWR sky130_fd_sc_hd__decap_3
XFILLER_77_113 VGND VGND VPWR VPWR sky130_fd_sc_hd__decap_3
XFILLER_77_124 VGND VGND VPWR VPWR sky130_fd_sc_hd__fill_1
XFILLER_77_146 VGND VGND VPWR VPWR sky130_fd_sc_hd__decap_3
XFILLER_78_658 VGND VGND VPWR VPWR sky130_fd_sc_hd__decap_3
Xfanout660 _3027_/B2 VGND VGND VPWR VPWR _2755_/B2 sky130_fd_sc_hd__clkdlybuf4s25_1
XFILLER_93_617 VGND VGND VPWR VPWR sky130_fd_sc_hd__fill_1
Xfanout682 wire685/A VGND VGND VPWR VPWR _2886_/A1 sky130_fd_sc_hd__buf_6
Xfanout671 fanout671/A VGND VGND VPWR VPWR _3230_/A1 sky130_fd_sc_hd__clkdlybuf4s25_1
XFILLER_46_533 VGND VGND VPWR VPWR sky130_fd_sc_hd__decap_3
XFILLER_73_396 VGND VGND VPWR VPWR sky130_fd_sc_hd__fill_1
XTAP_TAPCELL_ROW_16_436 VGND VPWR sky130_fd_sc_hd__tapvpwrvgnd_1
XTAP_TAPCELL_ROW_16_447 VGND VPWR sky130_fd_sc_hd__tapvpwrvgnd_1
XTAP_TAPCELL_ROW_44_778 VGND VPWR sky130_fd_sc_hd__tapvpwrvgnd_1
XFILLER_115_505 VGND VGND VPWR VPWR sky130_fd_sc_hd__decap_3
XFILLER_115_516 VGND VGND VPWR VPWR sky130_fd_sc_hd__decap_3
X_3490_ _5379_/Q _5347_/Q _5315_/Q _5283_/Q _3501_/S _3615_/S1 VGND VGND VPWR VPWR
+ _3490_/X sky130_fd_sc_hd__mux4_2
X_2510_ _5816_/Q _5432_/Q _2510_/S VGND VGND VPWR VPWR _2510_/X sky130_fd_sc_hd__mux2_1
XFILLER_5_172 VGND VGND VPWR VPWR sky130_fd_sc_hd__decap_3
XFILLER_6_684 VGND VGND VPWR VPWR sky130_fd_sc_hd__decap_3
X_5160_ _5525_/CLK _5160_/D VGND VGND VPWR VPWR _5160_/Q sky130_fd_sc_hd__dfxtp_2
XFILLER_96_433 VGND VGND VPWR VPWR sky130_fd_sc_hd__decap_3
Xhold1808 _5102_/Q VGND VGND VPWR VPWR _4011_/B2 sky130_fd_sc_hd__dlygate4sd3_1
X_5091_ _6019_/CLK _5091_/D VGND VGND VPWR VPWR _5091_/Q sky130_fd_sc_hd__dfxtp_2
X_4111_ _4998_/A1 _4111_/A2 _4112_/B1 _4111_/B2 VGND VGND VPWR VPWR _5192_/D sky130_fd_sc_hd__a22o_2
XFILLER_84_628 VGND VGND VPWR VPWR sky130_fd_sc_hd__fill_1
Xhold1819 _5949_/Q VGND VGND VPWR VPWR _4919_/B2 sky130_fd_sc_hd__dlygate4sd3_1
X_4042_ _4695_/A1 wire533/X _4055_/B1 _4042_/B2 VGND VGND VPWR VPWR _5130_/D sky130_fd_sc_hd__a22o_2
XTAP_TAPCELL_ROW_65_1028 VGND VPWR sky130_fd_sc_hd__tapvpwrvgnd_1
X_5993_ clkload8/A _5993_/D VGND VGND VPWR VPWR _5993_/Q sky130_fd_sc_hd__dfxtp_2
X_4944_ _5046_/A1 wire353/X wire136/X _4944_/B2 VGND VGND VPWR VPWR _5974_/D sky130_fd_sc_hd__a22o_2
XFILLER_32_271 VGND VGND VPWR VPWR sky130_fd_sc_hd__fill_1
X_4875_ _4943_/A1 _4875_/A2 _4875_/B1 _4875_/B2 VGND VGND VPWR VPWR _5909_/D sky130_fd_sc_hd__a22o_2
X_3826_ _5842_/Q _5458_/Q _6066_/Q _5970_/Q _3558_/S _3826_/S1 VGND VGND VPWR VPWR
+ _3826_/X sky130_fd_sc_hd__mux4_2
X_3757_ _3872_/A _3755_/X _3756_/X _3763_/A VGND VGND VPWR VPWR _3757_/X sky130_fd_sc_hd__o22a_2
X_2708_ _5792_/Q _5728_/Q _2708_/S VGND VGND VPWR VPWR _2708_/X sky130_fd_sc_hd__mux2_1
XFILLER_106_527 VGND VGND VPWR VPWR sky130_fd_sc_hd__decap_3
XFILLER_109_9 VGND VGND VPWR VPWR sky130_fd_sc_hd__decap_3
XFILLER_3_109 VGND VGND VPWR VPWR sky130_fd_sc_hd__decap_3
XTAP_TAPCELL_ROW_76_1157 VGND VPWR sky130_fd_sc_hd__tapvpwrvgnd_1
X_3688_ _5580_/Q _5548_/Q _3693_/S VGND VGND VPWR VPWR _3688_/X sky130_fd_sc_hd__mux2_1
X_5427_ _5813_/CLK _5427_/D VGND VGND VPWR VPWR _5427_/Q sky130_fd_sc_hd__dfxtp_2
X_2639_ _3105_/B2 _2637_/X _2638_/X _3105_/A1 VGND VGND VPWR VPWR _2639_/X sky130_fd_sc_hd__o22a_2
XFILLER_114_571 VGND VGND VPWR VPWR sky130_fd_sc_hd__decap_3
X_5358_ _5838_/CLK _5358_/D VGND VGND VPWR VPWR _5358_/Q sky130_fd_sc_hd__dfxtp_2
XFILLER_99_293 VGND VGND VPWR VPWR sky130_fd_sc_hd__decap_3
X_4309_ _4515_/A1 _4299_/B _4318_/B1 _4309_/B2 VGND VGND VPWR VPWR _5377_/D sky130_fd_sc_hd__a22o_2
XFILLER_75_617 VGND VGND VPWR VPWR sky130_fd_sc_hd__fill_1
XFILLER_87_466 VGND VGND VPWR VPWR sky130_fd_sc_hd__fill_1
Xwire1038 wire1038/A VGND VGND VPWR VPWR _3878_/S1 sky130_fd_sc_hd__clkbuf_4
X_5289_ _5824_/CLK _5289_/D VGND VGND VPWR VPWR _5289_/Q sky130_fd_sc_hd__dfxtp_2
XFILLER_114_44 VGND VGND VPWR VPWR sky130_fd_sc_hd__decap_3
XFILLER_28_533 VGND VGND VPWR VPWR sky130_fd_sc_hd__decap_3
XFILLER_75_639 VGND VGND VPWR VPWR sky130_fd_sc_hd__decap_3
XFILLER_114_77 VGND VGND VPWR VPWR sky130_fd_sc_hd__decap_3
XFILLER_114_88 VGND VGND VPWR VPWR sky130_fd_sc_hd__decap_3
XFILLER_43_503 VGND VGND VPWR VPWR sky130_fd_sc_hd__fill_1
XFILLER_55_374 VGND VGND VPWR VPWR sky130_fd_sc_hd__fill_1
XTAP_TAPCELL_ROW_87_1297 VGND VPWR sky130_fd_sc_hd__tapvpwrvgnd_1
XTAP_TAPCELL_ROW_13_406 VGND VPWR sky130_fd_sc_hd__tapvpwrvgnd_1
XTAP_TAPCELL_ROW_41_737 VGND VPWR sky130_fd_sc_hd__tapvpwrvgnd_1
XFILLER_23_52 VGND VGND VPWR VPWR sky130_fd_sc_hd__decap_3
XFILLER_11_488 VGND VGND VPWR VPWR sky130_fd_sc_hd__decap_3
XFILLER_99_12 VGND VGND VPWR VPWR sky130_fd_sc_hd__decap_3
XFILLER_3_610 VGND VGND VPWR VPWR sky130_fd_sc_hd__decap_3
XFILLER_3_632 VGND VGND VPWR VPWR sky130_fd_sc_hd__decap_3
XFILLER_3_665 VGND VGND VPWR VPWR sky130_fd_sc_hd__decap_3
XFILLER_3_676 VGND VGND VPWR VPWR sky130_fd_sc_hd__decap_3
Xload_slew329 _5038_/A2 VGND VGND VPWR VPWR _5043_/A2 sky130_fd_sc_hd__clkbuf_4
XFILLER_2_197 VGND VGND VPWR VPWR sky130_fd_sc_hd__fill_1
XFILLER_24_9 VGND VGND VPWR VPWR sky130_fd_sc_hd__fill_1
XFILLER_78_488 VGND VGND VPWR VPWR sky130_fd_sc_hd__decap_3
XFILLER_48_82 VGND VGND VPWR VPWR sky130_fd_sc_hd__fill_2
XFILLER_65_116 VGND VGND VPWR VPWR sky130_fd_sc_hd__decap_3
XTAP_TAPCELL_ROW_49_837 VGND VPWR sky130_fd_sc_hd__tapvpwrvgnd_1
Xfanout490 _4196_/Y VGND VGND VPWR VPWR _4227_/A2 sky130_fd_sc_hd__clkdlybuf4s25_1
XFILLER_0_12 VGND VGND VPWR VPWR sky130_fd_sc_hd__decap_3
XFILLER_19_555 VGND VGND VPWR VPWR sky130_fd_sc_hd__decap_3
XFILLER_19_588 VGND VGND VPWR VPWR sky130_fd_sc_hd__fill_1
XFILLER_46_363 VGND VGND VPWR VPWR sky130_fd_sc_hd__fill_1
XFILLER_74_683 VGND VGND VPWR VPWR sky130_fd_sc_hd__decap_3
XFILLER_34_558 VGND VGND VPWR VPWR sky130_fd_sc_hd__fill_1
XFILLER_46_396 VGND VGND VPWR VPWR sky130_fd_sc_hd__fill_2
XFILLER_73_182 VGND VGND VPWR VPWR sky130_fd_sc_hd__decap_3
XTAP_TAPCELL_ROW_29_594 VGND VPWR sky130_fd_sc_hd__tapvpwrvgnd_1
XFILLER_9_21 VGND VGND VPWR VPWR sky130_fd_sc_hd__decap_3
X_2990_ _2990_/A1 _2988_/X _2989_/X wire643/X VGND VGND VPWR VPWR _2990_/X sky130_fd_sc_hd__o22a_2
XFILLER_61_388 VGND VGND VPWR VPWR sky130_fd_sc_hd__decap_3
XFILLER_9_54 VGND VGND VPWR VPWR sky130_fd_sc_hd__fill_2
X_4660_ _4660_/A1 wire400/X wire179/X _4660_/B2 VGND VGND VPWR VPWR _5705_/D sky130_fd_sc_hd__a22o_2
X_3611_ _3611_/A1 _3608_/X _3610_/X _3611_/B2 VGND VGND VPWR VPWR _3611_/X sky130_fd_sc_hd__o22a_2
X_4591_ _4659_/A1 _4591_/A2 _4591_/B1 _4591_/B2 VGND VGND VPWR VPWR _5640_/D sky130_fd_sc_hd__a22o_2
X_3542_ _5189_/Q _5157_/Q _3575_/S VGND VGND VPWR VPWR _3542_/X sky130_fd_sc_hd__mux2_1
X_3473_ _5122_/Q _5090_/Q _6018_/Q _5986_/Q _3475_/S _3929_/S1 VGND VGND VPWR VPWR
+ _3473_/X sky130_fd_sc_hd__mux4_2
XFILLER_69_411 VGND VGND VPWR VPWR sky130_fd_sc_hd__fill_1
X_5212_ _6012_/CLK _5212_/D VGND VGND VPWR VPWR _5212_/Q sky130_fd_sc_hd__dfxtp_2
Xload_slew830 _3193_/S VGND VGND VPWR VPWR _2789_/S sky130_fd_sc_hd__buf_4
X_5143_ _6055_/CLK _5143_/D VGND VGND VPWR VPWR _5143_/Q sky130_fd_sc_hd__dfxtp_2
XFILLER_29_319 VGND VGND VPWR VPWR sky130_fd_sc_hd__decap_3
XFILLER_57_617 VGND VGND VPWR VPWR sky130_fd_sc_hd__decap_3
Xhold1605 _5278_/Q VGND VGND VPWR VPWR _4204_/B2 sky130_fd_sc_hd__dlygate4sd3_1
Xhold1616 _5625_/Q VGND VGND VPWR VPWR _4576_/B2 sky130_fd_sc_hd__dlygate4sd3_1
XFILLER_111_596 VGND VGND VPWR VPWR sky130_fd_sc_hd__decap_3
XTAP_TAPCELL_ROW_71_1098 VGND VPWR sky130_fd_sc_hd__tapvpwrvgnd_1
Xhold1627 _5053_/Q VGND VGND VPWR VPWR _3957_/B2 sky130_fd_sc_hd__dlygate4sd3_1
Xhold1638 _5512_/Q VGND VGND VPWR VPWR _4454_/B2 sky130_fd_sc_hd__dlygate4sd3_1
Xhold1649 _5788_/Q VGND VGND VPWR VPWR _4750_/B2 sky130_fd_sc_hd__dlygate4sd3_1
X_5074_ _5810_/CLK _5074_/D VGND VGND VPWR VPWR _5074_/Q sky130_fd_sc_hd__dfxtp_2
X_4025_ _4507_/A1 _4053_/A2 _4053_/B1 _4025_/B2 VGND VGND VPWR VPWR _5113_/D sky130_fd_sc_hd__a22o_2
XFILLER_25_514 VGND VGND VPWR VPWR sky130_fd_sc_hd__decap_3
XFILLER_71_119 VGND VGND VPWR VPWR sky130_fd_sc_hd__decap_3
XFILLER_25_558 VGND VGND VPWR VPWR sky130_fd_sc_hd__fill_2
XFILLER_37_396 VGND VGND VPWR VPWR sky130_fd_sc_hd__decap_3
XFILLER_80_631 VGND VGND VPWR VPWR sky130_fd_sc_hd__decap_3
XFILLER_92_491 VGND VGND VPWR VPWR sky130_fd_sc_hd__decap_3
XFILLER_80_664 VGND VGND VPWR VPWR sky130_fd_sc_hd__decap_3
X_5976_ _6036_/CLK _5976_/D VGND VGND VPWR VPWR _5976_/Q sky130_fd_sc_hd__dfxtp_2
X_4927_ _4927_/A1 wire355/X wire136/A _4927_/B2 VGND VGND VPWR VPWR _5957_/D sky130_fd_sc_hd__a22o_2
X_4858_ _4926_/A1 _4876_/A2 _4874_/B1 _4858_/B2 VGND VGND VPWR VPWR _5892_/D sky130_fd_sc_hd__a22o_2
X_3809_ _5265_/Q _5233_/Q _3810_/S VGND VGND VPWR VPWR _3809_/X sky130_fd_sc_hd__mux2_1
X_4789_ _4795_/A_N _4789_/B VGND VGND VPWR VPWR _5827_/D sky130_fd_sc_hd__and2b_2
XFILLER_106_324 VGND VGND VPWR VPWR sky130_fd_sc_hd__decap_3
XFILLER_109_33 VGND VGND VPWR VPWR sky130_fd_sc_hd__decap_3
XFILLER_109_66 VGND VGND VPWR VPWR sky130_fd_sc_hd__decap_3
XFILLER_109_99 VGND VGND VPWR VPWR sky130_fd_sc_hd__decap_3
XFILLER_106_368 VGND VGND VPWR VPWR sky130_fd_sc_hd__decap_3
XFILLER_102_530 VGND VGND VPWR VPWR sky130_fd_sc_hd__fill_2
XFILLER_0_657 VGND VGND VPWR VPWR sky130_fd_sc_hd__decap_3
XFILLER_0_679 VGND VGND VPWR VPWR sky130_fd_sc_hd__decap_3
XFILLER_87_263 VGND VGND VPWR VPWR sky130_fd_sc_hd__fill_1
XTAP_TAPCELL_ROW_89_1315 VGND VPWR sky130_fd_sc_hd__tapvpwrvgnd_1
XFILLER_18_41 VGND VGND VPWR VPWR sky130_fd_sc_hd__fill_2
XFILLER_47_149 VGND VGND VPWR VPWR sky130_fd_sc_hd__decap_3
XTAP_TAPCELL_ROW_46_807 VGND VPWR sky130_fd_sc_hd__tapvpwrvgnd_1
XFILLER_18_85 VGND VGND VPWR VPWR sky130_fd_sc_hd__decap_3
XFILLER_90_439 VGND VGND VPWR VPWR sky130_fd_sc_hd__fill_2
XFILLER_71_642 VGND VGND VPWR VPWR sky130_fd_sc_hd__fill_2
XFILLER_83_480 VGND VGND VPWR VPWR sky130_fd_sc_hd__decap_3
XFILLER_70_152 VGND VGND VPWR VPWR sky130_fd_sc_hd__fill_1
XTAP_TAPCELL_ROW_26_564 VGND VPWR sky130_fd_sc_hd__tapvpwrvgnd_1
XFILLER_31_539 VGND VGND VPWR VPWR sky130_fd_sc_hd__decap_3
XTAP_TAPCELL_ROW_54_895 VGND VPWR sky130_fd_sc_hd__tapvpwrvgnd_1
XFILLER_50_61 VGND VGND VPWR VPWR sky130_fd_sc_hd__decap_3
XFILLER_109_184 VGND VGND VPWR VPWR sky130_fd_sc_hd__decap_3
XFILLER_98_506 VGND VGND VPWR VPWR sky130_fd_sc_hd__fill_1
XFILLER_112_338 VGND VGND VPWR VPWR sky130_fd_sc_hd__fill_1
XFILLER_38_105 VGND VGND VPWR VPWR sky130_fd_sc_hd__fill_1
XFILLER_93_200 VGND VGND VPWR VPWR sky130_fd_sc_hd__decap_3
XFILLER_38_149 VGND VGND VPWR VPWR sky130_fd_sc_hd__fill_2
XFILLER_19_352 VGND VGND VPWR VPWR sky130_fd_sc_hd__decap_3
XTAP_TAPCELL_ROW_109_1562 VGND VPWR sky130_fd_sc_hd__tapvpwrvgnd_1
XFILLER_34_355 VGND VGND VPWR VPWR sky130_fd_sc_hd__decap_3
X_5830_ _6043_/CLK _5830_/D VGND VGND VPWR VPWR _5830_/Q sky130_fd_sc_hd__dfxtp_2
XFILLER_34_399 VGND VGND VPWR VPWR sky130_fd_sc_hd__decap_3
X_5761_ _5932_/CLK _5761_/D VGND VGND VPWR VPWR _5761_/Q sky130_fd_sc_hd__dfxtp_2
X_2973_ _5708_/Q _5676_/Q _5644_/Q _5612_/Q _2732_/S _2973_/S1 VGND VGND VPWR VPWR
+ _2973_/X sky130_fd_sc_hd__mux4_2
XFILLER_15_591 VGND VGND VPWR VPWR sky130_fd_sc_hd__decap_3
X_4712_ _4880_/A1 _4742_/A2 _4740_/B1 _4712_/B2 VGND VGND VPWR VPWR _5752_/D sky130_fd_sc_hd__a22o_2
X_5692_ _5692_/CLK _5692_/D VGND VGND VPWR VPWR _5692_/Q sky130_fd_sc_hd__dfxtp_2
X_4643_ _4880_/A1 wire400/A wire179/X _4643_/B2 VGND VGND VPWR VPWR _5688_/D sky130_fd_sc_hd__a22o_2
X_4574_ _4913_/A _4574_/B VGND VGND VPWR VPWR _4574_/Y sky130_fd_sc_hd__nor2_2
XFILLER_115_121 VGND VGND VPWR VPWR sky130_fd_sc_hd__decap_3
X_3525_ _3872_/A _3523_/X _3524_/X _3763_/A VGND VGND VPWR VPWR _3525_/X sky130_fd_sc_hd__o22a_2
XFILLER_115_176 VGND VGND VPWR VPWR sky130_fd_sc_hd__decap_3
XTAP_TAPCELL_ROW_73_1127 VGND VPWR sky130_fd_sc_hd__tapvpwrvgnd_1
Xhold2103 _5690_/Q VGND VGND VPWR VPWR _4645_/B2 sky130_fd_sc_hd__dlygate4sd3_1
X_3456_ _5793_/Q _5729_/Q _3683_/S VGND VGND VPWR VPWR _3456_/X sky130_fd_sc_hd__mux2_1
XFILLER_97_550 VGND VGND VPWR VPWR sky130_fd_sc_hd__fill_1
Xhold2114 _5209_/Q VGND VGND VPWR VPWR _4130_/B2 sky130_fd_sc_hd__dlygate4sd3_1
Xhold2125 _5267_/Q VGND VGND VPWR VPWR _4190_/B2 sky130_fd_sc_hd__dlygate4sd3_1
Xhold2136 _5824_/Q VGND VGND VPWR VPWR _4786_/B sky130_fd_sc_hd__dlygate4sd3_1
X_3387_ _3708_/A1 _3383_/X _3386_/X _3881_/B2 VGND VGND VPWR VPWR _3387_/X sky130_fd_sc_hd__a22o_2
XFILLER_29_116 VGND VGND VPWR VPWR sky130_fd_sc_hd__decap_3
XFILLER_84_200 VGND VGND VPWR VPWR sky130_fd_sc_hd__decap_3
Xhold1402 _6061_/Q VGND VGND VPWR VPWR _5037_/B2 sky130_fd_sc_hd__dlygate4sd3_1
Xhold1413 _5907_/Q VGND VGND VPWR VPWR _4873_/B2 sky130_fd_sc_hd__dlygate4sd3_1
Xhold1424 _5813_/Q VGND VGND VPWR VPWR _4775_/B2 sky130_fd_sc_hd__dlygate4sd3_1
Xhold2147 _5817_/Q VGND VGND VPWR VPWR _4779_/B sky130_fd_sc_hd__dlygate4sd3_1
Xhold2158 _5826_/Q VGND VGND VPWR VPWR _4788_/B sky130_fd_sc_hd__dlygate4sd3_1
X_5126_ _6066_/CLK _5126_/D VGND VGND VPWR VPWR _5126_/Q sky130_fd_sc_hd__dfxtp_2
XFILLER_111_393 VGND VGND VPWR VPWR sky130_fd_sc_hd__decap_3
Xhold1435 _5689_/Q VGND VGND VPWR VPWR _4644_/B2 sky130_fd_sc_hd__dlygate4sd3_1
Xhold1446 _5789_/Q VGND VGND VPWR VPWR _4751_/B2 sky130_fd_sc_hd__dlygate4sd3_1
Xhold1457 _5600_/Q VGND VGND VPWR VPWR _4549_/B2 sky130_fd_sc_hd__dlygate4sd3_1
Xhold1468 _5791_/Q VGND VGND VPWR VPWR _4753_/B2 sky130_fd_sc_hd__dlygate4sd3_1
X_5057_ _5804_/CLK _5057_/D VGND VGND VPWR VPWR _5057_/Q sky130_fd_sc_hd__dfxtp_2
XFILLER_55_39 VGND VGND VPWR VPWR sky130_fd_sc_hd__fill_1
Xhold1479 _5424_/Q VGND VGND VPWR VPWR _4358_/B2 sky130_fd_sc_hd__dlygate4sd3_1
X_4008_ _4525_/A1 _3988_/B _4017_/B1 _4008_/B2 VGND VGND VPWR VPWR _5099_/D sky130_fd_sc_hd__a22o_2
XFILLER_111_12 VGND VGND VPWR VPWR sky130_fd_sc_hd__decap_3
XFILLER_37_182 VGND VGND VPWR VPWR sky130_fd_sc_hd__decap_3
XFILLER_111_45 VGND VGND VPWR VPWR sky130_fd_sc_hd__decap_3
XFILLER_25_355 VGND VGND VPWR VPWR sky130_fd_sc_hd__decap_3
XFILLER_52_141 VGND VGND VPWR VPWR sky130_fd_sc_hd__fill_1
XTAP_TAPCELL_ROW_84_1256 VGND VPWR sky130_fd_sc_hd__tapvpwrvgnd_1
XFILLER_111_78 VGND VGND VPWR VPWR sky130_fd_sc_hd__decap_3
XFILLER_80_483 VGND VGND VPWR VPWR sky130_fd_sc_hd__decap_3
XTAP_TAPCELL_ROW_23_523 VGND VPWR sky130_fd_sc_hd__tapvpwrvgnd_1
X_5959_ _6017_/CLK _5959_/D VGND VGND VPWR VPWR _5959_/Q sky130_fd_sc_hd__dfxtp_2
XTAP_TAPCELL_ROW_51_865 VGND VPWR sky130_fd_sc_hd__tapvpwrvgnd_1
XFILLER_21_561 VGND VGND VPWR VPWR sky130_fd_sc_hd__fill_1
XFILLER_105_3 VGND VGND VPWR VPWR sky130_fd_sc_hd__decap_3
XFILLER_106_165 VGND VGND VPWR VPWR sky130_fd_sc_hd__decap_3
XFILLER_107_666 VGND VGND VPWR VPWR sky130_fd_sc_hd__decap_3
XTAP_TAPCELL_ROW_95_1385 VGND VPWR sky130_fd_sc_hd__tapvpwrvgnd_1
XFILLER_102_360 VGND VGND VPWR VPWR sky130_fd_sc_hd__decap_3
XFILLER_29_51 VGND VGND VPWR VPWR sky130_fd_sc_hd__decap_3
XFILLER_29_95 VGND VGND VPWR VPWR sky130_fd_sc_hd__fill_1
XFILLER_48_447 VGND VGND VPWR VPWR sky130_fd_sc_hd__fill_2
XTAP_TAPCELL_ROW_59_954 VGND VPWR sky130_fd_sc_hd__tapvpwrvgnd_1
XFILLER_75_277 VGND VGND VPWR VPWR sky130_fd_sc_hd__decap_3
Xhold1980 _5184_/Q VGND VGND VPWR VPWR _4103_/B2 sky130_fd_sc_hd__dlygate4sd3_1
XFILLER_90_225 VGND VGND VPWR VPWR sky130_fd_sc_hd__fill_1
XTAP_TAPCELL_ROW_3_281 VGND VPWR sky130_fd_sc_hd__tapvpwrvgnd_1
Xhold1991 _5162_/Q VGND VGND VPWR VPWR _4078_/B2 sky130_fd_sc_hd__dlygate4sd3_1
XFILLER_16_377 VGND VGND VPWR VPWR sky130_fd_sc_hd__decap_3
XFILLER_91_9 VGND VGND VPWR VPWR sky130_fd_sc_hd__decap_3
XTAP_TAPCELL_ROW_104_1492 VGND VPWR sky130_fd_sc_hd__tapvpwrvgnd_1
XFILLER_61_60 VGND VGND VPWR VPWR sky130_fd_sc_hd__decap_3
XFILLER_8_565 VGND VGND VPWR VPWR sky130_fd_sc_hd__decap_3
XANTENNA_4 _3238_/X VGND VGND VPWR VPWR sky130_fd_sc_hd__diode_2
XFILLER_6_44 VGND VGND VPWR VPWR sky130_fd_sc_hd__decap_3
XFILLER_113_614 VGND VGND VPWR VPWR sky130_fd_sc_hd__fill_2
XFILLER_6_88 VGND VGND VPWR VPWR sky130_fd_sc_hd__fill_2
X_3310_ _3303_/X _3309_/X _3899_/B1 VGND VGND VPWR VPWR _3310_/X sky130_fd_sc_hd__o21a_2
XFILLER_113_647 VGND VGND VPWR VPWR sky130_fd_sc_hd__decap_3
XFILLER_3_281 VGND VGND VPWR VPWR sky130_fd_sc_hd__decap_3
X_4290_ _5040_/A1 _4265_/B _4294_/B1 _4290_/B2 VGND VGND VPWR VPWR _5360_/D sky130_fd_sc_hd__a22o_2
X_3241_ _3791_/A1 _3236_/X _3791_/B2 _3240_/X VGND VGND VPWR VPWR _3241_/X sky130_fd_sc_hd__a22o_2
XFILLER_20_3 VGND VGND VPWR VPWR sky130_fd_sc_hd__decap_3
XFILLER_66_200 VGND VGND VPWR VPWR sky130_fd_sc_hd__decap_3
X_3172_ _3178_/A1 _3170_/X _3171_/X wire676/A VGND VGND VPWR VPWR _3172_/X sky130_fd_sc_hd__o22a_2
XFILLER_39_447 VGND VGND VPWR VPWR sky130_fd_sc_hd__fill_1
XFILLER_94_553 VGND VGND VPWR VPWR sky130_fd_sc_hd__decap_3
Xfanout1060 _3895_/S VGND VGND VPWR VPWR _3851_/S sky130_fd_sc_hd__clkdlybuf4s25_1
XFILLER_35_620 VGND VGND VPWR VPWR sky130_fd_sc_hd__decap_3
XFILLER_34_152 VGND VGND VPWR VPWR sky130_fd_sc_hd__fill_2
X_5813_ _5813_/CLK _5813_/D VGND VGND VPWR VPWR _5813_/Q sky130_fd_sc_hd__dfxtp_2
XFILLER_22_358 VGND VGND VPWR VPWR sky130_fd_sc_hd__decap_3
XFILLER_50_645 VGND VGND VPWR VPWR sky130_fd_sc_hd__fill_1
X_5744_ _5867_/CLK _5744_/D VGND VGND VPWR VPWR _5744_/Q sky130_fd_sc_hd__dfxtp_2
X_2956_ _5387_/Q _5355_/Q _5323_/Q _5291_/Q _3060_/S _3062_/S1 VGND VGND VPWR VPWR
+ _2956_/X sky130_fd_sc_hd__mux4_2
X_5675_ _5867_/CLK _5675_/D VGND VGND VPWR VPWR _5675_/Q sky130_fd_sc_hd__dfxtp_2
X_2887_ _2700_/A _2883_/X _2886_/X _2881_/X VGND VGND VPWR VPWR _2887_/X sky130_fd_sc_hd__a31o_2
X_4626_ _4660_/A1 wire407/X wire186/X _4626_/B2 VGND VGND VPWR VPWR _5673_/D sky130_fd_sc_hd__a22o_2
XFILLER_104_603 VGND VGND VPWR VPWR sky130_fd_sc_hd__decap_3
X_4557_ _4659_/A1 _4557_/A2 _4557_/B1 _4557_/B2 VGND VGND VPWR VPWR _5608_/D sky130_fd_sc_hd__a22o_2
XFILLER_103_113 VGND VGND VPWR VPWR sky130_fd_sc_hd__decap_3
XFILLER_104_636 VGND VGND VPWR VPWR sky130_fd_sc_hd__decap_3
X_4488_ _4659_/A1 _4494_/A2 _4494_/B1 _4488_/B2 VGND VGND VPWR VPWR _5544_/D sky130_fd_sc_hd__a22o_2
X_3508_ _5252_/Q _5220_/Q _3508_/S VGND VGND VPWR VPWR _3508_/X sky130_fd_sc_hd__mux2_1
XFILLER_104_669 VGND VGND VPWR VPWR sky130_fd_sc_hd__decap_3
XFILLER_106_12 VGND VGND VPWR VPWR sky130_fd_sc_hd__decap_3
X_3439_ _3502_/A1 _3437_/X _3438_/X _3611_/B2 VGND VGND VPWR VPWR _3439_/X sky130_fd_sc_hd__o22a_2
XFILLER_106_56 VGND VGND VPWR VPWR sky130_fd_sc_hd__decap_3
XFILLER_85_531 VGND VGND VPWR VPWR sky130_fd_sc_hd__decap_3
Xhold1210 _5574_/Q VGND VGND VPWR VPWR _4520_/B2 sky130_fd_sc_hd__dlygate4sd3_1
Xhold1221 _5999_/Q VGND VGND VPWR VPWR _4971_/B2 sky130_fd_sc_hd__dlygate4sd3_1
Xhold1232 _5502_/Q VGND VGND VPWR VPWR _4444_/B2 sky130_fd_sc_hd__dlygate4sd3_1
Xhold1243 _5289_/Q VGND VGND VPWR VPWR _4215_/B2 sky130_fd_sc_hd__dlygate4sd3_1
X_5109_ _6037_/CLK _5109_/D VGND VGND VPWR VPWR _5109_/Q sky130_fd_sc_hd__dfxtp_2
XTAP_TAPCELL_ROW_56_924 VGND VPWR sky130_fd_sc_hd__tapvpwrvgnd_1
Xhold1254 _5619_/Q VGND VGND VPWR VPWR _4568_/B2 sky130_fd_sc_hd__dlygate4sd3_1
Xhold1265 _5508_/Q VGND VGND VPWR VPWR _4450_/B2 sky130_fd_sc_hd__dlygate4sd3_1
Xhold1276 _6054_/Q VGND VGND VPWR VPWR _5030_/B2 sky130_fd_sc_hd__dlygate4sd3_1
XFILLER_45_428 VGND VGND VPWR VPWR sky130_fd_sc_hd__decap_3
Xhold1287 _5628_/Q VGND VGND VPWR VPWR _4579_/B2 sky130_fd_sc_hd__dlygate4sd3_1
Xhold1298 _5753_/Q VGND VGND VPWR VPWR _4713_/B2 sky130_fd_sc_hd__dlygate4sd3_1
XFILLER_26_675 VGND VGND VPWR VPWR sky130_fd_sc_hd__decap_3
XTAP_TAPCELL_ROW_0_240 VGND VPWR sky130_fd_sc_hd__tapvpwrvgnd_1
XTAP_TAPCELL_ROW_0_251 VGND VPWR sky130_fd_sc_hd__tapvpwrvgnd_1
XFILLER_40_100 VGND VGND VPWR VPWR sky130_fd_sc_hd__decap_3
XFILLER_41_623 VGND VGND VPWR VPWR sky130_fd_sc_hd__decap_3
XFILLER_53_494 VGND VGND VPWR VPWR sky130_fd_sc_hd__fill_2
XTAP_TAPCELL_ROW_36_681 VGND VPWR sky130_fd_sc_hd__tapvpwrvgnd_1
XTAP_TAPCELL_ROW_97_1414 VGND VPWR sky130_fd_sc_hd__tapvpwrvgnd_1
XFILLER_5_513 VGND VGND VPWR VPWR sky130_fd_sc_hd__fill_1
XFILLER_5_557 VGND VGND VPWR VPWR sky130_fd_sc_hd__decap_3
Xoutput52 _2781_/X VGND VGND VPWR VPWR rd1[11] sky130_fd_sc_hd__dlymetal6s2s_1
Xoutput85 _3528_/X VGND VGND VPWR VPWR rd2[12] sky130_fd_sc_hd__clkbuf_2
Xoutput74 _3231_/X VGND VGND VPWR VPWR rd1[31] sky130_fd_sc_hd__dlymetal6s4s_1
Xoutput63 _3007_/X VGND VGND VPWR VPWR rd1[21] sky130_fd_sc_hd__clkbuf_2
XTAP_TAPCELL_ROW_8_351 VGND VPWR sky130_fd_sc_hd__tapvpwrvgnd_1
XTAP_TAPCELL_ROW_8_340 VGND VPWR sky130_fd_sc_hd__tapvpwrvgnd_1
Xoutput96 _3748_/X VGND VGND VPWR VPWR rd2[22] sky130_fd_sc_hd__clkbuf_2
XFILLER_48_222 VGND VGND VPWR VPWR sky130_fd_sc_hd__decap_3
XFILLER_76_531 VGND VGND VPWR VPWR sky130_fd_sc_hd__fill_1
XFILLER_56_82 VGND VGND VPWR VPWR sky130_fd_sc_hd__fill_2
XTAP_TAPCELL_ROW_106_1521 VGND VPWR sky130_fd_sc_hd__tapvpwrvgnd_1
XFILLER_51_409 VGND VGND VPWR VPWR sky130_fd_sc_hd__decap_3
XFILLER_16_174 VGND VGND VPWR VPWR sky130_fd_sc_hd__decap_3
XFILLER_31_144 VGND VGND VPWR VPWR sky130_fd_sc_hd__decap_3
X_3790_ _5808_/Q _5744_/Q _3790_/S VGND VGND VPWR VPWR _3790_/X sky130_fd_sc_hd__mux2_1
X_2810_ _5925_/Q _5893_/Q _5861_/Q _5765_/Q _3199_/S _3091_/S1 VGND VGND VPWR VPWR
+ _2810_/X sky130_fd_sc_hd__mux4_2
X_2741_ _5122_/Q _5090_/Q _6018_/Q _5986_/Q _2743_/S _3214_/S1 VGND VGND VPWR VPWR
+ _2741_/X sky130_fd_sc_hd__mux4_2
X_5460_ _6052_/CLK _5460_/D VGND VGND VPWR VPWR _5460_/Q sky130_fd_sc_hd__dfxtp_2
XFILLER_68_3 VGND VGND VPWR VPWR sky130_fd_sc_hd__decap_3
X_4411_ _4719_/A1 _4434_/A2 _4419_/B1 _4411_/B2 VGND VGND VPWR VPWR _5471_/D sky130_fd_sc_hd__a22o_2
X_2672_ _5791_/Q _5727_/Q _2924_/S VGND VGND VPWR VPWR _2672_/X sky130_fd_sc_hd__mux2_1
X_5391_ _5999_/CLK _5391_/D VGND VGND VPWR VPWR _5391_/Q sky130_fd_sc_hd__dfxtp_2
XFILLER_98_100 VGND VGND VPWR VPWR sky130_fd_sc_hd__fill_1
XFILLER_99_634 VGND VGND VPWR VPWR sky130_fd_sc_hd__fill_2
X_4342_ _4754_/A1 wire462/X wire242/X _4342_/B2 VGND VGND VPWR VPWR _5408_/D sky130_fd_sc_hd__a22o_2
XFILLER_113_466 VGND VGND VPWR VPWR sky130_fd_sc_hd__decap_3
X_4273_ _4719_/A1 _4265_/B _4284_/B1 _4273_/B2 VGND VGND VPWR VPWR _5343_/D sky130_fd_sc_hd__a22o_2
XFILLER_113_499 VGND VGND VPWR VPWR sky130_fd_sc_hd__decap_3
X_6012_ _6012_/CLK _6012_/D VGND VGND VPWR VPWR _6012_/Q sky130_fd_sc_hd__dfxtp_2
X_3224_ _3224_/A1 _3215_/X _3218_/X _3223_/X VGND VGND VPWR VPWR _3224_/X sky130_fd_sc_hd__a31o_2
.ends
