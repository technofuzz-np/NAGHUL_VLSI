* NGSPICE file created from ALU.ext - technology: sky130A

* Black-box entry subcircuit for sky130_fd_sc_hd__decap_3 abstract view
.subckt sky130_fd_sc_hd__decap_3 VGND VNB VPB VPWR
.ends

* Black-box entry subcircuit for sky130_fd_sc_hd__tapvpwrvgnd_1 abstract view
.subckt sky130_fd_sc_hd__tapvpwrvgnd_1 VGND VPWR
.ends

* Black-box entry subcircuit for sky130_fd_sc_hd__fill_1 abstract view
.subckt sky130_fd_sc_hd__fill_1 VGND VNB VPB VPWR
.ends

* Black-box entry subcircuit for sky130_fd_sc_hd__nor2_2 abstract view
.subckt sky130_fd_sc_hd__nor2_2 A B VGND VNB VPB VPWR Y
.ends

* Black-box entry subcircuit for sky130_fd_sc_hd__fill_2 abstract view
.subckt sky130_fd_sc_hd__fill_2 VGND VNB VPB VPWR
.ends

* Black-box entry subcircuit for sky130_fd_sc_hd__a31o_4 abstract view
.subckt sky130_fd_sc_hd__a31o_4 A1 A2 A3 B1 VGND VNB VPB VPWR X
.ends

* Black-box entry subcircuit for sky130_fd_sc_hd__and2b_2 abstract view
.subckt sky130_fd_sc_hd__and2b_2 A_N B VGND VNB VPB VPWR X
.ends

* Black-box entry subcircuit for sky130_fd_sc_hd__dlymetal6s4s_1 abstract view
.subckt sky130_fd_sc_hd__dlymetal6s4s_1 A VGND VNB VPB VPWR X
.ends

* Black-box entry subcircuit for sky130_fd_sc_hd__clkdlybuf4s15_2 abstract view
.subckt sky130_fd_sc_hd__clkdlybuf4s15_2 A VGND VNB VPB VPWR X
.ends

* Black-box entry subcircuit for sky130_fd_sc_hd__clkdlybuf4s25_1 abstract view
.subckt sky130_fd_sc_hd__clkdlybuf4s25_1 A VGND VNB VPB VPWR X
.ends

* Black-box entry subcircuit for sky130_fd_sc_hd__or3_2 abstract view
.subckt sky130_fd_sc_hd__or3_2 A B C VGND VNB VPB VPWR X
.ends

* Black-box entry subcircuit for sky130_fd_sc_hd__o221a_2 abstract view
.subckt sky130_fd_sc_hd__o221a_2 A1 A2 B1 B2 C1 VGND VNB VPB VPWR X
.ends

* Black-box entry subcircuit for sky130_fd_sc_hd__a221o_2 abstract view
.subckt sky130_fd_sc_hd__a221o_2 A1 A2 B1 B2 C1 VGND VNB VPB VPWR X
.ends

* Black-box entry subcircuit for sky130_fd_sc_hd__a31o_2 abstract view
.subckt sky130_fd_sc_hd__a31o_2 A1 A2 A3 B1 VGND VNB VPB VPWR X
.ends

* Black-box entry subcircuit for sky130_fd_sc_hd__and3_2 abstract view
.subckt sky130_fd_sc_hd__and3_2 A B C VGND VNB VPB VPWR X
.ends

* Black-box entry subcircuit for sky130_fd_sc_hd__a21o_2 abstract view
.subckt sky130_fd_sc_hd__a21o_2 A1 A2 B1 VGND VNB VPB VPWR X
.ends

* Black-box entry subcircuit for sky130_fd_sc_hd__or2_2 abstract view
.subckt sky130_fd_sc_hd__or2_2 A B VGND VNB VPB VPWR X
.ends

* Black-box entry subcircuit for sky130_fd_sc_hd__or3_4 abstract view
.subckt sky130_fd_sc_hd__or3_4 A B C VGND VNB VPB VPWR X
.ends

* Black-box entry subcircuit for sky130_fd_sc_hd__o22a_2 abstract view
.subckt sky130_fd_sc_hd__o22a_2 A1 A2 B1 B2 VGND VNB VPB VPWR X
.ends

* Black-box entry subcircuit for sky130_fd_sc_hd__clkbuf_4 abstract view
.subckt sky130_fd_sc_hd__clkbuf_4 A VGND VNB VPB VPWR X
.ends

* Black-box entry subcircuit for sky130_fd_sc_hd__o21ai_2 abstract view
.subckt sky130_fd_sc_hd__o21ai_2 A1 A2 B1 VGND VNB VPB VPWR Y
.ends

* Black-box entry subcircuit for sky130_fd_sc_hd__mux4_2 abstract view
.subckt sky130_fd_sc_hd__mux4_2 A0 A1 A2 A3 S0 S1 VGND VNB VPB VPWR X
.ends

* Black-box entry subcircuit for sky130_fd_sc_hd__xnor2_2 abstract view
.subckt sky130_fd_sc_hd__xnor2_2 A B VGND VNB VPB VPWR Y
.ends

* Black-box entry subcircuit for sky130_fd_sc_hd__buf_4 abstract view
.subckt sky130_fd_sc_hd__buf_4 A VGND VNB VPB VPWR X
.ends

* Black-box entry subcircuit for sky130_fd_sc_hd__buf_8 abstract view
.subckt sky130_fd_sc_hd__buf_8 A VGND VNB VPB VPWR X
.ends

* Black-box entry subcircuit for sky130_fd_sc_hd__o31ai_4 abstract view
.subckt sky130_fd_sc_hd__o31ai_4 A1 A2 A3 B1 VGND VNB VPB VPWR Y
.ends

* Black-box entry subcircuit for sky130_fd_sc_hd__a21oi_2 abstract view
.subckt sky130_fd_sc_hd__a21oi_2 A1 A2 B1 VGND VNB VPB VPWR Y
.ends

* Black-box entry subcircuit for sky130_fd_sc_hd__a211o_2 abstract view
.subckt sky130_fd_sc_hd__a211o_2 A1 A2 B1 C1 VGND VNB VPB VPWR X
.ends

* Black-box entry subcircuit for sky130_fd_sc_hd__a2bb2o_2 abstract view
.subckt sky130_fd_sc_hd__a2bb2o_2 A1_N A2_N B1 B2 VGND VNB VPB VPWR X
.ends

* Black-box entry subcircuit for sky130_fd_sc_hd__mux2_4 abstract view
.subckt sky130_fd_sc_hd__mux2_4 A0 A1 S VGND VNB VPB VPWR X
.ends

* Black-box entry subcircuit for sky130_fd_sc_hd__buf_2 abstract view
.subckt sky130_fd_sc_hd__buf_2 A VGND VNB VPB VPWR X
.ends

* Black-box entry subcircuit for sky130_fd_sc_hd__nand3b_2 abstract view
.subckt sky130_fd_sc_hd__nand3b_2 A_N B C VGND VNB VPB VPWR Y
.ends

* Black-box entry subcircuit for sky130_fd_sc_hd__a32o_2 abstract view
.subckt sky130_fd_sc_hd__a32o_2 A1 A2 A3 B1 B2 VGND VNB VPB VPWR X
.ends

* Black-box entry subcircuit for sky130_fd_sc_hd__nand3_2 abstract view
.subckt sky130_fd_sc_hd__nand3_2 A B C VGND VNB VPB VPWR Y
.ends

* Black-box entry subcircuit for sky130_fd_sc_hd__nand2b_2 abstract view
.subckt sky130_fd_sc_hd__nand2b_2 A_N B VGND VNB VPB VPWR Y
.ends

* Black-box entry subcircuit for sky130_fd_sc_hd__a22o_2 abstract view
.subckt sky130_fd_sc_hd__a22o_2 A1 A2 B1 B2 VGND VNB VPB VPWR X
.ends

* Black-box entry subcircuit for sky130_fd_sc_hd__inv_2 abstract view
.subckt sky130_fd_sc_hd__inv_2 A VGND VNB VPB VPWR Y
.ends

* Black-box entry subcircuit for sky130_fd_sc_hd__mux2_2 abstract view
.subckt sky130_fd_sc_hd__mux2_2 A0 A1 S VGND VNB VPB VPWR X
.ends

* Black-box entry subcircuit for sky130_fd_sc_hd__or3b_4 abstract view
.subckt sky130_fd_sc_hd__or3b_4 A B C_N VGND VNB VPB VPWR X
.ends

* Black-box entry subcircuit for sky130_fd_sc_hd__buf_6 abstract view
.subckt sky130_fd_sc_hd__buf_6 A VGND VNB VPB VPWR X
.ends

* Black-box entry subcircuit for sky130_fd_sc_hd__or4_2 abstract view
.subckt sky130_fd_sc_hd__or4_2 A B C D VGND VNB VPB VPWR X
.ends

* Black-box entry subcircuit for sky130_fd_sc_hd__or4b_4 abstract view
.subckt sky130_fd_sc_hd__or4b_4 A B C D_N VGND VNB VPB VPWR X
.ends

* Black-box entry subcircuit for sky130_fd_sc_hd__dlymetal6s2s_1 abstract view
.subckt sky130_fd_sc_hd__dlymetal6s2s_1 A VGND VNB VPB VPWR X
.ends

* Black-box entry subcircuit for sky130_fd_sc_hd__a311o_2 abstract view
.subckt sky130_fd_sc_hd__a311o_2 A1 A2 A3 B1 C1 VGND VNB VPB VPWR X
.ends

* Black-box entry subcircuit for sky130_fd_sc_hd__o21a_2 abstract view
.subckt sky130_fd_sc_hd__o21a_2 A1 A2 B1 VGND VNB VPB VPWR X
.ends

* Black-box entry subcircuit for sky130_fd_sc_hd__a21bo_2 abstract view
.subckt sky130_fd_sc_hd__a21bo_2 A1 A2 B1_N VGND VNB VPB VPWR X
.ends

* Black-box entry subcircuit for sky130_fd_sc_hd__and2_2 abstract view
.subckt sky130_fd_sc_hd__and2_2 A B VGND VNB VPB VPWR X
.ends

* Black-box entry subcircuit for sky130_fd_sc_hd__a2bb2o_4 abstract view
.subckt sky130_fd_sc_hd__a2bb2o_4 A1_N A2_N B1 B2 VGND VNB VPB VPWR X
.ends

* Black-box entry subcircuit for sky130_fd_sc_hd__nand2_2 abstract view
.subckt sky130_fd_sc_hd__nand2_2 A B VGND VNB VPB VPWR Y
.ends

* Black-box entry subcircuit for sky130_fd_sc_hd__o211a_2 abstract view
.subckt sky130_fd_sc_hd__o211a_2 A1 A2 B1 C1 VGND VNB VPB VPWR X
.ends

* Black-box entry subcircuit for sky130_fd_sc_hd__xor2_2 abstract view
.subckt sky130_fd_sc_hd__xor2_2 A B VGND VNB VPB VPWR X
.ends

* Black-box entry subcircuit for sky130_fd_sc_hd__a311oi_2 abstract view
.subckt sky130_fd_sc_hd__a311oi_2 A1 A2 A3 B1 C1 VGND VNB VPB VPWR Y
.ends

* Black-box entry subcircuit for sky130_fd_sc_hd__or4_4 abstract view
.subckt sky130_fd_sc_hd__or4_4 A B C D VGND VNB VPB VPWR X
.ends

* Black-box entry subcircuit for sky130_fd_sc_hd__xor2_4 abstract view
.subckt sky130_fd_sc_hd__xor2_4 A B VGND VNB VPB VPWR X
.ends

* Black-box entry subcircuit for sky130_fd_sc_hd__a22o_4 abstract view
.subckt sky130_fd_sc_hd__a22o_4 A1 A2 B1 B2 VGND VNB VPB VPWR X
.ends

* Black-box entry subcircuit for sky130_fd_sc_hd__mux2_1 abstract view
.subckt sky130_fd_sc_hd__mux2_1 A0 A1 S VGND VNB VPB VPWR X
.ends

* Black-box entry subcircuit for sky130_fd_sc_hd__o21a_4 abstract view
.subckt sky130_fd_sc_hd__o21a_4 A1 A2 B1 VGND VNB VPB VPWR X
.ends

* Black-box entry subcircuit for sky130_fd_sc_hd__nand2_8 abstract view
.subckt sky130_fd_sc_hd__nand2_8 A B VGND VNB VPB VPWR Y
.ends

* Black-box entry subcircuit for sky130_fd_sc_hd__or3b_2 abstract view
.subckt sky130_fd_sc_hd__or3b_2 A B C_N VGND VNB VPB VPWR X
.ends

* Black-box entry subcircuit for sky130_fd_sc_hd__a21o_4 abstract view
.subckt sky130_fd_sc_hd__a21o_4 A1 A2 B1 VGND VNB VPB VPWR X
.ends

* Black-box entry subcircuit for sky130_fd_sc_hd__and4bb_2 abstract view
.subckt sky130_fd_sc_hd__and4bb_2 A_N B_N C D VGND VNB VPB VPWR X
.ends

* Black-box entry subcircuit for sky130_fd_sc_hd__a41o_2 abstract view
.subckt sky130_fd_sc_hd__a41o_2 A1 A2 A3 A4 B1 VGND VNB VPB VPWR X
.ends

* Black-box entry subcircuit for sky130_fd_sc_hd__or2_4 abstract view
.subckt sky130_fd_sc_hd__or2_4 A B VGND VNB VPB VPWR X
.ends

* Black-box entry subcircuit for sky130_fd_sc_hd__o2111a_2 abstract view
.subckt sky130_fd_sc_hd__o2111a_2 A1 A2 B1 C1 D1 VGND VNB VPB VPWR X
.ends

* Black-box entry subcircuit for sky130_fd_sc_hd__a21oi_4 abstract view
.subckt sky130_fd_sc_hd__a21oi_4 A1 A2 B1 VGND VNB VPB VPWR Y
.ends

* Black-box entry subcircuit for sky130_fd_sc_hd__o211ai_2 abstract view
.subckt sky130_fd_sc_hd__o211ai_2 A1 A2 B1 C1 VGND VNB VPB VPWR Y
.ends

* Black-box entry subcircuit for sky130_fd_sc_hd__o221a_4 abstract view
.subckt sky130_fd_sc_hd__o221a_4 A1 A2 B1 B2 C1 VGND VNB VPB VPWR X
.ends

* Black-box entry subcircuit for sky130_fd_sc_hd__and3b_2 abstract view
.subckt sky130_fd_sc_hd__and3b_2 A_N B C VGND VNB VPB VPWR X
.ends

* Black-box entry subcircuit for sky130_fd_sc_hd__o2bb2a_2 abstract view
.subckt sky130_fd_sc_hd__o2bb2a_2 A1_N A2_N B1 B2 VGND VNB VPB VPWR X
.ends

* Black-box entry subcircuit for sky130_fd_sc_hd__and3_4 abstract view
.subckt sky130_fd_sc_hd__and3_4 A B C VGND VNB VPB VPWR X
.ends

* Black-box entry subcircuit for sky130_fd_sc_hd__a211o_4 abstract view
.subckt sky130_fd_sc_hd__a211o_4 A1 A2 B1 C1 VGND VNB VPB VPWR X
.ends

* Black-box entry subcircuit for sky130_fd_sc_hd__o22ai_2 abstract view
.subckt sky130_fd_sc_hd__o22ai_2 A1 A2 B1 B2 VGND VNB VPB VPWR Y
.ends

* Black-box entry subcircuit for sky130_fd_sc_hd__and2_4 abstract view
.subckt sky130_fd_sc_hd__and2_4 A B VGND VNB VPB VPWR X
.ends

* Black-box entry subcircuit for sky130_fd_sc_hd__o21bai_2 abstract view
.subckt sky130_fd_sc_hd__o21bai_2 A1 A2 B1_N VGND VNB VPB VPWR Y
.ends

* Black-box entry subcircuit for sky130_fd_sc_hd__a211oi_4 abstract view
.subckt sky130_fd_sc_hd__a211oi_4 A1 A2 B1 C1 VGND VNB VPB VPWR Y
.ends

* Black-box entry subcircuit for sky130_fd_sc_hd__clkbuf_2 abstract view
.subckt sky130_fd_sc_hd__clkbuf_2 A VGND VNB VPB VPWR X
.ends

* Black-box entry subcircuit for sky130_fd_sc_hd__inv_4 abstract view
.subckt sky130_fd_sc_hd__inv_4 A VGND VNB VPB VPWR Y
.ends

* Black-box entry subcircuit for sky130_fd_sc_hd__nand2_4 abstract view
.subckt sky130_fd_sc_hd__nand2_4 A B VGND VNB VPB VPWR Y
.ends

* Black-box entry subcircuit for sky130_fd_sc_hd__o311a_4 abstract view
.subckt sky130_fd_sc_hd__o311a_4 A1 A2 A3 B1 C1 VGND VNB VPB VPWR X
.ends

* Black-box entry subcircuit for sky130_fd_sc_hd__o31a_2 abstract view
.subckt sky130_fd_sc_hd__o31a_2 A1 A2 A3 B1 VGND VNB VPB VPWR X
.ends

* Black-box entry subcircuit for sky130_fd_sc_hd__a211oi_2 abstract view
.subckt sky130_fd_sc_hd__a211oi_2 A1 A2 B1 C1 VGND VNB VPB VPWR Y
.ends

* Black-box entry subcircuit for sky130_fd_sc_hd__dlygate4sd1_1 abstract view
.subckt sky130_fd_sc_hd__dlygate4sd1_1 A VGND VNB VPB VPWR X
.ends

* Black-box entry subcircuit for sky130_fd_sc_hd__nand3b_4 abstract view
.subckt sky130_fd_sc_hd__nand3b_4 A_N B C VGND VNB VPB VPWR Y
.ends

* Black-box entry subcircuit for sky130_fd_sc_hd__o31a_4 abstract view
.subckt sky130_fd_sc_hd__o31a_4 A1 A2 A3 B1 VGND VNB VPB VPWR X
.ends

* Black-box entry subcircuit for sky130_fd_sc_hd__xnor2_4 abstract view
.subckt sky130_fd_sc_hd__xnor2_4 A B VGND VNB VPB VPWR Y
.ends

* Black-box entry subcircuit for sky130_fd_sc_hd__a221oi_2 abstract view
.subckt sky130_fd_sc_hd__a221oi_2 A1 A2 B1 B2 C1 VGND VNB VPB VPWR Y
.ends

* Black-box entry subcircuit for sky130_fd_sc_hd__buf_1 abstract view
.subckt sky130_fd_sc_hd__buf_1 A VGND VNB VPB VPWR X
.ends

* Black-box entry subcircuit for sky130_fd_sc_hd__and4b_2 abstract view
.subckt sky130_fd_sc_hd__and4b_2 A_N B C D VGND VNB VPB VPWR X
.ends

* Black-box entry subcircuit for sky130_fd_sc_hd__o211a_4 abstract view
.subckt sky130_fd_sc_hd__o211a_4 A1 A2 B1 C1 VGND VNB VPB VPWR X
.ends

* Black-box entry subcircuit for sky130_fd_sc_hd__nor3_2 abstract view
.subckt sky130_fd_sc_hd__nor3_2 A B C VGND VNB VPB VPWR Y
.ends

* Black-box entry subcircuit for sky130_fd_sc_hd__or4b_2 abstract view
.subckt sky130_fd_sc_hd__or4b_2 A B C D_N VGND VNB VPB VPWR X
.ends

* Black-box entry subcircuit for sky130_fd_sc_hd__o41a_4 abstract view
.subckt sky130_fd_sc_hd__o41a_4 A1 A2 A3 A4 B1 VGND VNB VPB VPWR X
.ends

* Black-box entry subcircuit for sky130_fd_sc_hd__nor4_4 abstract view
.subckt sky130_fd_sc_hd__nor4_4 A B C D VGND VNB VPB VPWR Y
.ends

* Black-box entry subcircuit for sky130_fd_sc_hd__and4_2 abstract view
.subckt sky130_fd_sc_hd__and4_2 A B C D VGND VNB VPB VPWR X
.ends

* Black-box entry subcircuit for sky130_fd_sc_hd__o221ai_2 abstract view
.subckt sky130_fd_sc_hd__o221ai_2 A1 A2 B1 B2 C1 VGND VNB VPB VPWR Y
.ends

* Black-box entry subcircuit for sky130_fd_sc_hd__a22oi_2 abstract view
.subckt sky130_fd_sc_hd__a22oi_2 A1 A2 B1 B2 VGND VNB VPB VPWR Y
.ends

* Black-box entry subcircuit for sky130_fd_sc_hd__nor2_1 abstract view
.subckt sky130_fd_sc_hd__nor2_1 A B VGND VNB VPB VPWR Y
.ends

* Black-box entry subcircuit for sky130_fd_sc_hd__a2111o_2 abstract view
.subckt sky130_fd_sc_hd__a2111o_2 A1 A2 B1 C1 D1 VGND VNB VPB VPWR X
.ends

* Black-box entry subcircuit for sky130_fd_sc_hd__a21boi_4 abstract view
.subckt sky130_fd_sc_hd__a21boi_4 A1 A2 B1_N VGND VNB VPB VPWR Y
.ends

.subckt ALU A[0] A[10] A[11] A[12] A[13] A[14] A[15] A[16] A[17] A[18] A[19] A[1]
+ A[20] A[21] A[22] A[23] A[24] A[25] A[26] A[27] A[28] A[29] A[2] A[30] A[31] A[3]
+ A[4] A[5] A[6] A[7] A[8] A[9] B[0] B[10] B[11] B[12] B[13] B[14] B[15] B[16] B[17]
+ B[18] B[19] B[1] B[20] B[21] B[22] B[23] B[24] B[25] B[26] B[27] B[28] B[29] B[2]
+ B[30] B[31] B[3] B[4] B[5] B[6] B[7] B[8] B[9] VGND VPWR control[0] control[1] control[2]
+ control[3] result[0] result[10] result[11] result[12] result[13] result[14] result[15]
+ result[16] result[17] result[18] result[19] result[1] result[20] result[21] result[22]
+ result[23] result[24] result[25] result[26] result[27] result[28] result[29] result[2]
+ result[30] result[31] result[3] result[4] result[5] result[6] result[7] result[8]
+ result[9] zero
XFILLER_22_122 VGND VGND VPWR VPWR sky130_fd_sc_hd__decap_3
XFILLER_52_18 VGND VGND VPWR VPWR sky130_fd_sc_hd__decap_3
XFILLER_52_29 VGND VGND VPWR VPWR sky130_fd_sc_hd__decap_3
XTAP_TAPCELL_ROW_52_404 VGND VPWR sky130_fd_sc_hd__tapvpwrvgnd_1
XFILLER_13_100 VGND VGND VPWR VPWR sky130_fd_sc_hd__decap_3
XFILLER_26_52 VGND VGND VPWR VPWR sky130_fd_sc_hd__decap_3
XFILLER_26_74 VGND VGND VPWR VPWR sky130_fd_sc_hd__decap_3
XFILLER_26_85 VGND VGND VPWR VPWR sky130_fd_sc_hd__decap_3
XFILLER_45_225 VGND VGND VPWR VPWR sky130_fd_sc_hd__fill_1
XFILLER_45_269 VGND VGND VPWR VPWR sky130_fd_sc_hd__decap_3
XFILLER_13_155 VGND VGND VPWR VPWR sky130_fd_sc_hd__fill_1
XFILLER_42_40 VGND VGND VPWR VPWR sky130_fd_sc_hd__decap_3
XFILLER_9_137 VGND VGND VPWR VPWR sky130_fd_sc_hd__fill_1
XFILLER_3_12 VGND VGND VPWR VPWR sky130_fd_sc_hd__decap_3
XFILLER_3_45 VGND VGND VPWR VPWR sky130_fd_sc_hd__decap_3
XFILLER_36_203 VGND VGND VPWR VPWR sky130_fd_sc_hd__decap_3
XFILLER_36_269 VGND VGND VPWR VPWR sky130_fd_sc_hd__decap_3
X_1270_ _1270_/A _1270_/B VGND VGND VPWR VPWR _1271_/C sky130_fd_sc_hd__nor2_2
XFILLER_44_280 VGND VGND VPWR VPWR sky130_fd_sc_hd__fill_1
XFILLER_44_291 VGND VGND VPWR VPWR sky130_fd_sc_hd__decap_3
XFILLER_51_239 VGND VGND VPWR VPWR sky130_fd_sc_hd__fill_2
XFILLER_8_192 VGND VGND VPWR VPWR sky130_fd_sc_hd__decap_3
X_1606_ _1637_/A2 _1594_/Y _1595_/X _1605_/X VGND VGND VPWR VPWR _1606_/X sky130_fd_sc_hd__a31o_4
X_0985_ _0952_/A _0985_/B VGND VGND VPWR VPWR _0985_/X sky130_fd_sc_hd__and2b_2
XFILLER_47_18 VGND VGND VPWR VPWR sky130_fd_sc_hd__decap_3
Xfanout105 _1392_/X VGND VGND VPWR VPWR _1537_/A sky130_fd_sc_hd__dlymetal6s4s_1
Xfanout116 _1133_/A VGND VGND VPWR VPWR _1535_/A sky130_fd_sc_hd__clkdlybuf4s15_2
Xfanout149 _0832_/Y VGND VGND VPWR VPWR _1275_/A sky130_fd_sc_hd__clkdlybuf4s25_1
X_1537_ _1537_/A _1537_/B _1537_/C VGND VGND VPWR VPWR _1537_/X sky130_fd_sc_hd__or3_2
X_1468_ _1452_/A _1048_/B _1166_/A _1419_/Y _1467_/X VGND VGND VPWR VPWR _1468_/X
+ sky130_fd_sc_hd__o221a_2
X_1399_ _1261_/A _1395_/Y _1398_/X _1570_/A1 _1394_/X VGND VGND VPWR VPWR _1399_/X
+ sky130_fd_sc_hd__a221o_2
XFILLER_27_225 VGND VGND VPWR VPWR sky130_fd_sc_hd__fill_2
XFILLER_42_239 VGND VGND VPWR VPWR sky130_fd_sc_hd__decap_3
XPHY_EDGE_ROW_19_Left_72 VGND VGND VPWR VPWR sky130_fd_sc_hd__decap_3
XFILLER_10_114 VGND VGND VPWR VPWR sky130_fd_sc_hd__decap_3
XFILLER_10_147 VGND VGND VPWR VPWR sky130_fd_sc_hd__fill_1
XFILLER_12_21 VGND VGND VPWR VPWR sky130_fd_sc_hd__decap_3
XFILLER_50_283 VGND VGND VPWR VPWR sky130_fd_sc_hd__decap_3
XFILLER_6_129 VGND VGND VPWR VPWR sky130_fd_sc_hd__decap_3
XFILLER_12_98 VGND VGND VPWR VPWR sky130_fd_sc_hd__decap_3
XFILLER_18_225 VGND VGND VPWR VPWR sky130_fd_sc_hd__decap_3
XTAP_TAPCELL_ROW_5_140 VGND VPWR sky130_fd_sc_hd__tapvpwrvgnd_1
XFILLER_37_95 VGND VGND VPWR VPWR sky130_fd_sc_hd__decap_3
XFILLER_52_6 VGND VGND VPWR VPWR sky130_fd_sc_hd__decap_3
XTAP_TAPCELL_ROW_11_175 VGND VPWR sky130_fd_sc_hd__tapvpwrvgnd_1
X_1322_ _1004_/A input3/X _1585_/A3 _1321_/Y VGND VGND VPWR VPWR _1322_/X sky130_fd_sc_hd__a31o_2
X_1253_ _1351_/B _1272_/C _1253_/C VGND VGND VPWR VPWR _1271_/A sky130_fd_sc_hd__and3_2
XFILLER_24_206 VGND VGND VPWR VPWR sky130_fd_sc_hd__decap_3
X_1184_ _1184_/A1 _1191_/A _1453_/A1 VGND VGND VPWR VPWR _1184_/X sky130_fd_sc_hd__a21o_2
XTAP_TAPCELL_ROW_19_220 VGND VPWR sky130_fd_sc_hd__tapvpwrvgnd_1
XFILLER_32_272 VGND VGND VPWR VPWR sky130_fd_sc_hd__decap_3
X_0968_ _0955_/Y _0963_/Y _0960_/X _0967_/X VGND VGND VPWR VPWR _0968_/X sky130_fd_sc_hd__a31o_4
X_0899_ _1635_/A _0899_/B VGND VGND VPWR VPWR _0899_/X sky130_fd_sc_hd__or2_2
XFILLER_15_239 VGND VGND VPWR VPWR sky130_fd_sc_hd__decap_3
XFILLER_23_250 VGND VGND VPWR VPWR sky130_fd_sc_hd__decap_3
XPHY_EDGE_ROW_4_Left_57 VGND VGND VPWR VPWR sky130_fd_sc_hd__decap_3
XFILLER_23_75 VGND VGND VPWR VPWR sky130_fd_sc_hd__decap_3
XFILLER_23_97 VGND VGND VPWR VPWR sky130_fd_sc_hd__decap_3
XFILLER_38_309 VGND VGND VPWR VPWR sky130_fd_sc_hd__fill_1
XFILLER_0_24 VGND VGND VPWR VPWR sky130_fd_sc_hd__decap_3
XFILLER_0_35 VGND VGND VPWR VPWR sky130_fd_sc_hd__decap_3
XFILLER_48_83 VGND VGND VPWR VPWR sky130_fd_sc_hd__fill_1
XTAP_TAPCELL_ROW_16_201 VGND VPWR sky130_fd_sc_hd__tapvpwrvgnd_1
XFILLER_9_33 VGND VGND VPWR VPWR sky130_fd_sc_hd__decap_3
XFILLER_9_77 VGND VGND VPWR VPWR sky130_fd_sc_hd__decap_3
XFILLER_50_3 VGND VGND VPWR VPWR sky130_fd_sc_hd__decap_3
X_1305_ _1305_/A _1305_/B _1305_/C VGND VGND VPWR VPWR _1305_/X sky130_fd_sc_hd__or3_4
X_1236_ _1236_/A _1236_/B VGND VGND VPWR VPWR _1250_/B sky130_fd_sc_hd__nor2_2
XTAP_TAPCELL_ROW_39_326 VGND VPWR sky130_fd_sc_hd__tapvpwrvgnd_1
X_1167_ _1452_/A _0953_/Y _1154_/A _1133_/A VGND VGND VPWR VPWR _1167_/X sky130_fd_sc_hd__o22a_2
X_1098_ _1659_/A _0957_/Y _1098_/B1 _1133_/A _1097_/Y VGND VGND VPWR VPWR _1098_/X
+ sky130_fd_sc_hd__o221a_2
XTAP_TAPCELL_ROW_47_370 VGND VPWR sky130_fd_sc_hd__tapvpwrvgnd_1
XPHY_EDGE_ROW_46_Left_99 VGND VGND VPWR VPWR sky130_fd_sc_hd__decap_3
XTAP_TAPCELL_ROW_30_281 VGND VPWR sky130_fd_sc_hd__tapvpwrvgnd_1
XTAP_TAPCELL_ROW_22_237 VGND VPWR sky130_fd_sc_hd__tapvpwrvgnd_1
XFILLER_18_75 VGND VGND VPWR VPWR sky130_fd_sc_hd__decap_3
XFILLER_43_301 VGND VGND VPWR VPWR sky130_fd_sc_hd__fill_1
XFILLER_11_253 VGND VGND VPWR VPWR sky130_fd_sc_hd__decap_3
XFILLER_34_41 VGND VGND VPWR VPWR sky130_fd_sc_hd__decap_3
XFILLER_34_74 VGND VGND VPWR VPWR sky130_fd_sc_hd__decap_3
XFILLER_7_257 VGND VGND VPWR VPWR sky130_fd_sc_hd__decap_3
Xwire177 wire177/A VGND VGND VPWR VPWR wire177/X sky130_fd_sc_hd__clkbuf_4
XFILLER_38_128 VGND VGND VPWR VPWR sky130_fd_sc_hd__decap_3
Xload_slew138 _1359_/S VGND VGND VPWR VPWR _1457_/S sky130_fd_sc_hd__clkbuf_4
X_1021_ _1272_/A _1272_/B _1019_/Y VGND VGND VPWR VPWR _1293_/B sky130_fd_sc_hd__o21ai_2
XFILLER_29_128 VGND VGND VPWR VPWR sky130_fd_sc_hd__decap_3
X_1219_ _0988_/B _0951_/B _1219_/A2 _0966_/B _1090_/S _1134_/A VGND VGND VPWR VPWR
+ _1220_/B sky130_fd_sc_hd__mux4_2
XFILLER_52_153 VGND VGND VPWR VPWR sky130_fd_sc_hd__fill_1
XFILLER_20_32 VGND VGND VPWR VPWR sky130_fd_sc_hd__decap_3
XFILLER_20_65 VGND VGND VPWR VPWR sky130_fd_sc_hd__decap_3
XTAP_TAPCELL_ROW_50_387 VGND VPWR sky130_fd_sc_hd__tapvpwrvgnd_1
XFILLER_29_63 VGND VGND VPWR VPWR sky130_fd_sc_hd__fill_1
XFILLER_29_74 VGND VGND VPWR VPWR sky130_fd_sc_hd__decap_3
XFILLER_35_109 VGND VGND VPWR VPWR sky130_fd_sc_hd__decap_3
XFILLER_6_12 VGND VGND VPWR VPWR sky130_fd_sc_hd__decap_3
XPHY_EDGE_ROW_7_Left_60 VGND VGND VPWR VPWR sky130_fd_sc_hd__decap_3
XFILLER_3_293 VGND VGND VPWR VPWR sky130_fd_sc_hd__decap_3
XFILLER_6_67 VGND VGND VPWR VPWR sky130_fd_sc_hd__decap_3
X_1570_ _1570_/A1 _1569_/X _1566_/X VGND VGND VPWR VPWR _1570_/X sky130_fd_sc_hd__a21o_2
XFILLER_13_3 VGND VGND VPWR VPWR sky130_fd_sc_hd__decap_3
XFILLER_26_109 VGND VGND VPWR VPWR sky130_fd_sc_hd__decap_3
XFILLER_34_186 VGND VGND VPWR VPWR sky130_fd_sc_hd__decap_3
XFILLER_34_197 VGND VGND VPWR VPWR sky130_fd_sc_hd__decap_3
X_1004_ _1004_/A _1018_/B VGND VGND VPWR VPWR _1309_/A sky130_fd_sc_hd__xnor2_2
XFILLER_25_131 VGND VGND VPWR VPWR sky130_fd_sc_hd__decap_3
XFILLER_40_112 VGND VGND VPWR VPWR sky130_fd_sc_hd__fill_2
XFILLER_40_156 VGND VGND VPWR VPWR sky130_fd_sc_hd__fill_1
Xoutput75 _1679_/A VGND VGND VPWR VPWR result[15] sky130_fd_sc_hd__buf_4
XPHY_EDGE_ROW_33_Left_86 VGND VGND VPWR VPWR sky130_fd_sc_hd__decap_3
XFILLER_0_274 VGND VGND VPWR VPWR sky130_fd_sc_hd__decap_3
XFILLER_0_296 VGND VGND VPWR VPWR sky130_fd_sc_hd__decap_3
XFILLER_48_234 VGND VGND VPWR VPWR sky130_fd_sc_hd__fill_1
XFILLER_48_256 VGND VGND VPWR VPWR sky130_fd_sc_hd__decap_3
XFILLER_48_289 VGND VGND VPWR VPWR sky130_fd_sc_hd__decap_3
Xoutput86 _1676_/B VGND VGND VPWR VPWR result[25] sky130_fd_sc_hd__buf_8
Xoutput97 _1673_/A VGND VGND VPWR VPWR result[6] sky130_fd_sc_hd__buf_8
XFILLER_16_153 VGND VGND VPWR VPWR sky130_fd_sc_hd__decap_3
XFILLER_16_197 VGND VGND VPWR VPWR sky130_fd_sc_hd__decap_3
XFILLER_31_156 VGND VGND VPWR VPWR sky130_fd_sc_hd__decap_3
XFILLER_31_178 VGND VGND VPWR VPWR sky130_fd_sc_hd__decap_3
X_1622_ _1621_/D _1621_/C _1621_/B _1621_/A VGND VGND VPWR VPWR _1622_/Y sky130_fd_sc_hd__o31ai_4
XFILLER_39_223 VGND VGND VPWR VPWR sky130_fd_sc_hd__fill_1
X_1553_ _1552_/B _1552_/C _1573_/B VGND VGND VPWR VPWR _1553_/Y sky130_fd_sc_hd__a21oi_2
X_1484_ _1509_/B _1480_/X _1482_/X _1561_/A1 VGND VGND VPWR VPWR _1485_/B sky130_fd_sc_hd__a31o_2
XFILLER_39_278 VGND VGND VPWR VPWR sky130_fd_sc_hd__fill_2
XFILLER_39_289 VGND VGND VPWR VPWR sky130_fd_sc_hd__decap_3
XTAP_TAPCELL_ROW_52_405 VGND VPWR sky130_fd_sc_hd__tapvpwrvgnd_1
XFILLER_22_156 VGND VGND VPWR VPWR sky130_fd_sc_hd__decap_3
XFILLER_45_259 VGND VGND VPWR VPWR sky130_fd_sc_hd__fill_2
XFILLER_9_116 VGND VGND VPWR VPWR sky130_fd_sc_hd__decap_3
XFILLER_42_52 VGND VGND VPWR VPWR sky130_fd_sc_hd__decap_3
XFILLER_42_85 VGND VGND VPWR VPWR sky130_fd_sc_hd__fill_1
Xrebuffer460 _1358_/A0 VGND VGND VPWR VPWR _0992_/B sky130_fd_sc_hd__buf_4
XFILLER_3_24 VGND VGND VPWR VPWR sky130_fd_sc_hd__decap_3
XFILLER_47_9 VGND VGND VPWR VPWR sky130_fd_sc_hd__decap_3
XTAP_TAPCELL_ROW_8_160 VGND VPWR sky130_fd_sc_hd__tapvpwrvgnd_1
X_0984_ _0976_/A _0984_/B VGND VGND VPWR VPWR _0984_/X sky130_fd_sc_hd__and2b_2
XFILLER_8_160 VGND VGND VPWR VPWR sky130_fd_sc_hd__fill_2
XFILLER_8_182 VGND VGND VPWR VPWR sky130_fd_sc_hd__decap_3
X_1605_ _1319_/X _1419_/B _1598_/Y _1604_/X VGND VGND VPWR VPWR _1605_/X sky130_fd_sc_hd__a211o_2
X_1536_ _1659_/A _0939_/B _0939_/A _1643_/A1 VGND VGND VPWR VPWR _1537_/C sky130_fd_sc_hd__a2bb2o_2
Xfanout106 _1392_/X VGND VGND VPWR VPWR _1647_/C1 sky130_fd_sc_hd__clkdlybuf4s25_1
Xfanout139 _1631_/A1 VGND VGND VPWR VPWR _1144_/S sky130_fd_sc_hd__clkdlybuf4s25_1
X_1467_ _1601_/A _1044_/Y _1048_/Y _1535_/A VGND VGND VPWR VPWR _1467_/X sky130_fd_sc_hd__o22a_2
X_1398_ _1241_/X _1397_/X _1472_/A VGND VGND VPWR VPWR _1398_/X sky130_fd_sc_hd__mux2_4
XFILLER_35_281 VGND VGND VPWR VPWR sky130_fd_sc_hd__decap_3
XFILLER_42_207 VGND VGND VPWR VPWR sky130_fd_sc_hd__decap_3
XFILLER_50_240 VGND VGND VPWR VPWR sky130_fd_sc_hd__decap_3
XFILLER_10_126 VGND VGND VPWR VPWR sky130_fd_sc_hd__decap_3
XFILLER_10_137 VGND VGND VPWR VPWR sky130_fd_sc_hd__decap_3
XFILLER_12_66 VGND VGND VPWR VPWR sky130_fd_sc_hd__decap_3
XFILLER_50_262 VGND VGND VPWR VPWR sky130_fd_sc_hd__decap_3
XFILLER_50_295 VGND VGND VPWR VPWR sky130_fd_sc_hd__decap_3
XFILLER_6_108 VGND VGND VPWR VPWR sky130_fd_sc_hd__decap_3
XFILLER_37_52 VGND VGND VPWR VPWR sky130_fd_sc_hd__decap_3
XTAP_TAPCELL_ROW_5_141 VGND VPWR sky130_fd_sc_hd__tapvpwrvgnd_1
XTAP_TAPCELL_ROW_28_265 VGND VPWR sky130_fd_sc_hd__tapvpwrvgnd_1
XFILLER_41_295 VGND VGND VPWR VPWR sky130_fd_sc_hd__decap_3
XFILLER_5_130 VGND VGND VPWR VPWR sky130_fd_sc_hd__decap_3
Xrebuffer290 _0958_/Y VGND VGND VPWR VPWR _1098_/B1 sky130_fd_sc_hd__buf_2
XTAP_TAPCELL_ROW_11_176 VGND VPWR sky130_fd_sc_hd__tapvpwrvgnd_1
X_1321_ _1535_/A _1333_/A VGND VGND VPWR VPWR _1321_/Y sky130_fd_sc_hd__nor2_2
X_1252_ _1288_/B _1252_/B _1252_/C VGND VGND VPWR VPWR _1253_/C sky130_fd_sc_hd__nand3b_2
XFILLER_24_218 VGND VGND VPWR VPWR sky130_fd_sc_hd__decap_3
XPHY_EDGE_ROW_20_Left_73 VGND VGND VPWR VPWR sky130_fd_sc_hd__decap_3
X_1183_ _1082_/B input1/X _1117_/X _1182_/X _1175_/A VGND VGND VPWR VPWR _1183_/X
+ sky130_fd_sc_hd__a32o_2
XFILLER_32_251 VGND VGND VPWR VPWR sky130_fd_sc_hd__fill_1
XFILLER_32_284 VGND VGND VPWR VPWR sky130_fd_sc_hd__decap_3
X_0967_ _0955_/Y _1154_/B _0966_/X VGND VGND VPWR VPWR _0967_/X sky130_fd_sc_hd__a21o_2
XPHY_EDGE_ROW_12_Right_12 VGND VGND VPWR VPWR sky130_fd_sc_hd__decap_3
X_1519_ _1548_/A _1519_/B _1519_/C VGND VGND VPWR VPWR _1519_/Y sky130_fd_sc_hd__nand3_2
X_0898_ _0905_/A _0905_/B VGND VGND VPWR VPWR _0899_/B sky130_fd_sc_hd__nand2b_2
XPHY_EDGE_ROW_21_Right_21 VGND VGND VPWR VPWR sky130_fd_sc_hd__decap_3
XTAP_TAPCELL_ROW_2_122 VGND VPWR sky130_fd_sc_hd__tapvpwrvgnd_1
XFILLER_15_229 VGND VGND VPWR VPWR sky130_fd_sc_hd__fill_1
XFILLER_23_240 VGND VGND VPWR VPWR sky130_fd_sc_hd__fill_2
XFILLER_23_262 VGND VGND VPWR VPWR sky130_fd_sc_hd__decap_3
XFILLER_23_295 VGND VGND VPWR VPWR sky130_fd_sc_hd__fill_1
XFILLER_23_54 VGND VGND VPWR VPWR sky130_fd_sc_hd__fill_2
XPHY_EDGE_ROW_30_Right_30 VGND VGND VPWR VPWR sky130_fd_sc_hd__decap_3
XFILLER_48_62 VGND VGND VPWR VPWR sky130_fd_sc_hd__decap_3
XFILLER_9_12 VGND VGND VPWR VPWR sky130_fd_sc_hd__decap_3
XTAP_TAPCELL_ROW_16_202 VGND VPWR sky130_fd_sc_hd__tapvpwrvgnd_1
XFILLER_14_251 VGND VGND VPWR VPWR sky130_fd_sc_hd__fill_1
X_1304_ _1598_/A _1591_/B _1301_/X _1570_/A1 VGND VGND VPWR VPWR _1305_/C sky130_fd_sc_hd__a22o_2
X_1235_ _0983_/B _0988_/Y _1214_/X _1464_/A VGND VGND VPWR VPWR _1236_/B sky130_fd_sc_hd__a31o_2
X_1166_ _1166_/A VGND VGND VPWR VPWR _1166_/Y sky130_fd_sc_hd__inv_2
XTAP_TAPCELL_ROW_39_327 VGND VPWR sky130_fd_sc_hd__tapvpwrvgnd_1
XFILLER_20_210 VGND VGND VPWR VPWR sky130_fd_sc_hd__decap_3
XFILLER_52_302 VGND VGND VPWR VPWR sky130_fd_sc_hd__decap_3
X_1097_ _1145_/S _0957_/B _1643_/A1 VGND VGND VPWR VPWR _1097_/Y sky130_fd_sc_hd__o21ai_2
XTAP_TAPCELL_ROW_47_371 VGND VPWR sky130_fd_sc_hd__tapvpwrvgnd_1
XFILLER_47_118 VGND VGND VPWR VPWR sky130_fd_sc_hd__fill_1
XFILLER_11_210 VGND VGND VPWR VPWR sky130_fd_sc_hd__fill_2
XFILLER_34_97 VGND VGND VPWR VPWR sky130_fd_sc_hd__fill_2
XFILLER_50_41 VGND VGND VPWR VPWR sky130_fd_sc_hd__decap_3
XFILLER_7_203 VGND VGND VPWR VPWR sky130_fd_sc_hd__decap_3
XFILLER_7_225 VGND VGND VPWR VPWR sky130_fd_sc_hd__fill_1
XFILLER_50_85 VGND VGND VPWR VPWR sky130_fd_sc_hd__fill_1
XFILLER_7_269 VGND VGND VPWR VPWR sky130_fd_sc_hd__fill_1
X_1020_ _1014_/A _1020_/B VGND VGND VPWR VPWR _1272_/B sky130_fd_sc_hd__nand2b_2
XFILLER_34_302 VGND VGND VPWR VPWR sky130_fd_sc_hd__decap_3
XFILLER_46_195 VGND VGND VPWR VPWR sky130_fd_sc_hd__fill_1
XFILLER_37_173 VGND VGND VPWR VPWR sky130_fd_sc_hd__decap_3
X_1218_ _1453_/A1 _0980_/X _1215_/B _1555_/B2 _1217_/Y VGND VGND VPWR VPWR _1218_/X
+ sky130_fd_sc_hd__a221o_2
X_1149_ _1144_/X _1148_/X _1178_/S VGND VGND VPWR VPWR _1149_/X sky130_fd_sc_hd__mux2_2
XFILLER_40_305 VGND VGND VPWR VPWR sky130_fd_sc_hd__decap_3
XTAP_TAPCELL_ROW_50_388 VGND VPWR sky130_fd_sc_hd__tapvpwrvgnd_1
XFILLER_20_55 VGND VGND VPWR VPWR sky130_fd_sc_hd__fill_1
XFILLER_20_88 VGND VGND VPWR VPWR sky130_fd_sc_hd__decap_3
XFILLER_4_206 VGND VGND VPWR VPWR sky130_fd_sc_hd__decap_3
XFILLER_29_86 VGND VGND VPWR VPWR sky130_fd_sc_hd__decap_3
XFILLER_16_302 VGND VGND VPWR VPWR sky130_fd_sc_hd__fill_2
XFILLER_28_151 VGND VGND VPWR VPWR sky130_fd_sc_hd__decap_3
XFILLER_43_165 VGND VGND VPWR VPWR sky130_fd_sc_hd__decap_3
XFILLER_45_41 VGND VGND VPWR VPWR sky130_fd_sc_hd__decap_3
XFILLER_45_96 VGND VGND VPWR VPWR sky130_fd_sc_hd__decap_3
XPHY_EDGE_ROW_51_Left_104 VGND VGND VPWR VPWR sky130_fd_sc_hd__decap_3
XFILLER_6_24 VGND VGND VPWR VPWR sky130_fd_sc_hd__decap_3
XFILLER_6_35 VGND VGND VPWR VPWR sky130_fd_sc_hd__decap_3
XFILLER_19_184 VGND VGND VPWR VPWR sky130_fd_sc_hd__decap_3
X_1003_ _1389_/B _1003_/B _1406_/A VGND VGND VPWR VPWR _1003_/X sky130_fd_sc_hd__or3b_4
XFILLER_34_176 VGND VGND VPWR VPWR sky130_fd_sc_hd__fill_2
XPHY_EDGE_ROW_6_Right_6 VGND VGND VPWR VPWR sky130_fd_sc_hd__decap_3
XFILLER_15_44 VGND VGND VPWR VPWR sky130_fd_sc_hd__decap_3
XFILLER_15_66 VGND VGND VPWR VPWR sky130_fd_sc_hd__fill_1
XFILLER_31_32 VGND VGND VPWR VPWR sky130_fd_sc_hd__decap_3
XFILLER_31_43 VGND VGND VPWR VPWR sky130_fd_sc_hd__decap_3
XFILLER_31_76 VGND VGND VPWR VPWR sky130_fd_sc_hd__fill_1
XFILLER_40_179 VGND VGND VPWR VPWR sky130_fd_sc_hd__decap_3
Xrebuffer631 _1228_/X VGND VGND VPWR VPWR _1527_/B1 sky130_fd_sc_hd__buf_2
XFILLER_0_242 VGND VGND VPWR VPWR sky130_fd_sc_hd__decap_3
XFILLER_0_253 VGND VGND VPWR VPWR sky130_fd_sc_hd__decap_3
Xoutput76 output76/A VGND VGND VPWR VPWR result[16] sky130_fd_sc_hd__buf_8
Xoutput87 _1677_/A VGND VGND VPWR VPWR result[26] sky130_fd_sc_hd__buf_8
Xoutput98 _1670_/A VGND VGND VPWR VPWR result[7] sky130_fd_sc_hd__buf_6
XFILLER_48_202 VGND VGND VPWR VPWR sky130_fd_sc_hd__decap_3
XFILLER_48_213 VGND VGND VPWR VPWR sky130_fd_sc_hd__decap_3
XFILLER_48_268 VGND VGND VPWR VPWR sky130_fd_sc_hd__decap_3
XFILLER_31_113 VGND VGND VPWR VPWR sky130_fd_sc_hd__fill_1
X_1621_ _1621_/A _1621_/B _1621_/C _1621_/D VGND VGND VPWR VPWR _1623_/B sky130_fd_sc_hd__or4_2
X_1552_ _1573_/B _1552_/B _1552_/C VGND VGND VPWR VPWR _1552_/X sky130_fd_sc_hd__and3_2
XFILLER_39_257 VGND VGND VPWR VPWR sky130_fd_sc_hd__decap_3
X_1483_ _1480_/X _1482_/X _1509_/B VGND VGND VPWR VPWR _1485_/A sky130_fd_sc_hd__a21oi_2
XFILLER_22_113 VGND VGND VPWR VPWR sky130_fd_sc_hd__decap_3
XFILLER_47_290 VGND VGND VPWR VPWR sky130_fd_sc_hd__decap_3
XTAP_TAPCELL_ROW_52_406 VGND VPWR sky130_fd_sc_hd__tapvpwrvgnd_1
XFILLER_7_9 VGND VGND VPWR VPWR sky130_fd_sc_hd__decap_3
XFILLER_13_135 VGND VGND VPWR VPWR sky130_fd_sc_hd__fill_2
XFILLER_26_43 VGND VGND VPWR VPWR sky130_fd_sc_hd__decap_3
XFILLER_26_65 VGND VGND VPWR VPWR sky130_fd_sc_hd__decap_3
XFILLER_42_97 VGND VGND VPWR VPWR sky130_fd_sc_hd__decap_3
Xrebuffer461 _1358_/A0 VGND VGND VPWR VPWR _1375_/A1 sky130_fd_sc_hd__buf_2
XFILLER_3_36 VGND VGND VPWR VPWR sky130_fd_sc_hd__decap_3
XFILLER_36_227 VGND VGND VPWR VPWR sky130_fd_sc_hd__fill_2
XFILLER_51_219 VGND VGND VPWR VPWR sky130_fd_sc_hd__decap_3
X_0983_ _0983_/A _0983_/B _0983_/C _0968_/X VGND VGND VPWR VPWR _0983_/X sky130_fd_sc_hd__or4b_4
X_1604_ _1632_/A3 _0911_/B _1601_/Y _1603_/X VGND VGND VPWR VPWR _1604_/X sky130_fd_sc_hd__a211o_2
Xfanout107 _1104_/X VGND VGND VPWR VPWR _1561_/A1 sky130_fd_sc_hd__dlymetal6s2s_1
Xfanout118 _0869_/Y VGND VGND VPWR VPWR _1184_/A1 sky130_fd_sc_hd__clkdlybuf4s25_1
X_1535_ _1535_/A _1548_/B VGND VGND VPWR VPWR _1537_/B sky130_fd_sc_hd__nor2_2
XFILLER_27_205 VGND VGND VPWR VPWR sky130_fd_sc_hd__decap_3
X_1466_ _1452_/B _1048_/Y _1451_/X _1465_/Y _1561_/A1 VGND VGND VPWR VPWR _1476_/B
+ sky130_fd_sc_hd__a311o_2
X_1397_ _1317_/X _1396_/X _1457_/S VGND VGND VPWR VPWR _1397_/X sky130_fd_sc_hd__mux2_4
XFILLER_35_293 VGND VGND VPWR VPWR sky130_fd_sc_hd__decap_3
XFILLER_50_274 VGND VGND VPWR VPWR sky130_fd_sc_hd__decap_3
XFILLER_12_12 VGND VGND VPWR VPWR sky130_fd_sc_hd__decap_3
XFILLER_2_304 VGND VGND VPWR VPWR sky130_fd_sc_hd__decap_3
XFILLER_5_6 VGND VGND VPWR VPWR sky130_fd_sc_hd__decap_3
XTAP_TAPCELL_ROW_5_142 VGND VPWR sky130_fd_sc_hd__tapvpwrvgnd_1
XFILLER_37_31 VGND VGND VPWR VPWR sky130_fd_sc_hd__decap_3
XTAP_TAPCELL_ROW_28_266 VGND VPWR sky130_fd_sc_hd__tapvpwrvgnd_1
XFILLER_41_252 VGND VGND VPWR VPWR sky130_fd_sc_hd__fill_1
Xrebuffer291 _0958_/Y VGND VGND VPWR VPWR _1101_/A sky130_fd_sc_hd__buf_2
X_1320_ _1004_/A _1018_/B _1453_/A1 VGND VGND VPWR VPWR _1320_/X sky130_fd_sc_hd__o21a_2
X_1251_ _1252_/B _1252_/C _1288_/B VGND VGND VPWR VPWR _1272_/C sky130_fd_sc_hd__a21bo_2
X_1182_ _0970_/B _0966_/B _0965_/B _0957_/B _0959_/B _1134_/A VGND VGND VPWR VPWR
+ _1182_/X sky130_fd_sc_hd__mux4_2
XFILLER_32_241 VGND VGND VPWR VPWR sky130_fd_sc_hd__fill_1
XFILLER_32_296 VGND VGND VPWR VPWR sky130_fd_sc_hd__decap_3
X_0966_ _0955_/A _0966_/B VGND VGND VPWR VPWR _0966_/X sky130_fd_sc_hd__and2b_2
X_0897_ _0897_/A _0897_/B VGND VGND VPWR VPWR _1635_/A sky130_fd_sc_hd__and2_2
X_1518_ _1519_/B _1519_/C _1548_/A VGND VGND VPWR VPWR _1533_/C sky130_fd_sc_hd__a21o_2
X_1449_ _1034_/A _1034_/B _1443_/A VGND VGND VPWR VPWR _1450_/C sky130_fd_sc_hd__a21oi_2
XTAP_TAPCELL_ROW_2_123 VGND VPWR sky130_fd_sc_hd__tapvpwrvgnd_1
XFILLER_23_33 VGND VGND VPWR VPWR sky130_fd_sc_hd__decap_3
XFILLER_23_66 VGND VGND VPWR VPWR sky130_fd_sc_hd__decap_3
XFILLER_3_3 VGND VGND VPWR VPWR sky130_fd_sc_hd__decap_3
XFILLER_0_15 VGND VGND VPWR VPWR sky130_fd_sc_hd__decap_3
XFILLER_48_41 VGND VGND VPWR VPWR sky130_fd_sc_hd__decap_3
XFILLER_9_24 VGND VGND VPWR VPWR sky130_fd_sc_hd__decap_3
XTAP_TAPCELL_ROW_16_203 VGND VPWR sky130_fd_sc_hd__tapvpwrvgnd_1
XFILLER_36_3 VGND VGND VPWR VPWR sky130_fd_sc_hd__fill_1
X_1303_ _1535_/A _1333_/B _1298_/X _1374_/A VGND VGND VPWR VPWR _1305_/A sky130_fd_sc_hd__a2bb2o_4
XFILLER_49_182 VGND VGND VPWR VPWR sky130_fd_sc_hd__fill_2
X_1234_ _0988_/Y _1214_/X _0983_/B VGND VGND VPWR VPWR _1236_/A sky130_fd_sc_hd__a21oi_2
X_1165_ _1220_/A _1165_/B VGND VGND VPWR VPWR _1166_/A sky130_fd_sc_hd__nand2_2
X_1096_ _1275_/A _1089_/X _1095_/X _1374_/A VGND VGND VPWR VPWR _1096_/X sky130_fd_sc_hd__o211a_2
XTAP_TAPCELL_ROW_47_372 VGND VPWR sky130_fd_sc_hd__tapvpwrvgnd_1
XTAP_TAPCELL_ROW_39_328 VGND VPWR sky130_fd_sc_hd__tapvpwrvgnd_1
XFILLER_20_200 VGND VGND VPWR VPWR sky130_fd_sc_hd__decap_3
XFILLER_20_222 VGND VGND VPWR VPWR sky130_fd_sc_hd__decap_3
XFILLER_20_244 VGND VGND VPWR VPWR sky130_fd_sc_hd__decap_3
X_0949_ _1548_/A _0940_/X _0948_/X VGND VGND VPWR VPWR _0949_/Y sky130_fd_sc_hd__a21oi_2
XFILLER_18_11 VGND VGND VPWR VPWR sky130_fd_sc_hd__fill_1
XFILLER_18_44 VGND VGND VPWR VPWR sky130_fd_sc_hd__decap_3
XFILLER_18_88 VGND VGND VPWR VPWR sky130_fd_sc_hd__decap_3
XFILLER_34_21 VGND VGND VPWR VPWR sky130_fd_sc_hd__decap_3
XFILLER_11_244 VGND VGND VPWR VPWR sky130_fd_sc_hd__decap_3
XFILLER_11_266 VGND VGND VPWR VPWR sky130_fd_sc_hd__fill_2
XFILLER_11_277 VGND VGND VPWR VPWR sky130_fd_sc_hd__decap_3
XFILLER_34_65 VGND VGND VPWR VPWR sky130_fd_sc_hd__decap_3
XFILLER_50_53 VGND VGND VPWR VPWR sky130_fd_sc_hd__fill_1
XFILLER_38_119 VGND VGND VPWR VPWR sky130_fd_sc_hd__decap_3
XFILLER_46_141 VGND VGND VPWR VPWR sky130_fd_sc_hd__decap_3
XTAP_TAPCELL_ROW_36_309 VGND VPWR sky130_fd_sc_hd__tapvpwrvgnd_1
XTAP_TAPCELL_ROW_44_353 VGND VPWR sky130_fd_sc_hd__tapvpwrvgnd_1
XFILLER_6_270 VGND VGND VPWR VPWR sky130_fd_sc_hd__decap_3
XFILLER_37_185 VGND VGND VPWR VPWR sky130_fd_sc_hd__decap_3
X_1217_ _1452_/A _1217_/B VGND VGND VPWR VPWR _1217_/Y sky130_fd_sc_hd__nor2_2
X_1148_ _1081_/X _1117_/X _1145_/X _1175_/A VGND VGND VPWR VPWR _1148_/X sky130_fd_sc_hd__a22o_2
X_1079_ _1072_/X _1078_/X _1416_/B VGND VGND VPWR VPWR _1079_/X sky130_fd_sc_hd__mux2_4
XTAP_TAPCELL_ROW_50_389 VGND VPWR sky130_fd_sc_hd__tapvpwrvgnd_1
XFILLER_29_54 VGND VGND VPWR VPWR sky130_fd_sc_hd__fill_2
XFILLER_45_20 VGND VGND VPWR VPWR sky130_fd_sc_hd__decap_3
XFILLER_31_306 VGND VGND VPWR VPWR sky130_fd_sc_hd__decap_3
XFILLER_43_144 VGND VGND VPWR VPWR sky130_fd_sc_hd__decap_3
XFILLER_43_177 VGND VGND VPWR VPWR sky130_fd_sc_hd__fill_1
XFILLER_45_53 VGND VGND VPWR VPWR sky130_fd_sc_hd__decap_3
XFILLER_45_86 VGND VGND VPWR VPWR sky130_fd_sc_hd__decap_3
XFILLER_6_58 VGND VGND VPWR VPWR sky130_fd_sc_hd__decap_3
XFILLER_3_273 VGND VGND VPWR VPWR sky130_fd_sc_hd__decap_3
XFILLER_3_284 VGND VGND VPWR VPWR sky130_fd_sc_hd__decap_3
XFILLER_34_144 VGND VGND VPWR VPWR sky130_fd_sc_hd__decap_3
X_1002_ _1406_/B _1408_/B VGND VGND VPWR VPWR _1389_/B sky130_fd_sc_hd__nor2_2
XFILLER_15_78 VGND VGND VPWR VPWR sky130_fd_sc_hd__decap_3
XFILLER_40_103 VGND VGND VPWR VPWR sky130_fd_sc_hd__decap_3
XFILLER_40_136 VGND VGND VPWR VPWR sky130_fd_sc_hd__decap_3
XFILLER_31_11 VGND VGND VPWR VPWR sky130_fd_sc_hd__decap_3
Xrebuffer632 _1070_/S0 VGND VGND VPWR VPWR rebuffer632/X sky130_fd_sc_hd__buf_2
XFILLER_0_221 VGND VGND VPWR VPWR sky130_fd_sc_hd__decap_3
XFILLER_0_265 VGND VGND VPWR VPWR sky130_fd_sc_hd__decap_3
XFILLER_0_287 VGND VGND VPWR VPWR sky130_fd_sc_hd__decap_3
XFILLER_48_225 VGND VGND VPWR VPWR sky130_fd_sc_hd__decap_3
Xoutput77 output77/A VGND VGND VPWR VPWR result[17] sky130_fd_sc_hd__buf_6
Xoutput88 output88/A VGND VGND VPWR VPWR result[27] sky130_fd_sc_hd__buf_8
Xoutput99 _1673_/B VGND VGND VPWR VPWR result[8] sky130_fd_sc_hd__buf_8
XFILLER_16_133 VGND VGND VPWR VPWR sky130_fd_sc_hd__decap_3
XFILLER_16_144 VGND VGND VPWR VPWR sky130_fd_sc_hd__decap_3
XFILLER_48_247 VGND VGND VPWR VPWR sky130_fd_sc_hd__decap_3
XFILLER_31_169 VGND VGND VPWR VPWR sky130_fd_sc_hd__fill_2
X_1620_ _1620_/A _1620_/B _1620_/C VGND VGND VPWR VPWR _1621_/D sky130_fd_sc_hd__and3_2
X_1551_ _1480_/X _1548_/X _1550_/X _0937_/Y VGND VGND VPWR VPWR _1552_/C sky130_fd_sc_hd__o22a_2
X_1482_ _1549_/A2 _1410_/X _1481_/X VGND VGND VPWR VPWR _1482_/X sky130_fd_sc_hd__a21o_2
XFILLER_39_225 VGND VGND VPWR VPWR sky130_fd_sc_hd__decap_3
XFILLER_39_269 VGND VGND VPWR VPWR sky130_fd_sc_hd__decap_3
XFILLER_22_103 VGND VGND VPWR VPWR sky130_fd_sc_hd__fill_1
XFILLER_22_125 VGND VGND VPWR VPWR sky130_fd_sc_hd__decap_3
XTAP_TAPCELL_ROW_52_407 VGND VPWR sky130_fd_sc_hd__tapvpwrvgnd_1
XFILLER_10_309 VGND VGND VPWR VPWR sky130_fd_sc_hd__fill_1
XFILLER_30_180 VGND VGND VPWR VPWR sky130_fd_sc_hd__fill_2
XFILLER_38_291 VGND VGND VPWR VPWR sky130_fd_sc_hd__decap_3
XFILLER_13_103 VGND VGND VPWR VPWR sky130_fd_sc_hd__fill_2
XFILLER_26_77 VGND VGND VPWR VPWR sky130_fd_sc_hd__decap_3
XFILLER_26_88 VGND VGND VPWR VPWR sky130_fd_sc_hd__decap_3
XFILLER_42_32 VGND VGND VPWR VPWR sky130_fd_sc_hd__fill_1
XFILLER_42_43 VGND VGND VPWR VPWR sky130_fd_sc_hd__decap_3
XFILLER_21_191 VGND VGND VPWR VPWR sky130_fd_sc_hd__decap_3
XFILLER_5_302 VGND VGND VPWR VPWR sky130_fd_sc_hd__fill_2
Xrebuffer462 _1358_/A1 VGND VGND VPWR VPWR _1025_/B sky130_fd_sc_hd__buf_2
XFILLER_36_206 VGND VGND VPWR VPWR sky130_fd_sc_hd__decap_3
XFILLER_3_15 VGND VGND VPWR VPWR sky130_fd_sc_hd__decap_3
XFILLER_3_48 VGND VGND VPWR VPWR sky130_fd_sc_hd__decap_3
XFILLER_44_294 VGND VGND VPWR VPWR sky130_fd_sc_hd__decap_3
XFILLER_8_195 VGND VGND VPWR VPWR sky130_fd_sc_hd__fill_1
X_0982_ _0982_/A VGND VGND VPWR VPWR _1254_/D sky130_fd_sc_hd__inv_2
X_1603_ _1660_/A1 _1620_/A _1602_/X _0881_/B _1647_/C1 VGND VGND VPWR VPWR _1603_/X
+ sky130_fd_sc_hd__a221o_2
Xfanout108 _1103_/Y VGND VGND VPWR VPWR _1513_/A1 sky130_fd_sc_hd__clkdlybuf4s25_1
X_1534_ _1533_/A _1533_/C _1548_/B VGND VGND VPWR VPWR _1534_/X sky130_fd_sc_hd__a21o_2
X_1465_ _1452_/B _1451_/X _1048_/Y VGND VGND VPWR VPWR _1465_/Y sky130_fd_sc_hd__a21oi_2
X_1396_ input7/X input6/X input5/X input4/X _1396_/S0 _1432_/S1 VGND VGND VPWR VPWR
+ _1396_/X sky130_fd_sc_hd__mux4_2
XFILLER_10_117 VGND VGND VPWR VPWR sky130_fd_sc_hd__fill_1
XFILLER_50_253 VGND VGND VPWR VPWR sky130_fd_sc_hd__decap_3
XFILLER_50_286 VGND VGND VPWR VPWR sky130_fd_sc_hd__decap_3
XFILLER_12_24 VGND VGND VPWR VPWR sky130_fd_sc_hd__decap_3
XFILLER_12_46 VGND VGND VPWR VPWR sky130_fd_sc_hd__fill_1
XTAP_TAPCELL_ROW_5_143 VGND VPWR sky130_fd_sc_hd__tapvpwrvgnd_1
XFILLER_18_228 VGND VGND VPWR VPWR sky130_fd_sc_hd__fill_2
XFILLER_26_272 VGND VGND VPWR VPWR sky130_fd_sc_hd__decap_3
XFILLER_37_98 VGND VGND VPWR VPWR sky130_fd_sc_hd__fill_1
XTAP_TAPCELL_ROW_28_267 VGND VPWR sky130_fd_sc_hd__tapvpwrvgnd_1
XFILLER_41_286 VGND VGND VPWR VPWR sky130_fd_sc_hd__decap_3
XFILLER_5_110 VGND VGND VPWR VPWR sky130_fd_sc_hd__fill_2
XFILLER_52_9 VGND VGND VPWR VPWR sky130_fd_sc_hd__decap_3
Xrebuffer292 _0963_/Y VGND VGND VPWR VPWR _1133_/B sky130_fd_sc_hd__buf_2
XFILLER_24_209 VGND VGND VPWR VPWR sky130_fd_sc_hd__decap_3
X_1250_ _1250_/A _1250_/B _1250_/C VGND VGND VPWR VPWR _1670_/A sky130_fd_sc_hd__or3_4
X_1181_ _1181_/A _1181_/B VGND VGND VPWR VPWR _1181_/X sky130_fd_sc_hd__xor2_2
XFILLER_17_250 VGND VGND VPWR VPWR sky130_fd_sc_hd__fill_2
XFILLER_32_253 VGND VGND VPWR VPWR sky130_fd_sc_hd__decap_3
XFILLER_32_275 VGND VGND VPWR VPWR sky130_fd_sc_hd__decap_3
X_0965_ _0962_/A _0965_/B VGND VGND VPWR VPWR _1154_/B sky130_fd_sc_hd__and2b_2
X_0896_ _0896_/A _0896_/B VGND VGND VPWR VPWR _0897_/B sky130_fd_sc_hd__or2_2
X_1517_ _1511_/A _1511_/B _0929_/B VGND VGND VPWR VPWR _1519_/C sky130_fd_sc_hd__o21a_2
X_1448_ _1447_/X _1462_/C VGND VGND VPWR VPWR _1461_/C sky130_fd_sc_hd__and2b_2
XFILLER_15_209 VGND VGND VPWR VPWR sky130_fd_sc_hd__fill_2
XFILLER_23_220 VGND VGND VPWR VPWR sky130_fd_sc_hd__decap_3
X_1379_ _1379_/A _1379_/B VGND VGND VPWR VPWR _1379_/X sky130_fd_sc_hd__or2_2
XTAP_TAPCELL_ROW_2_124 VGND VPWR sky130_fd_sc_hd__tapvpwrvgnd_1
XFILLER_23_253 VGND VGND VPWR VPWR sky130_fd_sc_hd__decap_3
XFILLER_23_78 VGND VGND VPWR VPWR sky130_fd_sc_hd__fill_1
XFILLER_0_27 VGND VGND VPWR VPWR sky130_fd_sc_hd__fill_1
XFILLER_0_38 VGND VGND VPWR VPWR sky130_fd_sc_hd__decap_3
XFILLER_46_301 VGND VGND VPWR VPWR sky130_fd_sc_hd__decap_3
XFILLER_14_253 VGND VGND VPWR VPWR sky130_fd_sc_hd__fill_1
XFILLER_9_36 VGND VGND VPWR VPWR sky130_fd_sc_hd__decap_3
XTAP_TAPCELL_ROW_16_204 VGND VPWR sky130_fd_sc_hd__tapvpwrvgnd_1
XFILLER_50_6 VGND VGND VPWR VPWR sky130_fd_sc_hd__decap_3
X_1302_ _1452_/A _1007_/B _1007_/A _1453_/A1 VGND VGND VPWR VPWR _1305_/B sky130_fd_sc_hd__a2bb2o_2
X_1233_ _1254_/C _1217_/B _1212_/X _1232_/Y _1104_/X VGND VGND VPWR VPWR _1250_/A
+ sky130_fd_sc_hd__a311oi_2
X_1164_ _0966_/B _0965_/B _0957_/B input1/X _1135_/S _1134_/A VGND VGND VPWR VPWR
+ _1165_/B sky130_fd_sc_hd__mux4_2
X_1095_ _1193_/A _1091_/X _1094_/X VGND VGND VPWR VPWR _1095_/X sky130_fd_sc_hd__a21o_2
XTAP_TAPCELL_ROW_47_373 VGND VPWR sky130_fd_sc_hd__tapvpwrvgnd_1
XTAP_TAPCELL_ROW_39_329 VGND VPWR sky130_fd_sc_hd__tapvpwrvgnd_1
X_0948_ _1548_/B _0946_/X _0947_/X VGND VGND VPWR VPWR _0948_/X sky130_fd_sc_hd__a21o_2
X_0879_ _1392_/B _1417_/B VGND VGND VPWR VPWR _0881_/B sky130_fd_sc_hd__nor2_2
XFILLER_18_23 VGND VGND VPWR VPWR sky130_fd_sc_hd__decap_3
XFILLER_18_78 VGND VGND VPWR VPWR sky130_fd_sc_hd__decap_3
XFILLER_34_44 VGND VGND VPWR VPWR sky130_fd_sc_hd__decap_3
XFILLER_34_77 VGND VGND VPWR VPWR sky130_fd_sc_hd__decap_3
XFILLER_11_256 VGND VGND VPWR VPWR sky130_fd_sc_hd__fill_2
XFILLER_50_21 VGND VGND VPWR VPWR sky130_fd_sc_hd__decap_3
XFILLER_50_32 VGND VGND VPWR VPWR sky130_fd_sc_hd__decap_3
XFILLER_7_238 VGND VGND VPWR VPWR sky130_fd_sc_hd__decap_3
Xload_slew119 _1184_/A1 VGND VGND VPWR VPWR _1555_/B2 sky130_fd_sc_hd__clkbuf_4
XTAP_TAPCELL_ROW_44_354 VGND VPWR sky130_fd_sc_hd__tapvpwrvgnd_1
XFILLER_6_282 VGND VGND VPWR VPWR sky130_fd_sc_hd__decap_3
X_1216_ _1113_/X _1122_/X _1123_/X _1125_/X _1124_/S _1472_/A VGND VGND VPWR VPWR
+ _1216_/X sky130_fd_sc_hd__mux4_2
X_1147_ _1144_/X _1313_/C _1178_/S VGND VGND VPWR VPWR _1147_/X sky130_fd_sc_hd__mux2_4
X_1078_ _1392_/A _1073_/X _1076_/X _1074_/X _1220_/A _1600_/S VGND VGND VPWR VPWR
+ _1078_/X sky130_fd_sc_hd__mux4_2
XFILLER_20_35 VGND VGND VPWR VPWR sky130_fd_sc_hd__decap_3
XFILLER_20_68 VGND VGND VPWR VPWR sky130_fd_sc_hd__decap_3
XFILLER_29_77 VGND VGND VPWR VPWR sky130_fd_sc_hd__decap_3
XFILLER_45_32 VGND VGND VPWR VPWR sky130_fd_sc_hd__decap_3
XFILLER_6_15 VGND VGND VPWR VPWR sky130_fd_sc_hd__decap_3
XFILLER_13_6 VGND VGND VPWR VPWR sky130_fd_sc_hd__decap_3
XFILLER_3_296 VGND VGND VPWR VPWR sky130_fd_sc_hd__decap_3
XFILLER_34_167 VGND VGND VPWR VPWR sky130_fd_sc_hd__decap_3
XFILLER_34_189 VGND VGND VPWR VPWR sky130_fd_sc_hd__decap_3
X_1001_ _1001_/A input7/X VGND VGND VPWR VPWR _1408_/B sky130_fd_sc_hd__and2_2
XFILLER_15_57 VGND VGND VPWR VPWR sky130_fd_sc_hd__decap_3
XFILLER_25_134 VGND VGND VPWR VPWR sky130_fd_sc_hd__fill_2
XFILLER_25_156 VGND VGND VPWR VPWR sky130_fd_sc_hd__decap_3
XFILLER_0_277 VGND VGND VPWR VPWR sky130_fd_sc_hd__decap_3
XFILLER_0_299 VGND VGND VPWR VPWR sky130_fd_sc_hd__decap_3
XFILLER_48_259 VGND VGND VPWR VPWR sky130_fd_sc_hd__decap_3
Xoutput78 _1679_/B VGND VGND VPWR VPWR result[18] sky130_fd_sc_hd__buf_8
Xoutput89 _1678_/D VGND VGND VPWR VPWR result[28] sky130_fd_sc_hd__buf_8
XFILLER_16_101 VGND VGND VPWR VPWR sky130_fd_sc_hd__decap_3
XFILLER_31_159 VGND VGND VPWR VPWR sky130_fd_sc_hd__decap_3
X_1550_ _1548_/A _1519_/C _0939_/B _1533_/A VGND VGND VPWR VPWR _1550_/X sky130_fd_sc_hd__o211a_2
X_1481_ _1481_/A _1481_/B VGND VGND VPWR VPWR _1481_/X sky130_fd_sc_hd__or2_2
XFILLER_39_204 VGND VGND VPWR VPWR sky130_fd_sc_hd__decap_3
XFILLER_47_281 VGND VGND VPWR VPWR sky130_fd_sc_hd__decap_3
XFILLER_22_159 VGND VGND VPWR VPWR sky130_fd_sc_hd__fill_1
XFILLER_30_170 VGND VGND VPWR VPWR sky130_fd_sc_hd__fill_1
X_1679_ _1679_/A _1679_/B _1679_/C _1679_/D VGND VGND VPWR VPWR _1681_/C sky130_fd_sc_hd__or4_4
XFILLER_26_34 VGND VGND VPWR VPWR sky130_fd_sc_hd__decap_3
XFILLER_45_218 VGND VGND VPWR VPWR sky130_fd_sc_hd__decap_3
XFILLER_42_55 VGND VGND VPWR VPWR sky130_fd_sc_hd__decap_3
XFILLER_9_119 VGND VGND VPWR VPWR sky130_fd_sc_hd__fill_1
XFILLER_3_27 VGND VGND VPWR VPWR sky130_fd_sc_hd__decap_3
Xrebuffer463 _1358_/A1 VGND VGND VPWR VPWR _1337_/A0 sky130_fd_sc_hd__buf_2
XFILLER_29_281 VGND VGND VPWR VPWR sky130_fd_sc_hd__decap_3
XPHY_EDGE_ROW_48_Left_101 VGND VGND VPWR VPWR sky130_fd_sc_hd__decap_3
XFILLER_44_240 VGND VGND VPWR VPWR sky130_fd_sc_hd__fill_2
X_0981_ _0981_/A _0981_/B VGND VGND VPWR VPWR _0981_/X sky130_fd_sc_hd__xor2_4
XFILLER_8_185 VGND VGND VPWR VPWR sky130_fd_sc_hd__decap_3
X_1602_ _1602_/A0 _1470_/X _1539_/X _1600_/X _1588_/S _1526_/S VGND VGND VPWR VPWR
+ _1602_/X sky130_fd_sc_hd__mux4_2
Xfanout109 _1103_/Y VGND VGND VPWR VPWR _1656_/A sky130_fd_sc_hd__clkdlybuf4s25_1
X_1533_ _1533_/A _1548_/B _1533_/C VGND VGND VPWR VPWR _1533_/Y sky130_fd_sc_hd__nand3_2
X_1464_ _1464_/A _1464_/B _1464_/C VGND VGND VPWR VPWR _1476_/C sky130_fd_sc_hd__or3_4
X_1395_ _1416_/B _1395_/B VGND VGND VPWR VPWR _1395_/Y sky130_fd_sc_hd__nor2_2
XFILLER_35_251 VGND VGND VPWR VPWR sky130_fd_sc_hd__decap_3
XFILLER_35_284 VGND VGND VPWR VPWR sky130_fd_sc_hd__decap_3
XFILLER_50_243 VGND VGND VPWR VPWR sky130_fd_sc_hd__decap_3
XFILLER_50_265 VGND VGND VPWR VPWR sky130_fd_sc_hd__decap_3
XFILLER_50_298 VGND VGND VPWR VPWR sky130_fd_sc_hd__decap_3
XFILLER_12_69 VGND VGND VPWR VPWR sky130_fd_sc_hd__fill_1
XFILLER_37_44 VGND VGND VPWR VPWR sky130_fd_sc_hd__fill_1
XFILLER_37_55 VGND VGND VPWR VPWR sky130_fd_sc_hd__fill_1
XFILLER_26_262 VGND VGND VPWR VPWR sky130_fd_sc_hd__decap_3
XFILLER_41_221 VGND VGND VPWR VPWR sky130_fd_sc_hd__decap_3
XFILLER_41_243 VGND VGND VPWR VPWR sky130_fd_sc_hd__decap_3
XTAP_TAPCELL_ROW_28_268 VGND VPWR sky130_fd_sc_hd__tapvpwrvgnd_1
XFILLER_41_298 VGND VGND VPWR VPWR sky130_fd_sc_hd__decap_3
XFILLER_5_133 VGND VGND VPWR VPWR sky130_fd_sc_hd__fill_2
XFILLER_17_262 VGND VGND VPWR VPWR sky130_fd_sc_hd__decap_3
X_1180_ _1392_/C _1178_/X _1179_/X _1080_/Y VGND VGND VPWR VPWR _1180_/X sky130_fd_sc_hd__a22o_4
XFILLER_32_221 VGND VGND VPWR VPWR sky130_fd_sc_hd__decap_3
XFILLER_32_287 VGND VGND VPWR VPWR sky130_fd_sc_hd__decap_3
X_0964_ _1132_/A _1133_/B VGND VGND VPWR VPWR _1155_/S sky130_fd_sc_hd__nand2_2
X_1516_ _0945_/A _0945_/B _1498_/X _1533_/A _0935_/A VGND VGND VPWR VPWR _1531_/B
+ sky130_fd_sc_hd__a32o_2
X_0895_ _0896_/A _0896_/B VGND VGND VPWR VPWR _0895_/Y sky130_fd_sc_hd__nor2_2
X_1447_ _1479_/A _1054_/Y _1427_/X _1464_/A VGND VGND VPWR VPWR _1447_/X sky130_fd_sc_hd__a31o_2
X_1378_ _1221_/Y _1377_/X _1526_/S VGND VGND VPWR VPWR _1378_/X sky130_fd_sc_hd__mux2_1
XTAP_TAPCELL_ROW_2_125 VGND VPWR sky130_fd_sc_hd__tapvpwrvgnd_1
XTAP_TAPCELL_ROW_25_249 VGND VPWR sky130_fd_sc_hd__tapvpwrvgnd_1
XFILLER_23_57 VGND VGND VPWR VPWR sky130_fd_sc_hd__decap_3
XTAP_TAPCELL_ROW_33_293 VGND VPWR sky130_fd_sc_hd__tapvpwrvgnd_1
XFILLER_48_21 VGND VGND VPWR VPWR sky130_fd_sc_hd__decap_3
XFILLER_48_32 VGND VGND VPWR VPWR sky130_fd_sc_hd__decap_3
XFILLER_48_65 VGND VGND VPWR VPWR sky130_fd_sc_hd__fill_1
XFILLER_9_15 VGND VGND VPWR VPWR sky130_fd_sc_hd__decap_3
XPHY_EDGE_ROW_24_Left_77 VGND VGND VPWR VPWR sky130_fd_sc_hd__decap_3
X_1301_ _1137_/Y _1300_/X _1472_/A VGND VGND VPWR VPWR _1301_/X sky130_fd_sc_hd__mux2_1
X_1232_ _1217_/B _1212_/X _1254_/C VGND VGND VPWR VPWR _1232_/Y sky130_fd_sc_hd__a21oi_2
XFILLER_52_305 VGND VGND VPWR VPWR sky130_fd_sc_hd__decap_3
X_1163_ _1275_/A _1159_/X _1162_/X _1560_/A1 VGND VGND VPWR VPWR _1169_/C sky130_fd_sc_hd__o211a_2
X_1094_ _1226_/C _1092_/X _1093_/X _0861_/A _1266_/A VGND VGND VPWR VPWR _1094_/X
+ sky130_fd_sc_hd__a221o_2
XTAP_TAPCELL_ROW_47_374 VGND VPWR sky130_fd_sc_hd__tapvpwrvgnd_1
XFILLER_20_213 VGND VGND VPWR VPWR sky130_fd_sc_hd__fill_1
X_0947_ _0938_/A _0947_/B VGND VGND VPWR VPWR _0947_/X sky130_fd_sc_hd__and2b_2
X_0878_ _1275_/B _1069_/C _0878_/C _0878_/D VGND VGND VPWR VPWR _1417_/B sky130_fd_sc_hd__or4_2
XFILLER_18_35 VGND VGND VPWR VPWR sky130_fd_sc_hd__decap_3
XFILLER_34_56 VGND VGND VPWR VPWR sky130_fd_sc_hd__decap_3
XFILLER_50_44 VGND VGND VPWR VPWR sky130_fd_sc_hd__decap_3
XFILLER_50_99 VGND VGND VPWR VPWR sky130_fd_sc_hd__decap_3
XFILLER_7_206 VGND VGND VPWR VPWR sky130_fd_sc_hd__decap_3
XTAP_TAPCELL_ROW_21_230 VGND VPWR sky130_fd_sc_hd__tapvpwrvgnd_1
XFILLER_34_305 VGND VGND VPWR VPWR sky130_fd_sc_hd__decap_3
XTAP_TAPCELL_ROW_44_355 VGND VPWR sky130_fd_sc_hd__tapvpwrvgnd_1
XFILLER_6_261 VGND VGND VPWR VPWR sky130_fd_sc_hd__decap_3
XFILLER_37_165 VGND VGND VPWR VPWR sky130_fd_sc_hd__decap_3
X_1215_ _1215_/A _1215_/B _1215_/C VGND VGND VPWR VPWR _1215_/Y sky130_fd_sc_hd__nand3_2
X_1146_ _1175_/A _1145_/X _1177_/A VGND VGND VPWR VPWR _1313_/C sky130_fd_sc_hd__a21bo_2
XFILLER_37_176 VGND VGND VPWR VPWR sky130_fd_sc_hd__decap_3
XFILLER_52_113 VGND VGND VPWR VPWR sky130_fd_sc_hd__decap_3
X_1077_ _1116_/A _1243_/S VGND VGND VPWR VPWR _1177_/A sky130_fd_sc_hd__nand2_2
XFILLER_4_209 VGND VGND VPWR VPWR sky130_fd_sc_hd__fill_1
XFILLER_28_110 VGND VGND VPWR VPWR sky130_fd_sc_hd__decap_3
XFILLER_28_154 VGND VGND VPWR VPWR sky130_fd_sc_hd__decap_3
XFILLER_28_176 VGND VGND VPWR VPWR sky130_fd_sc_hd__fill_2
XFILLER_29_89 VGND VGND VPWR VPWR sky130_fd_sc_hd__fill_2
XFILLER_43_102 VGND VGND VPWR VPWR sky130_fd_sc_hd__fill_1
XFILLER_43_113 VGND VGND VPWR VPWR sky130_fd_sc_hd__decap_3
XFILLER_45_11 VGND VGND VPWR VPWR sky130_fd_sc_hd__decap_3
XFILLER_45_44 VGND VGND VPWR VPWR sky130_fd_sc_hd__decap_3
XFILLER_45_77 VGND VGND VPWR VPWR sky130_fd_sc_hd__decap_3
XFILLER_45_99 VGND VGND VPWR VPWR sky130_fd_sc_hd__decap_3
XFILLER_10_80 VGND VGND VPWR VPWR sky130_fd_sc_hd__decap_3
XFILLER_3_264 VGND VGND VPWR VPWR sky130_fd_sc_hd__decap_3
XFILLER_6_27 VGND VGND VPWR VPWR sky130_fd_sc_hd__fill_1
XFILLER_6_38 VGND VGND VPWR VPWR sky130_fd_sc_hd__fill_2
XFILLER_19_110 VGND VGND VPWR VPWR sky130_fd_sc_hd__fill_2
XFILLER_19_143 VGND VGND VPWR VPWR sky130_fd_sc_hd__decap_3
X_1000_ _1001_/A input7/X VGND VGND VPWR VPWR _1406_/B sky130_fd_sc_hd__nor2_2
XFILLER_19_187 VGND VGND VPWR VPWR sky130_fd_sc_hd__decap_3
XFILLER_19_198 VGND VGND VPWR VPWR sky130_fd_sc_hd__fill_2
XPHY_EDGE_ROW_27_Left_80 VGND VGND VPWR VPWR sky130_fd_sc_hd__decap_3
XPHY_EDGE_ROW_11_Left_64 VGND VGND VPWR VPWR sky130_fd_sc_hd__decap_3
X_1129_ _1102_/A _0958_/Y _0957_/Y VGND VGND VPWR VPWR _1129_/X sky130_fd_sc_hd__o21a_4
XFILLER_15_47 VGND VGND VPWR VPWR sky130_fd_sc_hd__fill_2
XFILLER_31_35 VGND VGND VPWR VPWR sky130_fd_sc_hd__fill_2
XFILLER_31_46 VGND VGND VPWR VPWR sky130_fd_sc_hd__decap_3
XFILLER_31_57 VGND VGND VPWR VPWR sky130_fd_sc_hd__fill_1
XFILLER_0_245 VGND VGND VPWR VPWR sky130_fd_sc_hd__decap_3
XFILLER_0_256 VGND VGND VPWR VPWR sky130_fd_sc_hd__decap_3
XFILLER_48_216 VGND VGND VPWR VPWR sky130_fd_sc_hd__decap_3
Xoutput79 output79/A VGND VGND VPWR VPWR result[19] sky130_fd_sc_hd__buf_8
XPHY_EDGE_ROW_19_Right_19 VGND VGND VPWR VPWR sky130_fd_sc_hd__decap_3
X_1480_ _1452_/B _1044_/Y _1450_/C _1481_/B _1048_/B VGND VGND VPWR VPWR _1480_/X
+ sky130_fd_sc_hd__o221a_2
XPHY_EDGE_ROW_28_Right_28 VGND VGND VPWR VPWR sky130_fd_sc_hd__decap_3
XFILLER_47_271 VGND VGND VPWR VPWR sky130_fd_sc_hd__decap_3
XFILLER_47_293 VGND VGND VPWR VPWR sky130_fd_sc_hd__decap_3
XPHY_EDGE_ROW_37_Right_37 VGND VGND VPWR VPWR sky130_fd_sc_hd__decap_3
XFILLER_15_190 VGND VGND VPWR VPWR sky130_fd_sc_hd__fill_1
XFILLER_22_116 VGND VGND VPWR VPWR sky130_fd_sc_hd__decap_3
X_1678_ _1678_/A _1678_/B _1678_/C _1678_/D VGND VGND VPWR VPWR _1682_/D sky130_fd_sc_hd__or4_4
XPHY_EDGE_ROW_46_Right_46 VGND VGND VPWR VPWR sky130_fd_sc_hd__decap_3
XFILLER_26_46 VGND VGND VPWR VPWR sky130_fd_sc_hd__decap_3
XFILLER_26_68 VGND VGND VPWR VPWR sky130_fd_sc_hd__decap_3
Xrebuffer464 _0995_/B VGND VGND VPWR VPWR _1352_/B sky130_fd_sc_hd__buf_2
XFILLER_3_39 VGND VGND VPWR VPWR sky130_fd_sc_hd__decap_3
XFILLER_44_285 VGND VGND VPWR VPWR sky130_fd_sc_hd__decap_3
X_0980_ _0981_/A _0988_/B VGND VGND VPWR VPWR _0980_/X sky130_fd_sc_hd__or2_2
XTAP_TAPCELL_ROW_14_188 VGND VPWR sky130_fd_sc_hd__tapvpwrvgnd_1
XFILLER_8_197 VGND VGND VPWR VPWR sky130_fd_sc_hd__decap_3
X_1601_ _1601_/A _1601_/B VGND VGND VPWR VPWR _1601_/Y sky130_fd_sc_hd__nor2_2
X_1532_ _1548_/B _1532_/B VGND VGND VPWR VPWR _1532_/Y sky130_fd_sc_hd__xnor2_2
XFILLER_27_208 VGND VGND VPWR VPWR sky130_fd_sc_hd__decap_3
X_1463_ _1462_/B _1462_/C _1479_/B VGND VGND VPWR VPWR _1464_/C sky130_fd_sc_hd__a21oi_2
X_1394_ _1585_/A3 _1408_/B _1537_/A _1393_/X VGND VGND VPWR VPWR _1394_/X sky130_fd_sc_hd__a211o_2
XFILLER_35_296 VGND VGND VPWR VPWR sky130_fd_sc_hd__decap_3
XFILLER_50_200 VGND VGND VPWR VPWR sky130_fd_sc_hd__fill_1
XFILLER_10_108 VGND VGND VPWR VPWR sky130_fd_sc_hd__decap_3
XFILLER_12_15 VGND VGND VPWR VPWR sky130_fd_sc_hd__decap_3
XFILLER_50_277 VGND VGND VPWR VPWR sky130_fd_sc_hd__decap_3
XFILLER_2_307 VGND VGND VPWR VPWR sky130_fd_sc_hd__fill_1
XFILLER_5_9 VGND VGND VPWR VPWR sky130_fd_sc_hd__decap_3
XFILLER_37_34 VGND VGND VPWR VPWR sky130_fd_sc_hd__decap_3
XFILLER_37_89 VGND VGND VPWR VPWR sky130_fd_sc_hd__decap_3
XFILLER_26_241 VGND VGND VPWR VPWR sky130_fd_sc_hd__fill_1
XTAP_TAPCELL_ROW_28_269 VGND VPWR sky130_fd_sc_hd__tapvpwrvgnd_1
XFILLER_5_156 VGND VGND VPWR VPWR sky130_fd_sc_hd__fill_1
XFILLER_5_167 VGND VGND VPWR VPWR sky130_fd_sc_hd__fill_1
XFILLER_17_241 VGND VGND VPWR VPWR sky130_fd_sc_hd__decap_3
XFILLER_32_299 VGND VGND VPWR VPWR sky130_fd_sc_hd__decap_3
X_0963_ _0963_/A _0963_/B VGND VGND VPWR VPWR _0963_/Y sky130_fd_sc_hd__nand2_8
X_0894_ _0896_/A _0896_/B VGND VGND VPWR VPWR _0897_/A sky130_fd_sc_hd__nand2_2
X_1515_ _1548_/A _1515_/B _1514_/A4 VGND VGND VPWR VPWR _1515_/X sky130_fd_sc_hd__or3b_2
X_1446_ _1054_/Y _1427_/X _1479_/A VGND VGND VPWR VPWR _1462_/C sky130_fd_sc_hd__a21o_2
X_1377_ _1299_/X _1376_/X _1457_/S VGND VGND VPWR VPWR _1377_/X sky130_fd_sc_hd__mux2_1
XTAP_TAPCELL_ROW_2_126 VGND VPWR sky130_fd_sc_hd__tapvpwrvgnd_1
XFILLER_23_277 VGND VGND VPWR VPWR sky130_fd_sc_hd__decap_3
XFILLER_23_36 VGND VGND VPWR VPWR sky130_fd_sc_hd__decap_3
XFILLER_23_69 VGND VGND VPWR VPWR sky130_fd_sc_hd__decap_3
XTAP_TAPCELL_ROW_33_294 VGND VPWR sky130_fd_sc_hd__tapvpwrvgnd_1
XFILLER_3_6 VGND VGND VPWR VPWR sky130_fd_sc_hd__decap_3
XFILLER_48_44 VGND VGND VPWR VPWR sky130_fd_sc_hd__decap_3
XFILLER_0_18 VGND VGND VPWR VPWR sky130_fd_sc_hd__decap_3
XFILLER_0_29 VGND VGND VPWR VPWR sky130_fd_sc_hd__decap_3
XFILLER_14_200 VGND VGND VPWR VPWR sky130_fd_sc_hd__decap_3
XFILLER_9_27 VGND VGND VPWR VPWR sky130_fd_sc_hd__decap_3
XFILLER_13_80 VGND VGND VPWR VPWR sky130_fd_sc_hd__decap_3
XFILLER_1_192 VGND VGND VPWR VPWR sky130_fd_sc_hd__decap_3
X_1300_ _1220_/B _1299_/X _1457_/S VGND VGND VPWR VPWR _1300_/X sky130_fd_sc_hd__mux2_1
X_1231_ _1513_/A1 _1213_/Y _1230_/X VGND VGND VPWR VPWR _1673_/A sky130_fd_sc_hd__a21o_4
X_1162_ _1193_/A _1160_/X _1161_/X VGND VGND VPWR VPWR _1162_/X sky130_fd_sc_hd__a21o_2
XFILLER_20_203 VGND VGND VPWR VPWR sky130_fd_sc_hd__fill_1
X_1093_ _0966_/B _1093_/A1 _1135_/S VGND VGND VPWR VPWR _1093_/X sky130_fd_sc_hd__mux2_2
XFILLER_20_225 VGND VGND VPWR VPWR sky130_fd_sc_hd__fill_2
XFILLER_20_247 VGND VGND VPWR VPWR sky130_fd_sc_hd__decap_3
XFILLER_9_281 VGND VGND VPWR VPWR sky130_fd_sc_hd__fill_2
X_0946_ _1548_/A _1515_/B _0941_/X VGND VGND VPWR VPWR _0946_/X sky130_fd_sc_hd__a21o_2
X_0877_ _1069_/C _0878_/D _1069_/B _1313_/A VGND VGND VPWR VPWR _0877_/X sky130_fd_sc_hd__and4bb_2
X_1429_ _1405_/B _1426_/X _1427_/X _1428_/Y VGND VGND VPWR VPWR _1445_/A sky130_fd_sc_hd__o211a_2
XTAP_TAPCELL_ROW_38_320 VGND VPWR sky130_fd_sc_hd__tapvpwrvgnd_1
XFILLER_11_225 VGND VGND VPWR VPWR sky130_fd_sc_hd__fill_2
XFILLER_11_247 VGND VGND VPWR VPWR sky130_fd_sc_hd__decap_3
XFILLER_34_24 VGND VGND VPWR VPWR sky130_fd_sc_hd__decap_3
XFILLER_34_35 VGND VGND VPWR VPWR sky130_fd_sc_hd__decap_3
XFILLER_34_68 VGND VGND VPWR VPWR sky130_fd_sc_hd__decap_3
XFILLER_50_12 VGND VGND VPWR VPWR sky130_fd_sc_hd__decap_3
XTAP_TAPCELL_ROW_21_231 VGND VPWR sky130_fd_sc_hd__tapvpwrvgnd_1
XPHY_EDGE_ROW_41_Left_94 VGND VGND VPWR VPWR sky130_fd_sc_hd__decap_3
XFILLER_1_3 VGND VGND VPWR VPWR sky130_fd_sc_hd__decap_3
XFILLER_46_111 VGND VGND VPWR VPWR sky130_fd_sc_hd__decap_3
XFILLER_46_144 VGND VGND VPWR VPWR sky130_fd_sc_hd__fill_2
XTAP_TAPCELL_ROW_44_356 VGND VPWR sky130_fd_sc_hd__tapvpwrvgnd_1
XFILLER_6_273 VGND VGND VPWR VPWR sky130_fd_sc_hd__decap_3
XFILLER_37_111 VGND VGND VPWR VPWR sky130_fd_sc_hd__fill_1
XFILLER_37_155 VGND VGND VPWR VPWR sky130_fd_sc_hd__fill_1
XFILLER_37_188 VGND VGND VPWR VPWR sky130_fd_sc_hd__decap_3
X_1214_ _1215_/A _1215_/C _1215_/B VGND VGND VPWR VPWR _1214_/X sky130_fd_sc_hd__a21o_2
X_1145_ _1073_/X _1076_/X _1145_/S VGND VGND VPWR VPWR _1145_/X sky130_fd_sc_hd__mux2_1
XFILLER_40_309 VGND VGND VPWR VPWR sky130_fd_sc_hd__fill_1
X_1076_ _0896_/B _0891_/B _1076_/S VGND VGND VPWR VPWR _1076_/X sky130_fd_sc_hd__mux2_2
X_0929_ _0929_/A _0929_/B VGND VGND VPWR VPWR _1511_/A sky130_fd_sc_hd__nand2_2
XFILLER_28_122 VGND VGND VPWR VPWR sky130_fd_sc_hd__decap_3
XFILLER_29_24 VGND VGND VPWR VPWR sky130_fd_sc_hd__fill_1
XFILLER_29_57 VGND VGND VPWR VPWR sky130_fd_sc_hd__decap_3
XFILLER_28_166 VGND VGND VPWR VPWR sky130_fd_sc_hd__decap_3
XFILLER_31_309 VGND VGND VPWR VPWR sky130_fd_sc_hd__fill_1
XFILLER_43_147 VGND VGND VPWR VPWR sky130_fd_sc_hd__decap_3
XFILLER_45_23 VGND VGND VPWR VPWR sky130_fd_sc_hd__decap_3
XFILLER_45_67 VGND VGND VPWR VPWR sky130_fd_sc_hd__decap_3
XFILLER_45_89 VGND VGND VPWR VPWR sky130_fd_sc_hd__fill_2
XTAP_TAPCELL_ROW_41_337 VGND VPWR sky130_fd_sc_hd__tapvpwrvgnd_1
XFILLER_10_92 VGND VGND VPWR VPWR sky130_fd_sc_hd__decap_3
XFILLER_3_276 VGND VGND VPWR VPWR sky130_fd_sc_hd__decap_3
XFILLER_3_287 VGND VGND VPWR VPWR sky130_fd_sc_hd__decap_3
XFILLER_22_309 VGND VGND VPWR VPWR sky130_fd_sc_hd__fill_1
XFILLER_34_147 VGND VGND VPWR VPWR sky130_fd_sc_hd__decap_3
XFILLER_34_158 VGND VGND VPWR VPWR sky130_fd_sc_hd__fill_2
Xmax_cap213 _0958_/A VGND VGND VPWR VPWR _0957_/B sky130_fd_sc_hd__buf_2
XFILLER_15_26 VGND VGND VPWR VPWR sky130_fd_sc_hd__decap_3
XFILLER_25_169 VGND VGND VPWR VPWR sky130_fd_sc_hd__decap_3
XFILLER_40_106 VGND VGND VPWR VPWR sky130_fd_sc_hd__decap_3
X_1128_ _1275_/A _1124_/X _1127_/X _1560_/A1 VGND VGND VPWR VPWR _1128_/X sky130_fd_sc_hd__o211a_2
X_1059_ _1059_/A _1059_/B VGND VGND VPWR VPWR _1060_/B sky130_fd_sc_hd__or2_2
XFILLER_40_139 VGND VGND VPWR VPWR sky130_fd_sc_hd__fill_1
Xoutput69 _1678_/A VGND VGND VPWR VPWR result[0] sky130_fd_sc_hd__buf_6
XFILLER_0_268 VGND VGND VPWR VPWR sky130_fd_sc_hd__decap_3
XFILLER_48_228 VGND VGND VPWR VPWR sky130_fd_sc_hd__decap_3
XFILLER_16_136 VGND VGND VPWR VPWR sky130_fd_sc_hd__decap_3
XFILLER_16_147 VGND VGND VPWR VPWR sky130_fd_sc_hd__decap_3
XFILLER_24_191 VGND VGND VPWR VPWR sky130_fd_sc_hd__decap_3
XFILLER_39_228 VGND VGND VPWR VPWR sky130_fd_sc_hd__fill_2
XFILLER_47_250 VGND VGND VPWR VPWR sky130_fd_sc_hd__decap_3
XFILLER_22_128 VGND VGND VPWR VPWR sky130_fd_sc_hd__decap_3
XFILLER_30_150 VGND VGND VPWR VPWR sky130_fd_sc_hd__decap_3
XFILLER_30_194 VGND VGND VPWR VPWR sky130_fd_sc_hd__fill_2
XFILLER_7_60 VGND VGND VPWR VPWR sky130_fd_sc_hd__fill_2
XFILLER_7_71 VGND VGND VPWR VPWR sky130_fd_sc_hd__decap_3
X_1677_ _1677_/A _1677_/B _1677_/C _1677_/D VGND VGND VPWR VPWR _1678_/C sky130_fd_sc_hd__or4_4
XFILLER_13_117 VGND VGND VPWR VPWR sky130_fd_sc_hd__decap_3
XFILLER_38_294 VGND VGND VPWR VPWR sky130_fd_sc_hd__decap_3
XFILLER_21_150 VGND VGND VPWR VPWR sky130_fd_sc_hd__decap_3
XFILLER_21_172 VGND VGND VPWR VPWR sky130_fd_sc_hd__fill_1
XFILLER_21_194 VGND VGND VPWR VPWR sky130_fd_sc_hd__decap_3
XFILLER_42_46 VGND VGND VPWR VPWR sky130_fd_sc_hd__decap_3
Xrebuffer443 _1680_/A VGND VGND VPWR VPWR output79/A sky130_fd_sc_hd__buf_6
XFILLER_3_18 VGND VGND VPWR VPWR sky130_fd_sc_hd__decap_3
XFILLER_36_209 VGND VGND VPWR VPWR sky130_fd_sc_hd__decap_3
XFILLER_44_253 VGND VGND VPWR VPWR sky130_fd_sc_hd__decap_3
XFILLER_12_150 VGND VGND VPWR VPWR sky130_fd_sc_hd__fill_1
XFILLER_44_297 VGND VGND VPWR VPWR sky130_fd_sc_hd__decap_3
XTAP_TAPCELL_ROW_14_189 VGND VPWR sky130_fd_sc_hd__tapvpwrvgnd_1
XFILLER_8_176 VGND VGND VPWR VPWR sky130_fd_sc_hd__decap_3
X_1600_ _1567_/X _1599_/X _1600_/S VGND VGND VPWR VPWR _1600_/X sky130_fd_sc_hd__mux2_1
X_1531_ _0941_/X _1531_/B VGND VGND VPWR VPWR _1532_/B sky130_fd_sc_hd__and2b_2
X_1462_ _1479_/B _1462_/B _1462_/C VGND VGND VPWR VPWR _1464_/B sky130_fd_sc_hd__and3_2
X_1393_ _1601_/A _1406_/B _1389_/B _1555_/B2 VGND VGND VPWR VPWR _1393_/X sky130_fd_sc_hd__a2bb2o_2
XFILLER_35_242 VGND VGND VPWR VPWR sky130_fd_sc_hd__decap_3
XFILLER_35_264 VGND VGND VPWR VPWR sky130_fd_sc_hd__decap_3
XFILLER_35_275 VGND VGND VPWR VPWR sky130_fd_sc_hd__decap_3
XFILLER_50_256 VGND VGND VPWR VPWR sky130_fd_sc_hd__decap_3
XFILLER_12_27 VGND VGND VPWR VPWR sky130_fd_sc_hd__fill_1
XFILLER_50_289 VGND VGND VPWR VPWR sky130_fd_sc_hd__decap_3
XFILLER_37_57 VGND VGND VPWR VPWR sky130_fd_sc_hd__fill_2
XFILLER_37_68 VGND VGND VPWR VPWR sky130_fd_sc_hd__decap_3
XFILLER_37_79 VGND VGND VPWR VPWR sky130_fd_sc_hd__fill_2
XFILLER_26_275 VGND VGND VPWR VPWR sky130_fd_sc_hd__fill_2
XFILLER_41_289 VGND VGND VPWR VPWR sky130_fd_sc_hd__decap_3
Xrebuffer240 fanout188/A VGND VGND VPWR VPWR _1523_/S sky130_fd_sc_hd__buf_2
XFILLER_32_245 VGND VGND VPWR VPWR sky130_fd_sc_hd__fill_1
XFILLER_32_256 VGND VGND VPWR VPWR sky130_fd_sc_hd__decap_3
XFILLER_32_278 VGND VGND VPWR VPWR sky130_fd_sc_hd__decap_3
X_0962_ _0962_/A _0965_/B VGND VGND VPWR VPWR _0963_/B sky130_fd_sc_hd__nand2_2
X_0893_ _0901_/B VGND VGND VPWR VPWR _0893_/Y sky130_fd_sc_hd__inv_2
X_1514_ _0945_/B _1637_/A2 _1497_/X _1514_/A4 _1513_/X VGND VGND VPWR VPWR _1679_/D
+ sky130_fd_sc_hd__a41o_2
X_1445_ _1445_/A _1445_/B _1445_/C VGND VGND VPWR VPWR _1669_/A sky130_fd_sc_hd__or3_4
XTAP_TAPCELL_ROW_10_170 VGND VPWR sky130_fd_sc_hd__tapvpwrvgnd_1
X_1376_ _1337_/X _1375_/X _1568_/S VGND VGND VPWR VPWR _1376_/X sky130_fd_sc_hd__mux2_1
XTAP_TAPCELL_ROW_2_127 VGND VPWR sky130_fd_sc_hd__tapvpwrvgnd_1
XFILLER_23_223 VGND VGND VPWR VPWR sky130_fd_sc_hd__fill_1
XFILLER_23_256 VGND VGND VPWR VPWR sky130_fd_sc_hd__decap_3
XTAP_TAPCELL_ROW_33_295 VGND VPWR sky130_fd_sc_hd__tapvpwrvgnd_1
XFILLER_46_304 VGND VGND VPWR VPWR sky130_fd_sc_hd__decap_3
XFILLER_48_12 VGND VGND VPWR VPWR sky130_fd_sc_hd__decap_3
XFILLER_14_212 VGND VGND VPWR VPWR sky130_fd_sc_hd__decap_3
XFILLER_14_234 VGND VGND VPWR VPWR sky130_fd_sc_hd__decap_3
XFILLER_14_245 VGND VGND VPWR VPWR sky130_fd_sc_hd__decap_3
XFILLER_9_39 VGND VGND VPWR VPWR sky130_fd_sc_hd__decap_3
XFILLER_50_9 VGND VGND VPWR VPWR sky130_fd_sc_hd__decap_3
X_1230_ _1351_/B _1214_/X _1215_/Y _1229_/X VGND VGND VPWR VPWR _1230_/X sky130_fd_sc_hd__a31o_4
X_1161_ _0861_/A _1090_/X _1093_/X _1226_/C _1266_/A VGND VGND VPWR VPWR _1161_/X
+ sky130_fd_sc_hd__a221o_2
X_1092_ _0957_/B _0965_/B _1135_/S VGND VGND VPWR VPWR _1092_/X sky130_fd_sc_hd__mux2_1
X_0945_ _0945_/A _0945_/B VGND VGND VPWR VPWR _1515_/B sky130_fd_sc_hd__nand2_2
X_0876_ _1246_/C _1076_/S input1/X VGND VGND VPWR VPWR _1266_/B sky130_fd_sc_hd__or3b_2
XTAP_TAPCELL_ROW_30_276 VGND VPWR sky130_fd_sc_hd__tapvpwrvgnd_1
XFILLER_18_26 VGND VGND VPWR VPWR sky130_fd_sc_hd__fill_2
X_1428_ _1428_/A _1464_/A VGND VGND VPWR VPWR _1428_/Y sky130_fd_sc_hd__nor2_2
XFILLER_18_59 VGND VGND VPWR VPWR sky130_fd_sc_hd__fill_1
X_1359_ _1280_/X _1358_/X _1359_/S VGND VGND VPWR VPWR _1359_/X sky130_fd_sc_hd__mux2_1
XTAP_TAPCELL_ROW_38_321 VGND VPWR sky130_fd_sc_hd__tapvpwrvgnd_1
XFILLER_34_47 VGND VGND VPWR VPWR sky130_fd_sc_hd__decap_3
XFILLER_50_24 VGND VGND VPWR VPWR sky130_fd_sc_hd__decap_3
XFILLER_50_35 VGND VGND VPWR VPWR sky130_fd_sc_hd__decap_3
XTAP_TAPCELL_ROW_44_357 VGND VPWR sky130_fd_sc_hd__tapvpwrvgnd_1
XFILLER_6_285 VGND VGND VPWR VPWR sky130_fd_sc_hd__decap_3
X_1213_ _1213_/A _1213_/B VGND VGND VPWR VPWR _1213_/Y sky130_fd_sc_hd__xnor2_2
XFILLER_25_307 VGND VGND VPWR VPWR sky130_fd_sc_hd__decap_3
X_1144_ _1142_/X _1144_/A1 _1144_/S VGND VGND VPWR VPWR _1144_/X sky130_fd_sc_hd__mux2_4
X_1075_ _1073_/X _1074_/X _1600_/S VGND VGND VPWR VPWR _1075_/X sky130_fd_sc_hd__mux2_4
X_0928_ _0928_/A _0942_/B VGND VGND VPWR VPWR _1496_/A sky130_fd_sc_hd__xor2_2
X_0859_ _0965_/B _0966_/B _0859_/S VGND VGND VPWR VPWR _0859_/X sky130_fd_sc_hd__mux2_1
XFILLER_45_35 VGND VGND VPWR VPWR sky130_fd_sc_hd__decap_3
XTAP_TAPCELL_ROW_41_338 VGND VPWR sky130_fd_sc_hd__tapvpwrvgnd_1
XFILLER_6_18 VGND VGND VPWR VPWR sky130_fd_sc_hd__decap_3
XFILLER_6_29 VGND VGND VPWR VPWR sky130_fd_sc_hd__decap_3
XFILLER_3_299 VGND VGND VPWR VPWR sky130_fd_sc_hd__decap_3
XFILLER_13_9 VGND VGND VPWR VPWR sky130_fd_sc_hd__decap_3
XFILLER_19_167 VGND VGND VPWR VPWR sky130_fd_sc_hd__fill_1
XFILLER_34_115 VGND VGND VPWR VPWR sky130_fd_sc_hd__decap_3
XFILLER_33_181 VGND VGND VPWR VPWR sky130_fd_sc_hd__fill_2
X_1127_ _1391_/S0 _1125_/X _1126_/X VGND VGND VPWR VPWR _1127_/X sky130_fd_sc_hd__a21o_2
X_1058_ _1059_/A _1059_/B VGND VGND VPWR VPWR _1575_/B sky130_fd_sc_hd__nand2_2
XFILLER_33_192 VGND VGND VPWR VPWR sky130_fd_sc_hd__fill_1
XFILLER_0_225 VGND VGND VPWR VPWR sky130_fd_sc_hd__decap_3
XPHY_EDGE_ROW_1_Right_1 VGND VGND VPWR VPWR sky130_fd_sc_hd__decap_3
XFILLER_31_107 VGND VGND VPWR VPWR sky130_fd_sc_hd__decap_3
XFILLER_21_70 VGND VGND VPWR VPWR sky130_fd_sc_hd__decap_3
XFILLER_39_207 VGND VGND VPWR VPWR sky130_fd_sc_hd__fill_1
XFILLER_47_262 VGND VGND VPWR VPWR sky130_fd_sc_hd__decap_3
XFILLER_47_284 VGND VGND VPWR VPWR sky130_fd_sc_hd__decap_3
X_1676_ _1676_/A _1676_/B VGND VGND VPWR VPWR _1677_/B sky130_fd_sc_hd__or2_2
XFILLER_26_37 VGND VGND VPWR VPWR sky130_fd_sc_hd__decap_3
XFILLER_38_240 VGND VGND VPWR VPWR sky130_fd_sc_hd__decap_3
XFILLER_13_129 VGND VGND VPWR VPWR sky130_fd_sc_hd__decap_3
XFILLER_21_162 VGND VGND VPWR VPWR sky130_fd_sc_hd__decap_3
XFILLER_42_58 VGND VGND VPWR VPWR sky130_fd_sc_hd__fill_1
XFILLER_42_69 VGND VGND VPWR VPWR sky130_fd_sc_hd__decap_3
Xrebuffer477 _1498_/X VGND VGND VPWR VPWR _1514_/A4 sky130_fd_sc_hd__buf_2
Xrebuffer444 _1144_/A1 VGND VGND VPWR VPWR _1391_/A3 sky130_fd_sc_hd__buf_2
XTAP_TAPCELL_ROW_8_155 VGND VPWR sky130_fd_sc_hd__tapvpwrvgnd_1
XFILLER_29_251 VGND VGND VPWR VPWR sky130_fd_sc_hd__decap_3
XFILLER_29_273 VGND VGND VPWR VPWR sky130_fd_sc_hd__decap_3
XFILLER_29_284 VGND VGND VPWR VPWR sky130_fd_sc_hd__fill_2
XFILLER_16_92 VGND VGND VPWR VPWR sky130_fd_sc_hd__decap_3
XFILLER_8_122 VGND VGND VPWR VPWR sky130_fd_sc_hd__decap_3
X_1530_ _1637_/A2 _1515_/X _1531_/B _1529_/X VGND VGND VPWR VPWR _1680_/B sky130_fd_sc_hd__a31o_2
X_1461_ _1537_/A _1461_/B _1461_/C _1461_/D VGND VGND VPWR VPWR _1679_/B sky130_fd_sc_hd__or4_4
X_1392_ _1392_/A _1392_/B _1392_/C VGND VGND VPWR VPWR _1392_/X sky130_fd_sc_hd__and3_2
XFILLER_35_254 VGND VGND VPWR VPWR sky130_fd_sc_hd__fill_1
XFILLER_35_287 VGND VGND VPWR VPWR sky130_fd_sc_hd__decap_3
XFILLER_50_224 VGND VGND VPWR VPWR sky130_fd_sc_hd__fill_2
XFILLER_50_246 VGND VGND VPWR VPWR sky130_fd_sc_hd__decap_3
XFILLER_50_268 VGND VGND VPWR VPWR sky130_fd_sc_hd__decap_3
XFILLER_2_309 VGND VGND VPWR VPWR sky130_fd_sc_hd__fill_1
X_1659_ _1659_/A _1659_/B VGND VGND VPWR VPWR _1659_/Y sky130_fd_sc_hd__nor2_2
XFILLER_41_246 VGND VGND VPWR VPWR sky130_fd_sc_hd__decap_3
Xrebuffer241 fanout190/X VGND VGND VPWR VPWR _1599_/S sky130_fd_sc_hd__buf_2
Xrebuffer230 rebuffer632/X VGND VGND VPWR VPWR _1112_/S0 sky130_fd_sc_hd__buf_6
XFILLER_5_169 VGND VGND VPWR VPWR sky130_fd_sc_hd__decap_3
XFILLER_17_221 VGND VGND VPWR VPWR sky130_fd_sc_hd__decap_3
XFILLER_49_302 VGND VGND VPWR VPWR sky130_fd_sc_hd__decap_3
XTAP_TAPCELL_ROW_19_216 VGND VPWR sky130_fd_sc_hd__tapvpwrvgnd_1
XFILLER_17_265 VGND VGND VPWR VPWR sky130_fd_sc_hd__decap_3
X_0961_ _1137_/A _0965_/B VGND VGND VPWR VPWR _0963_/A sky130_fd_sc_hd__or2_4
XTAP_TAPCELL_ROW_27_260 VGND VPWR sky130_fd_sc_hd__tapvpwrvgnd_1
XFILLER_40_290 VGND VGND VPWR VPWR sky130_fd_sc_hd__decap_3
X_0892_ _1654_/B _0892_/B VGND VGND VPWR VPWR _0901_/B sky130_fd_sc_hd__and2_2
XTAP_TAPCELL_ROW_10_171 VGND VPWR sky130_fd_sc_hd__tapvpwrvgnd_1
XFILLER_4_73 VGND VGND VPWR VPWR sky130_fd_sc_hd__decap_3
X_1513_ _1513_/A1 _1508_/X _1519_/B _1512_/Y _1507_/X VGND VGND VPWR VPWR _1513_/X
+ sky130_fd_sc_hd__a41o_2
X_1444_ _1411_/Y _1439_/Y _1450_/B _1443_/Y _1513_/A1 VGND VGND VPWR VPWR _1445_/B
+ sky130_fd_sc_hd__o2111a_2
X_1375_ input6/X _1375_/A1 _1413_/S VGND VGND VPWR VPWR _1375_/X sky130_fd_sc_hd__mux2_1
XTAP_TAPCELL_ROW_33_296 VGND VPWR sky130_fd_sc_hd__tapvpwrvgnd_1
XFILLER_2_139 VGND VGND VPWR VPWR sky130_fd_sc_hd__fill_1
XFILLER_48_24 VGND VGND VPWR VPWR sky130_fd_sc_hd__decap_3
XFILLER_48_35 VGND VGND VPWR VPWR sky130_fd_sc_hd__decap_3
XFILLER_9_18 VGND VGND VPWR VPWR sky130_fd_sc_hd__decap_3
XFILLER_49_176 VGND VGND VPWR VPWR sky130_fd_sc_hd__decap_3
X_1160_ _0976_/B _1160_/A1 _1019_/B _1006_/B _1280_/S0 _1358_/S1 VGND VGND VPWR VPWR
+ _1160_/X sky130_fd_sc_hd__mux4_2
X_1091_ _0951_/B _0988_/B _0976_/B _1160_/A1 _1090_/S _1264_/S1 VGND VGND VPWR VPWR
+ _1091_/X sky130_fd_sc_hd__mux4_2
X_0944_ _1496_/A _1496_/B VGND VGND VPWR VPWR _0945_/B sky130_fd_sc_hd__or2_2
X_0875_ _1104_/A _1313_/A _0874_/C VGND VGND VPWR VPWR _1659_/A sky130_fd_sc_hd__or3b_2
XTAP_TAPCELL_ROW_30_277 VGND VPWR sky130_fd_sc_hd__tapvpwrvgnd_1
XFILLER_18_38 VGND VGND VPWR VPWR sky130_fd_sc_hd__fill_1
X_1427_ _1017_/X _1404_/B _1040_/Y VGND VGND VPWR VPWR _1427_/X sky130_fd_sc_hd__a21o_2
X_1358_ _1358_/A0 _1358_/A1 input3/X input2/X _1358_/S0 _1358_/S1 VGND VGND VPWR VPWR
+ _1358_/X sky130_fd_sc_hd__mux4_2
XFILLER_34_59 VGND VGND VPWR VPWR sky130_fd_sc_hd__decap_3
X_1289_ _1255_/X _1334_/A2 _1333_/C VGND VGND VPWR VPWR _1295_/B sky130_fd_sc_hd__a21o_2
XTAP_TAPCELL_ROW_38_322 VGND VPWR sky130_fd_sc_hd__tapvpwrvgnd_1
XFILLER_50_47 VGND VGND VPWR VPWR sky130_fd_sc_hd__decap_3
XTAP_TAPCELL_ROW_44_358 VGND VPWR sky130_fd_sc_hd__tapvpwrvgnd_1
XFILLER_40_80 VGND VGND VPWR VPWR sky130_fd_sc_hd__decap_3
XFILLER_6_220 VGND VGND VPWR VPWR sky130_fd_sc_hd__decap_3
XFILLER_6_264 VGND VGND VPWR VPWR sky130_fd_sc_hd__decap_3
XFILLER_1_30 VGND VGND VPWR VPWR sky130_fd_sc_hd__decap_3
XFILLER_37_113 VGND VGND VPWR VPWR sky130_fd_sc_hd__decap_3
X_1212_ _0951_/Y _1191_/A _1191_/B _1254_/D _0950_/Y VGND VGND VPWR VPWR _1212_/X
+ sky130_fd_sc_hd__a311o_2
XFILLER_1_52 VGND VGND VPWR VPWR sky130_fd_sc_hd__decap_3
XFILLER_37_179 VGND VGND VPWR VPWR sky130_fd_sc_hd__decap_3
X_1143_ _1051_/B _0943_/B _0942_/B _0941_/B _1486_/S _1116_/C VGND VGND VPWR VPWR
+ _1143_/X sky130_fd_sc_hd__mux4_2
X_1074_ _0919_/B _0914_/B _1538_/S VGND VGND VPWR VPWR _1074_/X sky130_fd_sc_hd__mux2_2
X_0927_ _0928_/A _0942_/B VGND VGND VPWR VPWR _0929_/B sky130_fd_sc_hd__nand2_2
X_0858_ input1/X _0957_/B _0859_/S VGND VGND VPWR VPWR _0858_/X sky130_fd_sc_hd__mux2_1
XFILLER_28_157 VGND VGND VPWR VPWR sky130_fd_sc_hd__fill_2
XFILLER_29_37 VGND VGND VPWR VPWR sky130_fd_sc_hd__decap_3
XFILLER_29_48 VGND VGND VPWR VPWR sky130_fd_sc_hd__decap_3
XFILLER_43_116 VGND VGND VPWR VPWR sky130_fd_sc_hd__decap_3
XFILLER_45_14 VGND VGND VPWR VPWR sky130_fd_sc_hd__decap_3
XFILLER_45_47 VGND VGND VPWR VPWR sky130_fd_sc_hd__decap_3
XFILLER_43_127 VGND VGND VPWR VPWR sky130_fd_sc_hd__fill_2
XFILLER_51_182 VGND VGND VPWR VPWR sky130_fd_sc_hd__decap_3
XFILLER_51_193 VGND VGND VPWR VPWR sky130_fd_sc_hd__fill_2
XTAP_TAPCELL_ROW_41_339 VGND VPWR sky130_fd_sc_hd__tapvpwrvgnd_1
XFILLER_3_201 VGND VGND VPWR VPWR sky130_fd_sc_hd__fill_1
XFILLER_3_223 VGND VGND VPWR VPWR sky130_fd_sc_hd__fill_1
XFILLER_10_61 VGND VGND VPWR VPWR sky130_fd_sc_hd__decap_3
XFILLER_10_83 VGND VGND VPWR VPWR sky130_fd_sc_hd__fill_1
XFILLER_19_113 VGND VGND VPWR VPWR sky130_fd_sc_hd__decap_3
XFILLER_3_267 VGND VGND VPWR VPWR sky130_fd_sc_hd__decap_3
XFILLER_19_146 VGND VGND VPWR VPWR sky130_fd_sc_hd__decap_3
XFILLER_19_81 VGND VGND VPWR VPWR sky130_fd_sc_hd__fill_1
XFILLER_42_193 VGND VGND VPWR VPWR sky130_fd_sc_hd__decap_3
X_1126_ _1226_/C _0859_/X _0861_/A _0853_/X _1266_/A VGND VGND VPWR VPWR _1126_/X
+ sky130_fd_sc_hd__a221o_2
X_1057_ _1477_/A _1056_/X _0949_/Y VGND VGND VPWR VPWR _1057_/Y sky130_fd_sc_hd__a21oi_4
XFILLER_0_248 VGND VGND VPWR VPWR sky130_fd_sc_hd__decap_3
XFILLER_0_259 VGND VGND VPWR VPWR sky130_fd_sc_hd__decap_3
XFILLER_48_219 VGND VGND VPWR VPWR sky130_fd_sc_hd__decap_3
XFILLER_24_171 VGND VGND VPWR VPWR sky130_fd_sc_hd__decap_3
XFILLER_21_82 VGND VGND VPWR VPWR sky130_fd_sc_hd__decap_3
XFILLER_47_241 VGND VGND VPWR VPWR sky130_fd_sc_hd__decap_3
XFILLER_47_274 VGND VGND VPWR VPWR sky130_fd_sc_hd__decap_3
XFILLER_22_119 VGND VGND VPWR VPWR sky130_fd_sc_hd__decap_3
XFILLER_47_296 VGND VGND VPWR VPWR sky130_fd_sc_hd__decap_3
XFILLER_30_141 VGND VGND VPWR VPWR sky130_fd_sc_hd__decap_3
XPHY_EDGE_ROW_15_Left_68 VGND VGND VPWR VPWR sky130_fd_sc_hd__decap_3
XPHY_EDGE_ROW_15_Right_15 VGND VGND VPWR VPWR sky130_fd_sc_hd__decap_3
X_1675_ _1675_/A _1675_/B VGND VGND VPWR VPWR _1677_/C sky130_fd_sc_hd__or2_2
XFILLER_26_49 VGND VGND VPWR VPWR sky130_fd_sc_hd__decap_3
XPHY_EDGE_ROW_24_Right_24 VGND VGND VPWR VPWR sky130_fd_sc_hd__decap_3
X_1109_ _1464_/A _1101_/Y _1108_/X _1098_/X VGND VGND VPWR VPWR _1109_/Y sky130_fd_sc_hd__o211ai_2
XFILLER_21_141 VGND VGND VPWR VPWR sky130_fd_sc_hd__decap_3
XFILLER_21_185 VGND VGND VPWR VPWR sky130_fd_sc_hd__decap_3
Xrebuffer456 _0981_/X VGND VGND VPWR VPWR _1213_/A sky130_fd_sc_hd__buf_2
XPHY_EDGE_ROW_33_Right_33 VGND VGND VPWR VPWR sky130_fd_sc_hd__decap_3
XTAP_TAPCELL_ROW_8_156 VGND VPWR sky130_fd_sc_hd__tapvpwrvgnd_1
XFILLER_16_71 VGND VGND VPWR VPWR sky130_fd_sc_hd__decap_3
XFILLER_44_200 VGND VGND VPWR VPWR sky130_fd_sc_hd__decap_3
XFILLER_44_222 VGND VGND VPWR VPWR sky130_fd_sc_hd__fill_2
XFILLER_44_277 VGND VGND VPWR VPWR sky130_fd_sc_hd__decap_3
XFILLER_44_288 VGND VGND VPWR VPWR sky130_fd_sc_hd__decap_3
XPHY_EDGE_ROW_42_Right_42 VGND VGND VPWR VPWR sky130_fd_sc_hd__decap_3
XFILLER_12_141 VGND VGND VPWR VPWR sky130_fd_sc_hd__decap_3
XFILLER_32_81 VGND VGND VPWR VPWR sky130_fd_sc_hd__decap_3
XPHY_EDGE_ROW_51_Right_51 VGND VGND VPWR VPWR sky130_fd_sc_hd__decap_3
X_1460_ _1513_/A1 _1450_/Y _1451_/X _1459_/X _0831_/Y VGND VGND VPWR VPWR _1461_/D
+ sky130_fd_sc_hd__a32o_2
X_1391_ _1142_/X _1145_/X _1391_/A2 _1391_/A3 _1391_/S0 _1430_/A VGND VGND VPWR VPWR
+ _1391_/X sky130_fd_sc_hd__mux4_2
XFILLER_12_18 VGND VGND VPWR VPWR sky130_fd_sc_hd__decap_3
XFILLER_35_299 VGND VGND VPWR VPWR sky130_fd_sc_hd__decap_3
XFILLER_12_29 VGND VGND VPWR VPWR sky130_fd_sc_hd__fill_1
X_1658_ _1657_/A _1065_/X _1641_/A _1657_/Y _1099_/X VGND VGND VPWR VPWR _1668_/B
+ sky130_fd_sc_hd__o221a_4
X_1589_ _1416_/X _1457_/X _1588_/X _1647_/A1 _1585_/X VGND VGND VPWR VPWR _1589_/X
+ sky130_fd_sc_hd__a221o_2
Xrebuffer242 _1070_/S0 VGND VGND VPWR VPWR _0838_/S0 sky130_fd_sc_hd__buf_2
Xrebuffer231 _0839_/X VGND VGND VPWR VPWR _1187_/A0 sky130_fd_sc_hd__buf_6
Xrebuffer220 fanout188/A VGND VGND VPWR VPWR _1538_/S sky130_fd_sc_hd__buf_2
XFILLER_17_244 VGND VGND VPWR VPWR sky130_fd_sc_hd__decap_3
XTAP_TAPCELL_ROW_19_217 VGND VPWR sky130_fd_sc_hd__tapvpwrvgnd_1
XFILLER_17_277 VGND VGND VPWR VPWR sky130_fd_sc_hd__decap_3
XFILLER_17_288 VGND VGND VPWR VPWR sky130_fd_sc_hd__fill_1
X_0960_ _0958_/Y _1101_/B _0956_/X VGND VGND VPWR VPWR _0960_/X sky130_fd_sc_hd__a21o_4
XTAP_TAPCELL_ROW_27_261 VGND VPWR sky130_fd_sc_hd__tapvpwrvgnd_1
X_1512_ _1512_/A VGND VGND VPWR VPWR _1512_/Y sky130_fd_sc_hd__inv_2
X_0891_ _0891_/A _0891_/B VGND VGND VPWR VPWR _0892_/B sky130_fd_sc_hd__or2_2
XFILLER_4_41 VGND VGND VPWR VPWR sky130_fd_sc_hd__decap_3
XFILLER_4_52 VGND VGND VPWR VPWR sky130_fd_sc_hd__decap_3
X_1443_ _1443_/A VGND VGND VPWR VPWR _1443_/Y sky130_fd_sc_hd__inv_2
X_1374_ _1374_/A _1374_/B VGND VGND VPWR VPWR _1374_/Y sky130_fd_sc_hd__nand2_2
XFILLER_23_225 VGND VGND VPWR VPWR sky130_fd_sc_hd__fill_2
XFILLER_23_247 VGND VGND VPWR VPWR sky130_fd_sc_hd__decap_3
XFILLER_23_39 VGND VGND VPWR VPWR sky130_fd_sc_hd__decap_3
XTAP_TAPCELL_ROW_33_297 VGND VPWR sky130_fd_sc_hd__tapvpwrvgnd_1
XFILLER_2_129 VGND VGND VPWR VPWR sky130_fd_sc_hd__fill_2
XFILLER_3_9 VGND VGND VPWR VPWR sky130_fd_sc_hd__decap_3
XPHY_EDGE_ROW_18_Left_71 VGND VGND VPWR VPWR sky130_fd_sc_hd__decap_3
XFILLER_48_47 VGND VGND VPWR VPWR sky130_fd_sc_hd__fill_2
XFILLER_14_203 VGND VGND VPWR VPWR sky130_fd_sc_hd__decap_3
XFILLER_13_83 VGND VGND VPWR VPWR sky130_fd_sc_hd__decap_3
XFILLER_13_94 VGND VGND VPWR VPWR sky130_fd_sc_hd__decap_3
XFILLER_52_309 VGND VGND VPWR VPWR sky130_fd_sc_hd__fill_1
X_1090_ _0951_/B _0988_/B _1090_/S VGND VGND VPWR VPWR _1090_/X sky130_fd_sc_hd__mux2_1
X_0943_ _0931_/A _0943_/B VGND VGND VPWR VPWR _1496_/B sky130_fd_sc_hd__nand2b_2
X_0874_ _1104_/A _1275_/B _0874_/C VGND VGND VPWR VPWR _0874_/X sky130_fd_sc_hd__and3b_2
XTAP_TAPCELL_ROW_30_278 VGND VPWR sky130_fd_sc_hd__tapvpwrvgnd_1
X_1426_ _1053_/A _1053_/B _1442_/A VGND VGND VPWR VPWR _1426_/X sky130_fd_sc_hd__a21o_2
X_1357_ _1193_/B _1075_/X _1357_/A2 _1071_/X _1391_/S0 _1502_/S VGND VGND VPWR VPWR
+ _1357_/X sky130_fd_sc_hd__mux4_2
X_1288_ _1288_/A _1288_/B VGND VGND VPWR VPWR _1333_/C sky130_fd_sc_hd__or2_2
XTAP_TAPCELL_ROW_38_323 VGND VPWR sky130_fd_sc_hd__tapvpwrvgnd_1
XFILLER_34_27 VGND VGND VPWR VPWR sky130_fd_sc_hd__fill_1
XFILLER_34_38 VGND VGND VPWR VPWR sky130_fd_sc_hd__decap_3
XFILLER_50_15 VGND VGND VPWR VPWR sky130_fd_sc_hd__decap_3
XFILLER_1_6 VGND VGND VPWR VPWR sky130_fd_sc_hd__decap_3
XPHY_EDGE_ROW_3_Left_56 VGND VGND VPWR VPWR sky130_fd_sc_hd__decap_3
XFILLER_34_309 VGND VGND VPWR VPWR sky130_fd_sc_hd__fill_1
XFILLER_46_114 VGND VGND VPWR VPWR sky130_fd_sc_hd__fill_2
XFILLER_24_71 VGND VGND VPWR VPWR sky130_fd_sc_hd__decap_3
XFILLER_6_210 VGND VGND VPWR VPWR sky130_fd_sc_hd__fill_1
XFILLER_6_276 VGND VGND VPWR VPWR sky130_fd_sc_hd__decap_3
XFILLER_1_42 VGND VGND VPWR VPWR sky130_fd_sc_hd__decap_3
XFILLER_37_136 VGND VGND VPWR VPWR sky130_fd_sc_hd__decap_3
X_1211_ _0951_/Y _1191_/A _1191_/B _0950_/Y VGND VGND VPWR VPWR _1213_/B sky130_fd_sc_hd__a31o_2
X_1142_ _0947_/B _1059_/B _0919_/B _0914_/B _1142_/S0 wire177/X VGND VGND VPWR VPWR
+ _1142_/X sky130_fd_sc_hd__mux4_2
XFILLER_45_180 VGND VGND VPWR VPWR sky130_fd_sc_hd__fill_2
X_1073_ _0910_/B _0905_/B _1076_/S VGND VGND VPWR VPWR _1073_/X sky130_fd_sc_hd__mux2_2
XTAP_TAPCELL_ROW_35_304 VGND VPWR sky130_fd_sc_hd__tapvpwrvgnd_1
XFILLER_20_18 VGND VGND VPWR VPWR sky130_fd_sc_hd__decap_3
XFILLER_20_29 VGND VGND VPWR VPWR sky130_fd_sc_hd__decap_3
X_0926_ _0928_/A _0942_/B VGND VGND VPWR VPWR _0929_/A sky130_fd_sc_hd__or2_2
X_0857_ _1137_/A _1145_/S VGND VGND VPWR VPWR _1246_/C sky130_fd_sc_hd__or2_2
X_1409_ _0999_/A _1370_/X _1408_/Y VGND VGND VPWR VPWR _1409_/X sky130_fd_sc_hd__o21a_2
XPHY_EDGE_ROW_45_Left_98 VGND VGND VPWR VPWR sky130_fd_sc_hd__decap_3
XFILLER_16_309 VGND VGND VPWR VPWR sky130_fd_sc_hd__fill_1
XFILLER_28_125 VGND VGND VPWR VPWR sky130_fd_sc_hd__decap_3
XFILLER_28_169 VGND VGND VPWR VPWR sky130_fd_sc_hd__fill_1
XFILLER_45_26 VGND VGND VPWR VPWR sky130_fd_sc_hd__decap_3
XFILLER_10_95 VGND VGND VPWR VPWR sky130_fd_sc_hd__decap_3
XFILLER_19_60 VGND VGND VPWR VPWR sky130_fd_sc_hd__decap_3
XFILLER_3_279 VGND VGND VPWR VPWR sky130_fd_sc_hd__fill_1
XFILLER_35_70 VGND VGND VPWR VPWR sky130_fd_sc_hd__decap_3
XFILLER_42_150 VGND VGND VPWR VPWR sky130_fd_sc_hd__decap_3
XFILLER_25_106 VGND VGND VPWR VPWR sky130_fd_sc_hd__decap_3
X_1125_ _0988_/B _0976_/B _1160_/A1 _1019_/B _1125_/S0 _1358_/S1 VGND VGND VPWR VPWR
+ _1125_/X sky130_fd_sc_hd__mux4_2
XFILLER_15_18 VGND VGND VPWR VPWR sky130_fd_sc_hd__decap_3
XFILLER_33_161 VGND VGND VPWR VPWR sky130_fd_sc_hd__decap_3
XFILLER_40_109 VGND VGND VPWR VPWR sky130_fd_sc_hd__decap_3
X_1056_ _0948_/X _1477_/B VGND VGND VPWR VPWR _1056_/X sky130_fd_sc_hd__and2b_2
Xrebuffer616 _1396_/X VGND VGND VPWR VPWR _1602_/A0 sky130_fd_sc_hd__buf_2
X_0909_ _0910_/A _0910_/B VGND VGND VPWR VPWR _1601_/B sky130_fd_sc_hd__nor2_2
XFILLER_16_139 VGND VGND VPWR VPWR sky130_fd_sc_hd__fill_1
XFILLER_24_194 VGND VGND VPWR VPWR sky130_fd_sc_hd__fill_2
XFILLER_47_253 VGND VGND VPWR VPWR sky130_fd_sc_hd__decap_3
XFILLER_46_91 VGND VGND VPWR VPWR sky130_fd_sc_hd__fill_2
XFILLER_30_197 VGND VGND VPWR VPWR sky130_fd_sc_hd__decap_3
XFILLER_7_30 VGND VGND VPWR VPWR sky130_fd_sc_hd__decap_3
XFILLER_7_74 VGND VGND VPWR VPWR sky130_fd_sc_hd__decap_3
XFILLER_7_96 VGND VGND VPWR VPWR sky130_fd_sc_hd__decap_3
X_1674_ _1674_/A _1674_/B _1674_/C _1674_/D VGND VGND VPWR VPWR _1677_/D sky130_fd_sc_hd__or4_4
XFILLER_38_297 VGND VGND VPWR VPWR sky130_fd_sc_hd__decap_3
X_1108_ _1647_/A1 _1107_/X _1105_/X _1102_/Y VGND VGND VPWR VPWR _1108_/X sky130_fd_sc_hd__o2bb2a_2
X_1039_ _1442_/B _1039_/B VGND VGND VPWR VPWR _1440_/B sky130_fd_sc_hd__nand2_2
XFILLER_21_153 VGND VGND VPWR VPWR sky130_fd_sc_hd__decap_3
XFILLER_21_197 VGND VGND VPWR VPWR sky130_fd_sc_hd__decap_3
XFILLER_42_49 VGND VGND VPWR VPWR sky130_fd_sc_hd__decap_3
XFILLER_5_308 VGND VGND VPWR VPWR sky130_fd_sc_hd__fill_2
Xrebuffer457 _0970_/A VGND VGND VPWR VPWR _1270_/A sky130_fd_sc_hd__buf_2
XTAP_TAPCELL_ROW_8_157 VGND VPWR sky130_fd_sc_hd__tapvpwrvgnd_1
XFILLER_29_220 VGND VGND VPWR VPWR sky130_fd_sc_hd__decap_3
XFILLER_44_212 VGND VGND VPWR VPWR sky130_fd_sc_hd__fill_2
XFILLER_44_256 VGND VGND VPWR VPWR sky130_fd_sc_hd__fill_1
XPHY_EDGE_ROW_32_Left_85 VGND VGND VPWR VPWR sky130_fd_sc_hd__decap_3
XFILLER_8_146 VGND VGND VPWR VPWR sky130_fd_sc_hd__decap_3
XFILLER_8_157 VGND VGND VPWR VPWR sky130_fd_sc_hd__decap_3
XFILLER_8_179 VGND VGND VPWR VPWR sky130_fd_sc_hd__decap_3
X_1390_ _1408_/A _1389_/C _1389_/B VGND VGND VPWR VPWR _1390_/Y sky130_fd_sc_hd__o21ai_2
XFILLER_35_245 VGND VGND VPWR VPWR sky130_fd_sc_hd__decap_3
XFILLER_35_278 VGND VGND VPWR VPWR sky130_fd_sc_hd__fill_2
XFILLER_50_259 VGND VGND VPWR VPWR sky130_fd_sc_hd__decap_3
X_1657_ _1657_/A _1657_/B VGND VGND VPWR VPWR _1657_/Y sky130_fd_sc_hd__nand2_2
X_1588_ _1524_/X _1587_/X _1588_/S VGND VGND VPWR VPWR _1588_/X sky130_fd_sc_hd__mux2_1
Xrebuffer287 _1050_/X VGND VGND VPWR VPWR _1477_/A sky130_fd_sc_hd__buf_8
Xrebuffer243 _1651_/X VGND VGND VPWR VPWR _1654_/C sky130_fd_sc_hd__buf_2
Xrebuffer232 fanout184/A VGND VGND VPWR VPWR _1455_/S sky130_fd_sc_hd__buf_2
Xrebuffer221 _0968_/X VGND VGND VPWR VPWR _1181_/A sky130_fd_sc_hd__buf_2
XFILLER_17_212 VGND VGND VPWR VPWR sky130_fd_sc_hd__decap_3
XFILLER_27_71 VGND VGND VPWR VPWR sky130_fd_sc_hd__decap_3
XTAP_TAPCELL_ROW_19_218 VGND VPWR sky130_fd_sc_hd__tapvpwrvgnd_1
XFILLER_32_215 VGND VGND VPWR VPWR sky130_fd_sc_hd__decap_3
XFILLER_32_259 VGND VGND VPWR VPWR sky130_fd_sc_hd__decap_3
X_0890_ _0891_/A _0891_/B VGND VGND VPWR VPWR _1654_/B sky130_fd_sc_hd__nand2_2
XTAP_TAPCELL_ROW_27_262 VGND VPWR sky130_fd_sc_hd__tapvpwrvgnd_1
X_1511_ _1511_/A _1511_/B VGND VGND VPWR VPWR _1512_/A sky130_fd_sc_hd__nor2_2
X_1442_ _1442_/A _1442_/B VGND VGND VPWR VPWR _1443_/A sky130_fd_sc_hd__nor2_2
X_1373_ _1373_/A0 _1115_/X _1122_/X _1113_/X _1391_/S0 _1430_/A VGND VGND VPWR VPWR
+ _1374_/B sky130_fd_sc_hd__mux4_2
XFILLER_23_237 VGND VGND VPWR VPWR sky130_fd_sc_hd__decap_3
XFILLER_23_259 VGND VGND VPWR VPWR sky130_fd_sc_hd__decap_3
XFILLER_48_15 VGND VGND VPWR VPWR sky130_fd_sc_hd__decap_3
XFILLER_46_307 VGND VGND VPWR VPWR sky130_fd_sc_hd__fill_1
XFILLER_14_215 VGND VGND VPWR VPWR sky130_fd_sc_hd__fill_1
XFILLER_14_248 VGND VGND VPWR VPWR sky130_fd_sc_hd__decap_3
XTAP_TAPCELL_ROW_24_243 VGND VPWR sky130_fd_sc_hd__tapvpwrvgnd_1
XFILLER_38_70 VGND VGND VPWR VPWR sky130_fd_sc_hd__decap_3
XFILLER_49_167 VGND VGND VPWR VPWR sky130_fd_sc_hd__fill_1
XFILLER_9_241 VGND VGND VPWR VPWR sky130_fd_sc_hd__decap_3
X_0942_ _0928_/A _0942_/B VGND VGND VPWR VPWR _0945_/A sky130_fd_sc_hd__nand2b_2
X_0873_ _0867_/A input1/X _1643_/A1 _0872_/X VGND VGND VPWR VPWR _0873_/X sky130_fd_sc_hd__o22a_2
XTAP_TAPCELL_ROW_30_279 VGND VPWR sky130_fd_sc_hd__tapvpwrvgnd_1
X_1425_ _1425_/A _1425_/B _1405_/X VGND VGND VPWR VPWR _1669_/C sky130_fd_sc_hd__or3b_4
XFILLER_18_29 VGND VGND VPWR VPWR sky130_fd_sc_hd__fill_1
XFILLER_28_307 VGND VGND VPWR VPWR sky130_fd_sc_hd__fill_1
X_1356_ _1335_/Y _1352_/Y _1353_/X _1355_/X VGND VGND VPWR VPWR _1356_/X sky130_fd_sc_hd__o211a_2
X_1287_ _1014_/A _1020_/B _1272_/A _1258_/Y VGND VGND VPWR VPWR _1287_/X sky130_fd_sc_hd__a211o_2
XTAP_TAPCELL_ROW_38_324 VGND VPWR sky130_fd_sc_hd__tapvpwrvgnd_1
XFILLER_11_207 VGND VGND VPWR VPWR sky130_fd_sc_hd__decap_3
XFILLER_50_27 VGND VGND VPWR VPWR sky130_fd_sc_hd__fill_1
XFILLER_50_38 VGND VGND VPWR VPWR sky130_fd_sc_hd__decap_3
XFILLER_24_83 VGND VGND VPWR VPWR sky130_fd_sc_hd__fill_1
XFILLER_6_244 VGND VGND VPWR VPWR sky130_fd_sc_hd__fill_1
XFILLER_6_288 VGND VGND VPWR VPWR sky130_fd_sc_hd__decap_3
XFILLER_1_21 VGND VGND VPWR VPWR sky130_fd_sc_hd__decap_3
XFILLER_1_87 VGND VGND VPWR VPWR sky130_fd_sc_hd__fill_1
X_1210_ _1210_/A _1210_/B _1210_/C VGND VGND VPWR VPWR _1672_/B sky130_fd_sc_hd__or3_4
X_1141_ _1261_/A _1121_/X _1128_/X _1140_/X VGND VGND VPWR VPWR _1671_/B sky130_fd_sc_hd__a211o_2
X_1072_ _1070_/X _1071_/X _1339_/S VGND VGND VPWR VPWR _1072_/X sky130_fd_sc_hd__mux2_4
XTAP_TAPCELL_ROW_35_305 VGND VPWR sky130_fd_sc_hd__tapvpwrvgnd_1
X_0925_ _1594_/A _0924_/X _0908_/Y VGND VGND VPWR VPWR _0925_/Y sky130_fd_sc_hd__o21ai_2
X_0856_ _1137_/A _1145_/S VGND VGND VPWR VPWR _0856_/Y sky130_fd_sc_hd__nor2_2
X_1408_ _1408_/A _1408_/B VGND VGND VPWR VPWR _1408_/Y sky130_fd_sc_hd__nor2_2
XFILLER_28_148 VGND VGND VPWR VPWR sky130_fd_sc_hd__decap_3
XFILLER_36_170 VGND VGND VPWR VPWR sky130_fd_sc_hd__decap_3
XFILLER_45_38 VGND VGND VPWR VPWR sky130_fd_sc_hd__decap_3
X_1339_ _1264_/X _1338_/X _1339_/S VGND VGND VPWR VPWR _1339_/X sky130_fd_sc_hd__mux2_2
XFILLER_10_52 VGND VGND VPWR VPWR sky130_fd_sc_hd__decap_3
XFILLER_10_74 VGND VGND VPWR VPWR sky130_fd_sc_hd__decap_3
XFILLER_3_225 VGND VGND VPWR VPWR sky130_fd_sc_hd__decap_3
XFILLER_19_104 VGND VGND VPWR VPWR sky130_fd_sc_hd__decap_3
XFILLER_19_72 VGND VGND VPWR VPWR sky130_fd_sc_hd__decap_3
XFILLER_34_118 VGND VGND VPWR VPWR sky130_fd_sc_hd__fill_2
XFILLER_34_129 VGND VGND VPWR VPWR sky130_fd_sc_hd__decap_3
XFILLER_51_92 VGND VGND VPWR VPWR sky130_fd_sc_hd__fill_2
XFILLER_25_3 VGND VGND VPWR VPWR sky130_fd_sc_hd__fill_2
XFILLER_2_280 VGND VGND VPWR VPWR sky130_fd_sc_hd__decap_3
XFILLER_18_192 VGND VGND VPWR VPWR sky130_fd_sc_hd__decap_3
X_1124_ _1122_/X _1123_/X _1124_/S VGND VGND VPWR VPWR _1124_/X sky130_fd_sc_hd__mux2_1
X_1055_ _1479_/B _1462_/B _1054_/Y _1049_/X _1051_/Y VGND VGND VPWR VPWR _1477_/B
+ sky130_fd_sc_hd__o221a_2
XFILLER_31_29 VGND VGND VPWR VPWR sky130_fd_sc_hd__decap_3
XFILLER_33_140 VGND VGND VPWR VPWR sky130_fd_sc_hd__decap_3
XFILLER_0_228 VGND VGND VPWR VPWR sky130_fd_sc_hd__fill_1
X_0908_ _0910_/A _0910_/B VGND VGND VPWR VPWR _0908_/Y sky130_fd_sc_hd__nand2b_2
X_0839_ _1053_/B _1034_/B _1052_/B _1051_/B _1413_/S _1432_/S1 VGND VGND VPWR VPWR
+ _0839_/X sky130_fd_sc_hd__mux4_2
XFILLER_0_239 VGND VGND VPWR VPWR sky130_fd_sc_hd__decap_3
XFILLER_21_73 VGND VGND VPWR VPWR sky130_fd_sc_hd__decap_3
XFILLER_47_265 VGND VGND VPWR VPWR sky130_fd_sc_hd__decap_3
XFILLER_47_287 VGND VGND VPWR VPWR sky130_fd_sc_hd__decap_3
X_1673_ _1673_/A _1673_/B _1673_/C VGND VGND VPWR VPWR _1674_/A sky130_fd_sc_hd__or3_4
XFILLER_38_243 VGND VGND VPWR VPWR sky130_fd_sc_hd__decap_3
XFILLER_21_110 VGND VGND VPWR VPWR sky130_fd_sc_hd__fill_2
X_1107_ _1226_/C _1107_/B VGND VGND VPWR VPWR _1107_/X sky130_fd_sc_hd__and2_2
X_1038_ _1442_/B _1039_/B VGND VGND VPWR VPWR _1404_/C sky130_fd_sc_hd__and2_2
XPHY_EDGE_ROW_5_Right_5 VGND VGND VPWR VPWR sky130_fd_sc_hd__decap_3
XFILLER_21_132 VGND VGND VPWR VPWR sky130_fd_sc_hd__decap_3
XFILLER_21_165 VGND VGND VPWR VPWR sky130_fd_sc_hd__decap_3
Xrebuffer458 _1354_/A VGND VGND VPWR VPWR _1352_/A sky130_fd_sc_hd__buf_2
XTAP_TAPCELL_ROW_8_158 VGND VPWR sky130_fd_sc_hd__tapvpwrvgnd_1
XFILLER_29_254 VGND VGND VPWR VPWR sky130_fd_sc_hd__decap_3
XFILLER_29_276 VGND VGND VPWR VPWR sky130_fd_sc_hd__decap_3
XFILLER_12_121 VGND VGND VPWR VPWR sky130_fd_sc_hd__decap_3
XFILLER_12_132 VGND VGND VPWR VPWR sky130_fd_sc_hd__decap_3
XFILLER_16_62 VGND VGND VPWR VPWR sky130_fd_sc_hd__decap_3
XFILLER_16_95 VGND VGND VPWR VPWR sky130_fd_sc_hd__decap_3
XFILLER_52_290 VGND VGND VPWR VPWR sky130_fd_sc_hd__decap_3
XFILLER_8_125 VGND VGND VPWR VPWR sky130_fd_sc_hd__decap_3
XFILLER_32_50 VGND VGND VPWR VPWR sky130_fd_sc_hd__decap_3
XFILLER_32_72 VGND VGND VPWR VPWR sky130_fd_sc_hd__decap_3
XFILLER_50_249 VGND VGND VPWR VPWR sky130_fd_sc_hd__decap_3
XFILLER_7_191 VGND VGND VPWR VPWR sky130_fd_sc_hd__decap_3
X_1656_ _1656_/A _1656_/B _1656_/C VGND VGND VPWR VPWR _1668_/C sky130_fd_sc_hd__and3_4
X_1587_ _1556_/X _1612_/B _1600_/S VGND VGND VPWR VPWR _1587_/X sky130_fd_sc_hd__mux2_1
XFILLER_26_213 VGND VGND VPWR VPWR sky130_fd_sc_hd__decap_3
XTAP_TAPCELL_ROW_5_139 VGND VPWR sky130_fd_sc_hd__tapvpwrvgnd_1
XFILLER_34_290 VGND VGND VPWR VPWR sky130_fd_sc_hd__decap_3
XFILLER_41_249 VGND VGND VPWR VPWR sky130_fd_sc_hd__decap_3
Xrebuffer288 _0983_/X VGND VGND VPWR VPWR _1252_/B sky130_fd_sc_hd__buf_2
Xrebuffer244 _1622_/Y VGND VGND VPWR VPWR _1623_/C sky130_fd_sc_hd__buf_6
Xrebuffer233 _1112_/X VGND VGND VPWR VPWR _1223_/A0 sky130_fd_sc_hd__buf_6
Xrebuffer222 _1087_/X VGND VGND VPWR VPWR _1357_/A2 sky130_fd_sc_hd__buf_2
XFILLER_49_305 VGND VGND VPWR VPWR sky130_fd_sc_hd__decap_3
XFILLER_17_268 VGND VGND VPWR VPWR sky130_fd_sc_hd__fill_1
XFILLER_32_205 VGND VGND VPWR VPWR sky130_fd_sc_hd__fill_1
XFILLER_32_238 VGND VGND VPWR VPWR sky130_fd_sc_hd__decap_3
XTAP_TAPCELL_ROW_27_263 VGND VPWR sky130_fd_sc_hd__tapvpwrvgnd_1
XTAP_TAPCELL_ROW_19_219 VGND VPWR sky130_fd_sc_hd__tapvpwrvgnd_1
XFILLER_40_271 VGND VGND VPWR VPWR sky130_fd_sc_hd__decap_3
XFILLER_40_293 VGND VGND VPWR VPWR sky130_fd_sc_hd__decap_3
XFILLER_43_93 VGND VGND VPWR VPWR sky130_fd_sc_hd__decap_3
XFILLER_4_21 VGND VGND VPWR VPWR sky130_fd_sc_hd__decap_3
XFILLER_4_32 VGND VGND VPWR VPWR sky130_fd_sc_hd__decap_3
XFILLER_4_76 VGND VGND VPWR VPWR sky130_fd_sc_hd__decap_3
X_1510_ _1480_/X _1482_/X _1548_/C VGND VGND VPWR VPWR _1519_/B sky130_fd_sc_hd__a21o_2
X_1441_ _1407_/X _1410_/X _1481_/A VGND VGND VPWR VPWR _1450_/B sky130_fd_sc_hd__a21o_2
X_1372_ _1406_/A _1355_/X _1370_/X _1561_/A1 VGND VGND VPWR VPWR _1372_/X sky130_fd_sc_hd__a31o_2
XFILLER_48_27 VGND VGND VPWR VPWR sky130_fd_sc_hd__fill_1
XFILLER_48_38 VGND VGND VPWR VPWR sky130_fd_sc_hd__decap_3
X_1639_ _0900_/X _1640_/A3 _0901_/B VGND VGND VPWR VPWR _1641_/A sky130_fd_sc_hd__a21oi_4
XTAP_TAPCELL_ROW_1_120 VGND VPWR sky130_fd_sc_hd__tapvpwrvgnd_1
XFILLER_13_30 VGND VGND VPWR VPWR sky130_fd_sc_hd__fill_1
XFILLER_13_52 VGND VGND VPWR VPWR sky130_fd_sc_hd__decap_3
XFILLER_13_74 VGND VGND VPWR VPWR sky130_fd_sc_hd__decap_3
XTAP_TAPCELL_ROW_24_244 VGND VPWR sky130_fd_sc_hd__tapvpwrvgnd_1
XFILLER_38_82 VGND VGND VPWR VPWR sky130_fd_sc_hd__fill_2
XFILLER_49_113 VGND VGND VPWR VPWR sky130_fd_sc_hd__fill_2
XFILLER_49_179 VGND VGND VPWR VPWR sky130_fd_sc_hd__decap_3
XFILLER_13_260 VGND VGND VPWR VPWR sky130_fd_sc_hd__fill_1
X_0941_ _0934_/A _0941_/B VGND VGND VPWR VPWR _0941_/X sky130_fd_sc_hd__and2b_2
X_0872_ _1184_/A1 _1100_/B _1102_/A VGND VGND VPWR VPWR _0872_/X sky130_fd_sc_hd__o21a_2
X_1424_ _1374_/A _0848_/B _1647_/A1 _1415_/X _1423_/X VGND VGND VPWR VPWR _1425_/B
+ sky130_fd_sc_hd__a221o_2
X_1355_ _1332_/X _1334_/X _1406_/C VGND VGND VPWR VPWR _1355_/X sky130_fd_sc_hd__a21o_2
XFILLER_34_18 VGND VGND VPWR VPWR sky130_fd_sc_hd__decap_3
X_1286_ _1286_/A _1286_/B _1286_/C VGND VGND VPWR VPWR _1291_/C sky130_fd_sc_hd__or3_2
XTAP_TAPCELL_ROW_38_325 VGND VPWR sky130_fd_sc_hd__tapvpwrvgnd_1
XFILLER_46_105 VGND VGND VPWR VPWR sky130_fd_sc_hd__decap_3
Xfanout210 input2/X VGND VGND VPWR VPWR _1006_/B sky130_fd_sc_hd__dlymetal6s2s_1
XFILLER_24_62 VGND VGND VPWR VPWR sky130_fd_sc_hd__fill_1
XFILLER_40_50 VGND VGND VPWR VPWR sky130_fd_sc_hd__decap_3
XFILLER_6_223 VGND VGND VPWR VPWR sky130_fd_sc_hd__decap_3
XFILLER_6_267 VGND VGND VPWR VPWR sky130_fd_sc_hd__decap_3
XFILLER_40_83 VGND VGND VPWR VPWR sky130_fd_sc_hd__fill_1
XFILLER_40_94 VGND VGND VPWR VPWR sky130_fd_sc_hd__decap_3
XFILLER_1_33 VGND VGND VPWR VPWR sky130_fd_sc_hd__decap_3
XFILLER_1_55 VGND VGND VPWR VPWR sky130_fd_sc_hd__fill_1
XFILLER_37_116 VGND VGND VPWR VPWR sky130_fd_sc_hd__fill_2
X_1140_ _1155_/S _1351_/B _1132_/X _1139_/X _1131_/X VGND VGND VPWR VPWR _1140_/X
+ sky130_fd_sc_hd__a311o_2
X_1071_ _1034_/B _1052_/B _1051_/B _0943_/B _1469_/S wire177/X VGND VGND VPWR VPWR
+ _1071_/X sky130_fd_sc_hd__mux4_2
XTAP_TAPCELL_ROW_35_306 VGND VPWR sky130_fd_sc_hd__tapvpwrvgnd_1
X_0924_ _1620_/B _1579_/B _1594_/B VGND VGND VPWR VPWR _0924_/X sky130_fd_sc_hd__o21a_2
XTAP_TAPCELL_ROW_43_350 VGND VPWR sky130_fd_sc_hd__tapvpwrvgnd_1
X_0855_ _1137_/A _0855_/B VGND VGND VPWR VPWR _0855_/X sky130_fd_sc_hd__and2_2
XFILLER_28_138 VGND VGND VPWR VPWR sky130_fd_sc_hd__fill_2
X_1407_ _1257_/X _1255_/X _1333_/X _1406_/X VGND VGND VPWR VPWR _1407_/X sky130_fd_sc_hd__a211o_4
X_1338_ _1358_/A1 input3/X input2/X input32/X _1358_/S0 _1358_/S1 VGND VGND VPWR VPWR
+ _1338_/X sky130_fd_sc_hd__mux4_2
XFILLER_36_182 VGND VGND VPWR VPWR sky130_fd_sc_hd__fill_2
XFILLER_36_193 VGND VGND VPWR VPWR sky130_fd_sc_hd__decap_3
XFILLER_43_119 VGND VGND VPWR VPWR sky130_fd_sc_hd__fill_2
XFILLER_45_17 VGND VGND VPWR VPWR sky130_fd_sc_hd__decap_3
X_1269_ _0851_/X _1313_/B _1268_/X VGND VGND VPWR VPWR _1270_/B sky130_fd_sc_hd__a21oi_2
XFILLER_10_64 VGND VGND VPWR VPWR sky130_fd_sc_hd__fill_2
XFILLER_19_51 VGND VGND VPWR VPWR sky130_fd_sc_hd__decap_3
XFILLER_42_141 VGND VGND VPWR VPWR sky130_fd_sc_hd__decap_3
XTAP_TAPCELL_ROW_40_331 VGND VPWR sky130_fd_sc_hd__tapvpwrvgnd_1
Xmax_cap207 _0955_/B VGND VGND VPWR VPWR _0966_/B sky130_fd_sc_hd__buf_2
XFILLER_2_292 VGND VGND VPWR VPWR sky130_fd_sc_hd__decap_3
XFILLER_18_160 VGND VGND VPWR VPWR sky130_fd_sc_hd__decap_3
XFILLER_33_152 VGND VGND VPWR VPWR sky130_fd_sc_hd__decap_3
X_1123_ _1006_/B _1018_/B _1358_/A1 _1358_/A0 _1455_/S _1358_/S1 VGND VGND VPWR VPWR
+ _1123_/X sky130_fd_sc_hd__mux4_2
X_1054_ _0827_/Y _1034_/B _1428_/A VGND VGND VPWR VPWR _1054_/Y sky130_fd_sc_hd__a21oi_2
X_0907_ _1635_/A _1621_/A VGND VGND VPWR VPWR _1627_/A sky130_fd_sc_hd__or2_2
XFILLER_0_218 VGND VGND VPWR VPWR sky130_fd_sc_hd__decap_3
X_0838_ _0943_/B _0942_/B _0941_/B _0947_/B _0838_/S0 wire177/X VGND VGND VPWR VPWR
+ _0838_/X sky130_fd_sc_hd__mux4_2
XFILLER_24_141 VGND VGND VPWR VPWR sky130_fd_sc_hd__decap_3
XFILLER_21_52 VGND VGND VPWR VPWR sky130_fd_sc_hd__decap_3
XFILLER_21_85 VGND VGND VPWR VPWR sky130_fd_sc_hd__decap_3
XFILLER_46_82 VGND VGND VPWR VPWR sky130_fd_sc_hd__fill_2
XFILLER_47_244 VGND VGND VPWR VPWR sky130_fd_sc_hd__decap_3
XFILLER_47_277 VGND VGND VPWR VPWR sky130_fd_sc_hd__decap_3
XFILLER_47_299 VGND VGND VPWR VPWR sky130_fd_sc_hd__decap_3
XFILLER_30_144 VGND VGND VPWR VPWR sky130_fd_sc_hd__decap_3
XFILLER_7_21 VGND VGND VPWR VPWR sky130_fd_sc_hd__decap_3
X_1672_ _1672_/A _1672_/B VGND VGND VPWR VPWR _1674_/C sky130_fd_sc_hd__or2_4
XFILLER_38_200 VGND VGND VPWR VPWR sky130_fd_sc_hd__decap_3
X_1106_ _0957_/B _1082_/B _1102_/A VGND VGND VPWR VPWR _1107_/B sky130_fd_sc_hd__a21bo_2
XFILLER_21_144 VGND VGND VPWR VPWR sky130_fd_sc_hd__decap_3
XFILLER_42_18 VGND VGND VPWR VPWR sky130_fd_sc_hd__fill_1
XFILLER_42_29 VGND VGND VPWR VPWR sky130_fd_sc_hd__decap_3
X_1037_ _1037_/A _1053_/B VGND VGND VPWR VPWR _1039_/B sky130_fd_sc_hd__or2_2
XFILLER_21_188 VGND VGND VPWR VPWR sky130_fd_sc_hd__decap_3
Xrebuffer459 _1254_/A VGND VGND VPWR VPWR _1192_/A sky130_fd_sc_hd__buf_2
XFILLER_29_200 VGND VGND VPWR VPWR sky130_fd_sc_hd__fill_1
XTAP_TAPCELL_ROW_8_159 VGND VPWR sky130_fd_sc_hd__tapvpwrvgnd_1
XFILLER_44_203 VGND VGND VPWR VPWR sky130_fd_sc_hd__decap_3
XFILLER_44_269 VGND VGND VPWR VPWR sky130_fd_sc_hd__decap_3
XFILLER_12_144 VGND VGND VPWR VPWR sky130_fd_sc_hd__decap_3
XFILLER_16_74 VGND VGND VPWR VPWR sky130_fd_sc_hd__decap_3
XFILLER_32_62 VGND VGND VPWR VPWR sky130_fd_sc_hd__decap_3
XPHY_EDGE_ROW_11_Right_11 VGND VGND VPWR VPWR sky130_fd_sc_hd__decap_3
XPHY_EDGE_ROW_20_Right_20 VGND VGND VPWR VPWR sky130_fd_sc_hd__decap_3
XFILLER_35_225 VGND VGND VPWR VPWR sky130_fd_sc_hd__decap_3
XFILLER_35_236 VGND VGND VPWR VPWR sky130_fd_sc_hd__decap_3
XFILLER_50_206 VGND VGND VPWR VPWR sky130_fd_sc_hd__fill_1
XTAP_TAPCELL_ROW_13_183 VGND VPWR sky130_fd_sc_hd__tapvpwrvgnd_1
X_1655_ _1654_/B _1651_/X _1657_/A VGND VGND VPWR VPWR _1656_/C sky130_fd_sc_hd__a21bo_2
X_1586_ _0914_/B _0919_/B _1586_/S VGND VGND VPWR VPWR _1612_/B sky130_fd_sc_hd__mux2_1
Xrebuffer223 _1669_/A VGND VGND VPWR VPWR output77/A sky130_fd_sc_hd__buf_2
XFILLER_1_302 VGND VGND VPWR VPWR sky130_fd_sc_hd__decap_3
Xrebuffer289 _0958_/Y VGND VGND VPWR VPWR _1102_/B sky130_fd_sc_hd__buf_2
Xrebuffer245 _0952_/B VGND VGND VPWR VPWR _0951_/B sky130_fd_sc_hd__buf_2
Xrebuffer234 _1391_/A3 VGND VGND VPWR VPWR _1316_/A1 sky130_fd_sc_hd__buf_2
XFILLER_17_225 VGND VGND VPWR VPWR sky130_fd_sc_hd__decap_3
XFILLER_17_247 VGND VGND VPWR VPWR sky130_fd_sc_hd__decap_3
XFILLER_27_40 VGND VGND VPWR VPWR sky130_fd_sc_hd__fill_2
XTAP_TAPCELL_ROW_27_264 VGND VPWR sky130_fd_sc_hd__tapvpwrvgnd_1
XFILLER_4_44 VGND VGND VPWR VPWR sky130_fd_sc_hd__fill_1
XFILLER_4_55 VGND VGND VPWR VPWR sky130_fd_sc_hd__fill_1
X_1440_ _1442_/A _1440_/B VGND VGND VPWR VPWR _1481_/A sky130_fd_sc_hd__or2_2
X_1371_ _1355_/X _1370_/X _1406_/A VGND VGND VPWR VPWR _1389_/C sky130_fd_sc_hd__a21oi_2
XFILLER_23_217 VGND VGND VPWR VPWR sky130_fd_sc_hd__decap_3
X_1638_ _1656_/A _1635_/X _1636_/X _1637_/X VGND VGND VPWR VPWR _1681_/B sky130_fd_sc_hd__a31o_4
XFILLER_46_309 VGND VGND VPWR VPWR sky130_fd_sc_hd__fill_1
X_1569_ _1358_/X _1432_/X _1500_/X _1568_/X _1144_/S _1526_/S VGND VGND VPWR VPWR
+ _1569_/X sky130_fd_sc_hd__mux4_2
XFILLER_14_206 VGND VGND VPWR VPWR sky130_fd_sc_hd__decap_3
XTAP_TAPCELL_ROW_1_121 VGND VPWR sky130_fd_sc_hd__tapvpwrvgnd_1
XFILLER_13_86 VGND VGND VPWR VPWR sky130_fd_sc_hd__fill_1
XFILLER_13_97 VGND VGND VPWR VPWR sky130_fd_sc_hd__decap_3
XFILLER_22_294 VGND VGND VPWR VPWR sky130_fd_sc_hd__fill_1
XTAP_TAPCELL_ROW_24_245 VGND VPWR sky130_fd_sc_hd__tapvpwrvgnd_1
XFILLER_38_61 VGND VGND VPWR VPWR sky130_fd_sc_hd__decap_3
X_0940_ _1511_/A _1509_/B _1548_/B VGND VGND VPWR VPWR _0940_/X sky130_fd_sc_hd__and3_2
X_0871_ _1069_/C _1104_/A VGND VGND VPWR VPWR _1100_/B sky130_fd_sc_hd__nor2_2
XFILLER_28_309 VGND VGND VPWR VPWR sky130_fd_sc_hd__fill_1
XFILLER_48_3 VGND VGND VPWR VPWR sky130_fd_sc_hd__decap_3
X_1423_ _1265_/X _1416_/X _1421_/X _1422_/Y VGND VGND VPWR VPWR _1423_/X sky130_fd_sc_hd__a211o_2
X_1354_ _1354_/A _1354_/B VGND VGND VPWR VPWR _1406_/C sky130_fd_sc_hd__or2_2
X_1285_ _1598_/A _1278_/Y _1282_/X _1570_/A1 VGND VGND VPWR VPWR _1286_/C sky130_fd_sc_hd__a22o_2
XPHY_EDGE_ROW_50_Left_103 VGND VGND VPWR VPWR sky130_fd_sc_hd__decap_3
XFILLER_50_18 VGND VGND VPWR VPWR sky130_fd_sc_hd__decap_3
XFILLER_50_29 VGND VGND VPWR VPWR sky130_fd_sc_hd__decap_3
XFILLER_1_9 VGND VGND VPWR VPWR sky130_fd_sc_hd__decap_3
Xfanout200 input32/X VGND VGND VPWR VPWR _1019_/B sky130_fd_sc_hd__buf_4
Xfanout211 input14/X VGND VGND VPWR VPWR _0942_/B sky130_fd_sc_hd__dlymetal6s2s_1
XFILLER_19_309 VGND VGND VPWR VPWR sky130_fd_sc_hd__fill_1
XFILLER_24_41 VGND VGND VPWR VPWR sky130_fd_sc_hd__decap_3
XFILLER_24_85 VGND VGND VPWR VPWR sky130_fd_sc_hd__decap_3
XFILLER_10_286 VGND VGND VPWR VPWR sky130_fd_sc_hd__decap_3
XFILLER_6_279 VGND VGND VPWR VPWR sky130_fd_sc_hd__decap_3
XFILLER_1_12 VGND VGND VPWR VPWR sky130_fd_sc_hd__decap_3
XFILLER_49_60 VGND VGND VPWR VPWR sky130_fd_sc_hd__fill_1
XFILLER_1_45 VGND VGND VPWR VPWR sky130_fd_sc_hd__decap_3
XFILLER_45_150 VGND VGND VPWR VPWR sky130_fd_sc_hd__decap_3
X_1070_ _0942_/B _0941_/B _0947_/B _1059_/B _1070_/S0 wire177/X VGND VGND VPWR VPWR
+ _1070_/X sky130_fd_sc_hd__mux4_2
XTAP_TAPCELL_ROW_35_307 VGND VPWR sky130_fd_sc_hd__tapvpwrvgnd_1
X_0923_ _0919_/A _0826_/Y _0922_/Y VGND VGND VPWR VPWR _1579_/B sky130_fd_sc_hd__o21a_2
X_0854_ _0970_/B _0951_/B _0988_/B _0976_/B _1090_/S _1264_/S1 VGND VGND VPWR VPWR
+ _0855_/B sky130_fd_sc_hd__mux4_2
XTAP_TAPCELL_ROW_43_351 VGND VPWR sky130_fd_sc_hd__tapvpwrvgnd_1
XFILLER_5_290 VGND VGND VPWR VPWR sky130_fd_sc_hd__decap_3
XPHY_EDGE_ROW_49_Right_49 VGND VGND VPWR VPWR sky130_fd_sc_hd__decap_3
XFILLER_28_128 VGND VGND VPWR VPWR sky130_fd_sc_hd__fill_1
XFILLER_45_29 VGND VGND VPWR VPWR sky130_fd_sc_hd__decap_3
X_1406_ _1406_/A _1406_/B _1406_/C _1408_/B VGND VGND VPWR VPWR _1406_/X sky130_fd_sc_hd__or4_4
X_1337_ _1337_/A0 input3/X _1337_/S VGND VGND VPWR VPWR _1337_/X sky130_fd_sc_hd__mux2_1
X_1268_ _1266_/A _0840_/X _1275_/C _1267_/X VGND VGND VPWR VPWR _1268_/X sky130_fd_sc_hd__a31o_2
XFILLER_36_150 VGND VGND VPWR VPWR sky130_fd_sc_hd__decap_3
X_1199_ _0985_/B _1219_/A2 _0966_/B _0965_/B _0859_/S _1134_/A VGND VGND VPWR VPWR
+ _1199_/X sky130_fd_sc_hd__mux4_2
XFILLER_10_21 VGND VGND VPWR VPWR sky130_fd_sc_hd__decap_3
XFILLER_10_32 VGND VGND VPWR VPWR sky130_fd_sc_hd__decap_3
XFILLER_10_98 VGND VGND VPWR VPWR sky130_fd_sc_hd__decap_3
XFILLER_15_301 VGND VGND VPWR VPWR sky130_fd_sc_hd__fill_1
XFILLER_19_128 VGND VGND VPWR VPWR sky130_fd_sc_hd__fill_1
XFILLER_19_63 VGND VGND VPWR VPWR sky130_fd_sc_hd__decap_3
XFILLER_35_40 VGND VGND VPWR VPWR sky130_fd_sc_hd__decap_3
XFILLER_35_73 VGND VGND VPWR VPWR sky130_fd_sc_hd__decap_3
XFILLER_42_153 VGND VGND VPWR VPWR sky130_fd_sc_hd__decap_3
XFILLER_42_197 VGND VGND VPWR VPWR sky130_fd_sc_hd__fill_1
XTAP_TAPCELL_ROW_40_332 VGND VPWR sky130_fd_sc_hd__tapvpwrvgnd_1
XFILLER_2_271 VGND VGND VPWR VPWR sky130_fd_sc_hd__decap_3
X_1122_ input6/X input7/X _1053_/B _1034_/B _1396_/S0 _1432_/S1 VGND VGND VPWR VPWR
+ _1122_/X sky130_fd_sc_hd__mux4_2
XFILLER_18_172 VGND VGND VPWR VPWR sky130_fd_sc_hd__fill_2
XFILLER_25_109 VGND VGND VPWR VPWR sky130_fd_sc_hd__decap_3
XFILLER_33_164 VGND VGND VPWR VPWR sky130_fd_sc_hd__decap_3
X_1053_ _1053_/A _1053_/B _1442_/A VGND VGND VPWR VPWR _1428_/A sky130_fd_sc_hd__and3_2
X_0906_ _1635_/B _0906_/B VGND VGND VPWR VPWR _1621_/A sky130_fd_sc_hd__nor2_2
X_0837_ _1069_/B VGND VGND VPWR VPWR _0878_/C sky130_fd_sc_hd__inv_2
XFILLER_24_131 VGND VGND VPWR VPWR sky130_fd_sc_hd__decap_3
XFILLER_24_197 VGND VGND VPWR VPWR sky130_fd_sc_hd__decap_3
XFILLER_47_256 VGND VGND VPWR VPWR sky130_fd_sc_hd__decap_3
XFILLER_15_131 VGND VGND VPWR VPWR sky130_fd_sc_hd__decap_3
XFILLER_30_112 VGND VGND VPWR VPWR sky130_fd_sc_hd__fill_2
XFILLER_30_123 VGND VGND VPWR VPWR sky130_fd_sc_hd__fill_1
XFILLER_7_33 VGND VGND VPWR VPWR sky130_fd_sc_hd__decap_3
X_1671_ _1671_/A _1671_/B _1671_/C _1671_/D VGND VGND VPWR VPWR _1672_/A sky130_fd_sc_hd__or4_4
XFILLER_30_3 VGND VGND VPWR VPWR sky130_fd_sc_hd__fill_1
XFILLER_7_99 VGND VGND VPWR VPWR sky130_fd_sc_hd__decap_3
X_1105_ _1102_/A _1102_/B _1561_/A1 VGND VGND VPWR VPWR _1105_/X sky130_fd_sc_hd__a21o_2
XFILLER_21_156 VGND VGND VPWR VPWR sky130_fd_sc_hd__decap_3
X_1036_ _1037_/A _1053_/B VGND VGND VPWR VPWR _1442_/B sky130_fd_sc_hd__nand2_2
XFILLER_29_223 VGND VGND VPWR VPWR sky130_fd_sc_hd__fill_1
XFILLER_29_245 VGND VGND VPWR VPWR sky130_fd_sc_hd__decap_3
XFILLER_12_101 VGND VGND VPWR VPWR sky130_fd_sc_hd__fill_2
XFILLER_16_53 VGND VGND VPWR VPWR sky130_fd_sc_hd__decap_3
XFILLER_52_270 VGND VGND VPWR VPWR sky130_fd_sc_hd__fill_2
XFILLER_12_112 VGND VGND VPWR VPWR sky130_fd_sc_hd__decap_3
XFILLER_32_41 VGND VGND VPWR VPWR sky130_fd_sc_hd__decap_3
XFILLER_52_281 VGND VGND VPWR VPWR sky130_fd_sc_hd__decap_3
XFILLER_8_116 VGND VGND VPWR VPWR sky130_fd_sc_hd__decap_3
XFILLER_8_138 VGND VGND VPWR VPWR sky130_fd_sc_hd__fill_2
XFILLER_8_149 VGND VGND VPWR VPWR sky130_fd_sc_hd__decap_3
XFILLER_35_215 VGND VGND VPWR VPWR sky130_fd_sc_hd__decap_3
XFILLER_35_248 VGND VGND VPWR VPWR sky130_fd_sc_hd__decap_3
XFILLER_43_292 VGND VGND VPWR VPWR sky130_fd_sc_hd__decap_3
X_1654_ _1657_/A _1654_/B _1654_/C VGND VGND VPWR VPWR _1656_/B sky130_fd_sc_hd__nand3b_2
XTAP_TAPCELL_ROW_13_184 VGND VPWR sky130_fd_sc_hd__tapvpwrvgnd_1
X_1585_ _0914_/A _0914_/B _1585_/A3 _1647_/C1 _1584_/X VGND VGND VPWR VPWR _1585_/X
+ sky130_fd_sc_hd__a311o_2
X_1019_ _1010_/A _1019_/B VGND VGND VPWR VPWR _1019_/Y sky130_fd_sc_hd__nand2b_2
Xrebuffer246 _0981_/B VGND VGND VPWR VPWR _0988_/B sky130_fd_sc_hd__buf_4
Xrebuffer235 _1143_/X VGND VGND VPWR VPWR _1144_/A1 sky130_fd_sc_hd__buf_6
Xrebuffer224 _1281_/S VGND VGND VPWR VPWR _1124_/S sky130_fd_sc_hd__buf_2
XPHY_EDGE_ROW_36_Left_89 VGND VGND VPWR VPWR sky130_fd_sc_hd__decap_3
XFILLER_17_215 VGND VGND VPWR VPWR sky130_fd_sc_hd__decap_3
XFILLER_27_74 VGND VGND VPWR VPWR sky130_fd_sc_hd__decap_3
XFILLER_27_96 VGND VGND VPWR VPWR sky130_fd_sc_hd__decap_3
XFILLER_32_218 VGND VGND VPWR VPWR sky130_fd_sc_hd__decap_3
XFILLER_40_262 VGND VGND VPWR VPWR sky130_fd_sc_hd__decap_3
XFILLER_43_84 VGND VGND VPWR VPWR sky130_fd_sc_hd__fill_2
XFILLER_4_12 VGND VGND VPWR VPWR sky130_fd_sc_hd__decap_3
XFILLER_4_67 VGND VGND VPWR VPWR sky130_fd_sc_hd__fill_1
X_1370_ _1352_/A _1352_/B _0991_/Y VGND VGND VPWR VPWR _1370_/X sky130_fd_sc_hd__o21a_2
XFILLER_23_207 VGND VGND VPWR VPWR sky130_fd_sc_hd__fill_2
XTAP_TAPCELL_ROW_18_210 VGND VPWR sky130_fd_sc_hd__tapvpwrvgnd_1
X_1637_ _0899_/X _1637_/A2 _1626_/Y _1627_/X _1634_/X VGND VGND VPWR VPWR _1637_/X
+ sky130_fd_sc_hd__a41o_2
XFILLER_48_18 VGND VGND VPWR VPWR sky130_fd_sc_hd__decap_3
XFILLER_48_29 VGND VGND VPWR VPWR sky130_fd_sc_hd__decap_3
X_1568_ _1538_/X _1567_/X _1568_/S VGND VGND VPWR VPWR _1568_/X sky130_fd_sc_hd__mux2_1
X_1499_ _0942_/B input13/X _1499_/S VGND VGND VPWR VPWR _1499_/X sky130_fd_sc_hd__mux2_1
XFILLER_22_251 VGND VGND VPWR VPWR sky130_fd_sc_hd__fill_1
XTAP_TAPCELL_ROW_24_246 VGND VPWR sky130_fd_sc_hd__tapvpwrvgnd_1
XFILLER_13_21 VGND VGND VPWR VPWR sky130_fd_sc_hd__decap_3
XTAP_TAPCELL_ROW_32_290 VGND VPWR sky130_fd_sc_hd__tapvpwrvgnd_1
XFILLER_8_3 VGND VGND VPWR VPWR sky130_fd_sc_hd__decap_3
XFILLER_38_40 VGND VGND VPWR VPWR sky130_fd_sc_hd__decap_3
XFILLER_38_73 VGND VGND VPWR VPWR sky130_fd_sc_hd__decap_3
XFILLER_9_211 VGND VGND VPWR VPWR sky130_fd_sc_hd__fill_1
XFILLER_9_244 VGND VGND VPWR VPWR sky130_fd_sc_hd__fill_1
X_0870_ _0878_/C _0878_/D _1104_/B VGND VGND VPWR VPWR _1133_/A sky130_fd_sc_hd__or3_2
X_1422_ _1659_/A _1442_/B _1419_/Y _1266_/B VGND VGND VPWR VPWR _1422_/Y sky130_fd_sc_hd__o22ai_2
X_1353_ _1352_/A _1352_/B _1513_/A1 VGND VGND VPWR VPWR _1353_/X sky130_fd_sc_hd__o21a_2
X_1284_ _1555_/B2 _1272_/A _1279_/X _1374_/A VGND VGND VPWR VPWR _1286_/B sky130_fd_sc_hd__a22o_2
XFILLER_48_181 VGND VGND VPWR VPWR sky130_fd_sc_hd__fill_2
XFILLER_51_302 VGND VGND VPWR VPWR sky130_fd_sc_hd__decap_3
X_0999_ _0999_/A _1408_/A VGND VGND VPWR VPWR _1406_/A sky130_fd_sc_hd__or2_4
XTAP_TAPCELL_ROW_21_227 VGND VPWR sky130_fd_sc_hd__tapvpwrvgnd_1
Xfanout201 input31/X VGND VGND VPWR VPWR _1280_/A1 sky130_fd_sc_hd__buf_6
Xfanout212 input13/X VGND VGND VPWR VPWR _0943_/B sky130_fd_sc_hd__dlymetal6s2s_1
XFILLER_10_221 VGND VGND VPWR VPWR sky130_fd_sc_hd__decap_3
XFILLER_24_53 VGND VGND VPWR VPWR sky130_fd_sc_hd__fill_1
XFILLER_40_74 VGND VGND VPWR VPWR sky130_fd_sc_hd__decap_3
XFILLER_40_85 VGND VGND VPWR VPWR sky130_fd_sc_hd__fill_1
XFILLER_1_24 VGND VGND VPWR VPWR sky130_fd_sc_hd__decap_3
XPHY_EDGE_ROW_39_Left_92 VGND VGND VPWR VPWR sky130_fd_sc_hd__decap_3
XFILLER_33_302 VGND VGND VPWR VPWR sky130_fd_sc_hd__decap_3
XFILLER_45_162 VGND VGND VPWR VPWR sky130_fd_sc_hd__decap_3
XPHY_EDGE_ROW_23_Left_76 VGND VGND VPWR VPWR sky130_fd_sc_hd__decap_3
XTAP_TAPCELL_ROW_43_352 VGND VPWR sky130_fd_sc_hd__tapvpwrvgnd_1
XTAP_TAPCELL_ROW_35_308 VGND VPWR sky130_fd_sc_hd__tapvpwrvgnd_1
X_0922_ _1575_/A _0922_/B VGND VGND VPWR VPWR _0922_/Y sky130_fd_sc_hd__nand2_2
X_0853_ _1093_/A1 _0951_/B _0859_/S VGND VGND VPWR VPWR _0853_/X sky130_fd_sc_hd__mux2_1
X_1405_ _1464_/A _1405_/B _1405_/C VGND VGND VPWR VPWR _1405_/X sky130_fd_sc_hd__or3_4
XFILLER_28_107 VGND VGND VPWR VPWR sky130_fd_sc_hd__decap_3
Xinput1 A[0] VGND VGND VPWR VPWR input1/X sky130_fd_sc_hd__dlymetal6s4s_1
X_1336_ _1354_/B _1332_/X _1334_/X _1335_/Y _1561_/A1 VGND VGND VPWR VPWR _1348_/B
+ sky130_fd_sc_hd__a311oi_2
X_1267_ _1266_/A _1265_/X _1266_/Y _1418_/C VGND VGND VPWR VPWR _1267_/X sky130_fd_sc_hd__o211a_2
X_1198_ _1392_/C _1196_/X _1197_/X _1080_/Y VGND VGND VPWR VPWR _1198_/X sky130_fd_sc_hd__a22o_2
XFILLER_10_55 VGND VGND VPWR VPWR sky130_fd_sc_hd__decap_3
XFILLER_3_228 VGND VGND VPWR VPWR sky130_fd_sc_hd__fill_1
XFILLER_10_77 VGND VGND VPWR VPWR sky130_fd_sc_hd__decap_3
XFILLER_19_107 VGND VGND VPWR VPWR sky130_fd_sc_hd__decap_3
XFILLER_19_75 VGND VGND VPWR VPWR sky130_fd_sc_hd__decap_3
XFILLER_27_151 VGND VGND VPWR VPWR sky130_fd_sc_hd__decap_3
XFILLER_35_52 VGND VGND VPWR VPWR sky130_fd_sc_hd__decap_3
XFILLER_42_110 VGND VGND VPWR VPWR sky130_fd_sc_hd__decap_3
XFILLER_51_51 VGND VGND VPWR VPWR sky130_fd_sc_hd__decap_3
XTAP_TAPCELL_ROW_40_333 VGND VPWR sky130_fd_sc_hd__tapvpwrvgnd_1
XFILLER_2_283 VGND VGND VPWR VPWR sky130_fd_sc_hd__decap_3
XFILLER_18_151 VGND VGND VPWR VPWR sky130_fd_sc_hd__decap_3
X_1121_ _1313_/B _1121_/A2 _1120_/Y _1266_/A VGND VGND VPWR VPWR _1121_/X sky130_fd_sc_hd__a22o_2
X_1052_ _1042_/A _1052_/B VGND VGND VPWR VPWR _1462_/B sky130_fd_sc_hd__nand2b_2
XFILLER_18_195 VGND VGND VPWR VPWR sky130_fd_sc_hd__fill_1
XFILLER_33_143 VGND VGND VPWR VPWR sky130_fd_sc_hd__decap_3
X_0905_ _0905_/A _0905_/B VGND VGND VPWR VPWR _0906_/B sky130_fd_sc_hd__nor2_2
X_0836_ _1313_/A VGND VGND VPWR VPWR _1275_/B sky130_fd_sc_hd__inv_2
X_1319_ _1166_/Y _1472_/B _1472_/A VGND VGND VPWR VPWR _1319_/X sky130_fd_sc_hd__mux2_2
XFILLER_21_21 VGND VGND VPWR VPWR sky130_fd_sc_hd__decap_3
XFILLER_24_165 VGND VGND VPWR VPWR sky130_fd_sc_hd__decap_3
XFILLER_8_309 VGND VGND VPWR VPWR sky130_fd_sc_hd__fill_1
XFILLER_21_43 VGND VGND VPWR VPWR sky130_fd_sc_hd__decap_3
XFILLER_21_76 VGND VGND VPWR VPWR sky130_fd_sc_hd__decap_3
XFILLER_47_268 VGND VGND VPWR VPWR sky130_fd_sc_hd__decap_3
XFILLER_15_110 VGND VGND VPWR VPWR sky130_fd_sc_hd__fill_2
XFILLER_15_154 VGND VGND VPWR VPWR sky130_fd_sc_hd__fill_2
XFILLER_15_176 VGND VGND VPWR VPWR sky130_fd_sc_hd__fill_1
XFILLER_7_12 VGND VGND VPWR VPWR sky130_fd_sc_hd__decap_3
X_1670_ _1670_/A _1670_/B VGND VGND VPWR VPWR _1674_/B sky130_fd_sc_hd__or2_2
XFILLER_38_246 VGND VGND VPWR VPWR sky130_fd_sc_hd__decap_3
X_1104_ _1104_/A _1104_/B VGND VGND VPWR VPWR _1104_/X sky130_fd_sc_hd__or2_2
X_1035_ _1035_/A _1035_/B VGND VGND VPWR VPWR _1442_/A sky130_fd_sc_hd__nand2_2
XFILLER_21_113 VGND VGND VPWR VPWR sky130_fd_sc_hd__decap_3
XFILLER_21_135 VGND VGND VPWR VPWR sky130_fd_sc_hd__decap_3
XPHY_EDGE_ROW_10_Left_63 VGND VGND VPWR VPWR sky130_fd_sc_hd__decap_3
XFILLER_29_257 VGND VGND VPWR VPWR sky130_fd_sc_hd__fill_2
XFILLER_29_279 VGND VGND VPWR VPWR sky130_fd_sc_hd__fill_1
XFILLER_12_124 VGND VGND VPWR VPWR sky130_fd_sc_hd__fill_1
XFILLER_12_135 VGND VGND VPWR VPWR sky130_fd_sc_hd__decap_3
XFILLER_16_65 VGND VGND VPWR VPWR sky130_fd_sc_hd__decap_3
XFILLER_16_98 VGND VGND VPWR VPWR sky130_fd_sc_hd__decap_3
XFILLER_37_290 VGND VGND VPWR VPWR sky130_fd_sc_hd__decap_3
XFILLER_44_249 VGND VGND VPWR VPWR sky130_fd_sc_hd__decap_3
XFILLER_52_293 VGND VGND VPWR VPWR sky130_fd_sc_hd__decap_3
XFILLER_32_53 VGND VGND VPWR VPWR sky130_fd_sc_hd__decap_3
XFILLER_32_75 VGND VGND VPWR VPWR sky130_fd_sc_hd__decap_3
XFILLER_8_128 VGND VGND VPWR VPWR sky130_fd_sc_hd__decap_3
XTAP_TAPCELL_ROW_7_150 VGND VPWR sky130_fd_sc_hd__tapvpwrvgnd_1
XFILLER_7_150 VGND VGND VPWR VPWR sky130_fd_sc_hd__decap_3
XFILLER_7_172 VGND VGND VPWR VPWR sky130_fd_sc_hd__decap_3
XFILLER_7_194 VGND VGND VPWR VPWR sky130_fd_sc_hd__decap_3
X_1653_ _1654_/C _1652_/Y _1641_/Y _1649_/X VGND VGND VPWR VPWR _1682_/A sky130_fd_sc_hd__a211o_4
X_1584_ _1643_/A1 _0915_/B _1620_/B _1660_/A1 VGND VGND VPWR VPWR _1584_/X sky130_fd_sc_hd__a22o_2
XTAP_TAPCELL_ROW_13_185 VGND VPWR sky130_fd_sc_hd__tapvpwrvgnd_1
XPHY_EDGE_ROW_9_Right_9 VGND VGND VPWR VPWR sky130_fd_sc_hd__decap_3
XFILLER_19_290 VGND VGND VPWR VPWR sky130_fd_sc_hd__fill_1
XFILLER_26_205 VGND VGND VPWR VPWR sky130_fd_sc_hd__fill_1
XFILLER_26_216 VGND VGND VPWR VPWR sky130_fd_sc_hd__decap_3
XFILLER_26_238 VGND VGND VPWR VPWR sky130_fd_sc_hd__decap_3
XFILLER_26_249 VGND VGND VPWR VPWR sky130_fd_sc_hd__decap_3
XFILLER_34_293 VGND VGND VPWR VPWR sky130_fd_sc_hd__decap_3
X_1018_ _1004_/A _1018_/B VGND VGND VPWR VPWR _1018_/X sky130_fd_sc_hd__and2b_2
Xrebuffer214 _0833_/A VGND VGND VPWR VPWR _1137_/A sky130_fd_sc_hd__buf_8
Xrebuffer247 _1549_/X VGND VGND VPWR VPWR _1552_/B sky130_fd_sc_hd__buf_6
Xrebuffer236 _1114_/X VGND VGND VPWR VPWR _1121_/A2 sky130_fd_sc_hd__buf_2
Xrebuffer225 _1281_/S VGND VGND VPWR VPWR _1205_/S0 sky130_fd_sc_hd__buf_2
XFILLER_49_308 VGND VGND VPWR VPWR sky130_fd_sc_hd__fill_2
XFILLER_17_238 VGND VGND VPWR VPWR sky130_fd_sc_hd__decap_3
XFILLER_40_241 VGND VGND VPWR VPWR sky130_fd_sc_hd__fill_1
XFILLER_40_296 VGND VGND VPWR VPWR sky130_fd_sc_hd__decap_3
XFILLER_43_30 VGND VGND VPWR VPWR sky130_fd_sc_hd__decap_3
XFILLER_43_52 VGND VGND VPWR VPWR sky130_fd_sc_hd__decap_3
XFILLER_43_96 VGND VGND VPWR VPWR sky130_fd_sc_hd__decap_3
XFILLER_4_164 VGND VGND VPWR VPWR sky130_fd_sc_hd__fill_1
XFILLER_4_24 VGND VGND VPWR VPWR sky130_fd_sc_hd__decap_3
XTAP_TAPCELL_ROW_10_166 VGND VPWR sky130_fd_sc_hd__tapvpwrvgnd_1
XFILLER_4_35 VGND VGND VPWR VPWR sky130_fd_sc_hd__decap_3
XTAP_TAPCELL_ROW_18_211 VGND VPWR sky130_fd_sc_hd__tapvpwrvgnd_1
XFILLER_31_263 VGND VGND VPWR VPWR sky130_fd_sc_hd__fill_2
X_1636_ _0904_/Y _1623_/C _1635_/A VGND VGND VPWR VPWR _1636_/X sky130_fd_sc_hd__a21bo_2
X_1567_ _0919_/B _1059_/B _1586_/S VGND VGND VPWR VPWR _1567_/X sky130_fd_sc_hd__mux2_1
X_1498_ _0932_/A _1511_/B _1477_/A _1477_/B _1496_/A VGND VGND VPWR VPWR _1498_/X
+ sky130_fd_sc_hd__a221o_2
XFILLER_22_230 VGND VGND VPWR VPWR sky130_fd_sc_hd__decap_3
XFILLER_22_263 VGND VGND VPWR VPWR sky130_fd_sc_hd__decap_3
XTAP_TAPCELL_ROW_24_247 VGND VPWR sky130_fd_sc_hd__tapvpwrvgnd_1
XFILLER_13_55 VGND VGND VPWR VPWR sky130_fd_sc_hd__fill_1
XFILLER_13_77 VGND VGND VPWR VPWR sky130_fd_sc_hd__decap_3
XTAP_TAPCELL_ROW_32_291 VGND VPWR sky130_fd_sc_hd__tapvpwrvgnd_1
XFILLER_38_52 VGND VGND VPWR VPWR sky130_fd_sc_hd__decap_3
XFILLER_13_252 VGND VGND VPWR VPWR sky130_fd_sc_hd__decap_3
X_1421_ _1039_/B _1420_/X _1537_/A VGND VGND VPWR VPWR _1421_/X sky130_fd_sc_hd__a21o_2
XFILLER_36_300 VGND VGND VPWR VPWR sky130_fd_sc_hd__decap_3
XFILLER_48_160 VGND VGND VPWR VPWR sky130_fd_sc_hd__fill_1
X_1352_ _1352_/A _1352_/B VGND VGND VPWR VPWR _1352_/Y sky130_fd_sc_hd__nand2_2
X_1283_ _1452_/A _1012_/B _1012_/A _1661_/A1 VGND VGND VPWR VPWR _1286_/A sky130_fd_sc_hd__a2bb2o_2
X_0998_ _0998_/A input6/X VGND VGND VPWR VPWR _1408_/A sky130_fd_sc_hd__and2_4
XTAP_TAPCELL_ROW_21_228 VGND VPWR sky130_fd_sc_hd__tapvpwrvgnd_1
X_1619_ _1601_/B _1597_/B _0911_/B VGND VGND VPWR VPWR _1621_/C sky130_fd_sc_hd__o21bai_2
Xfanout202 input30/X VGND VGND VPWR VPWR _0984_/B sky130_fd_sc_hd__buf_6
XFILLER_46_108 VGND VGND VPWR VPWR sky130_fd_sc_hd__decap_3
XFILLER_6_226 VGND VGND VPWR VPWR sky130_fd_sc_hd__decap_3
XTAP_TAPCELL_ROW_52_397 VGND VPWR sky130_fd_sc_hd__tapvpwrvgnd_1
XFILLER_40_53 VGND VGND VPWR VPWR sky130_fd_sc_hd__decap_3
XFILLER_40_97 VGND VGND VPWR VPWR sky130_fd_sc_hd__decap_3
XFILLER_1_36 VGND VGND VPWR VPWR sky130_fd_sc_hd__decap_3
XFILLER_37_108 VGND VGND VPWR VPWR sky130_fd_sc_hd__decap_3
XFILLER_45_141 VGND VGND VPWR VPWR sky130_fd_sc_hd__decap_3
XFILLER_45_174 VGND VGND VPWR VPWR sky130_fd_sc_hd__decap_3
X_0921_ _1059_/A _1059_/B VGND VGND VPWR VPWR _0922_/B sky130_fd_sc_hd__and2b_2
X_0852_ _0852_/A _1246_/B VGND VGND VPWR VPWR _0852_/Y sky130_fd_sc_hd__nor2_2
XFILLER_5_281 VGND VGND VPWR VPWR sky130_fd_sc_hd__decap_3
X_1404_ _1404_/A _1404_/B _1404_/C VGND VGND VPWR VPWR _1405_/C sky130_fd_sc_hd__and3_4
X_1335_ _1332_/X _1334_/X _1354_/B VGND VGND VPWR VPWR _1335_/Y sky130_fd_sc_hd__a21oi_2
XFILLER_36_130 VGND VGND VPWR VPWR sky130_fd_sc_hd__fill_2
XFILLER_36_141 VGND VGND VPWR VPWR sky130_fd_sc_hd__decap_3
Xinput2 A[10] VGND VGND VPWR VPWR input2/X sky130_fd_sc_hd__clkdlybuf4s25_1
X_1266_ _1266_/A _1266_/B VGND VGND VPWR VPWR _1266_/Y sky130_fd_sc_hd__nand2_2
X_1197_ _1416_/B _1175_/A _1083_/X _1194_/X VGND VGND VPWR VPWR _1197_/X sky130_fd_sc_hd__a31o_2
XFILLER_10_12 VGND VGND VPWR VPWR sky130_fd_sc_hd__decap_3
XFILLER_19_32 VGND VGND VPWR VPWR sky130_fd_sc_hd__decap_3
XFILLER_19_54 VGND VGND VPWR VPWR sky130_fd_sc_hd__fill_2
XPHY_EDGE_ROW_40_Left_93 VGND VGND VPWR VPWR sky130_fd_sc_hd__decap_3
XFILLER_27_130 VGND VGND VPWR VPWR sky130_fd_sc_hd__decap_3
XFILLER_35_31 VGND VGND VPWR VPWR sky130_fd_sc_hd__decap_3
XFILLER_35_64 VGND VGND VPWR VPWR sky130_fd_sc_hd__decap_3
XFILLER_42_100 VGND VGND VPWR VPWR sky130_fd_sc_hd__decap_3
XFILLER_42_144 VGND VGND VPWR VPWR sky130_fd_sc_hd__decap_3
XFILLER_51_30 VGND VGND VPWR VPWR sky130_fd_sc_hd__decap_3
XTAP_TAPCELL_ROW_40_334 VGND VPWR sky130_fd_sc_hd__tapvpwrvgnd_1
XFILLER_2_251 VGND VGND VPWR VPWR sky130_fd_sc_hd__fill_1
XFILLER_2_262 VGND VGND VPWR VPWR sky130_fd_sc_hd__decap_3
XFILLER_2_295 VGND VGND VPWR VPWR sky130_fd_sc_hd__decap_3
XFILLER_18_163 VGND VGND VPWR VPWR sky130_fd_sc_hd__decap_3
XFILLER_33_111 VGND VGND VPWR VPWR sky130_fd_sc_hd__fill_1
X_1120_ _1120_/A VGND VGND VPWR VPWR _1120_/Y sky130_fd_sc_hd__inv_2
X_1051_ _1046_/A _1051_/B VGND VGND VPWR VPWR _1051_/Y sky130_fd_sc_hd__nand2b_2
XFILLER_33_155 VGND VGND VPWR VPWR sky130_fd_sc_hd__decap_3
X_0904_ _0905_/A _0905_/B VGND VGND VPWR VPWR _0904_/Y sky130_fd_sc_hd__nand2_2
X_0835_ _0835_/A VGND VGND VPWR VPWR _1082_/B sky130_fd_sc_hd__inv_2
XPHY_EDGE_ROW_47_Left_100 VGND VGND VPWR VPWR sky130_fd_sc_hd__decap_3
X_1318_ _1240_/X _1317_/X _1457_/S VGND VGND VPWR VPWR _1472_/B sky130_fd_sc_hd__mux2_1
XFILLER_24_144 VGND VGND VPWR VPWR sky130_fd_sc_hd__decap_3
X_1249_ _1249_/A _1249_/B _1249_/C VGND VGND VPWR VPWR _1250_/C sky130_fd_sc_hd__or3_2
XFILLER_21_55 VGND VGND VPWR VPWR sky130_fd_sc_hd__fill_1
XFILLER_21_88 VGND VGND VPWR VPWR sky130_fd_sc_hd__fill_1
XFILLER_46_41 VGND VGND VPWR VPWR sky130_fd_sc_hd__decap_3
XFILLER_46_85 VGND VGND VPWR VPWR sky130_fd_sc_hd__decap_3
XFILLER_47_247 VGND VGND VPWR VPWR sky130_fd_sc_hd__decap_3
XFILLER_15_166 VGND VGND VPWR VPWR sky130_fd_sc_hd__fill_2
XFILLER_15_199 VGND VGND VPWR VPWR sky130_fd_sc_hd__decap_3
XFILLER_30_147 VGND VGND VPWR VPWR sky130_fd_sc_hd__decap_3
XFILLER_7_24 VGND VGND VPWR VPWR sky130_fd_sc_hd__decap_3
XFILLER_7_57 VGND VGND VPWR VPWR sky130_fd_sc_hd__decap_3
XFILLER_38_203 VGND VGND VPWR VPWR sky130_fd_sc_hd__decap_3
XFILLER_38_225 VGND VGND VPWR VPWR sky130_fd_sc_hd__decap_3
XFILLER_46_280 VGND VGND VPWR VPWR sky130_fd_sc_hd__decap_3
X_1103_ _1104_/A _1104_/B VGND VGND VPWR VPWR _1103_/Y sky130_fd_sc_hd__nor2_2
X_1034_ _1034_/A _1034_/B VGND VGND VPWR VPWR _1035_/B sky130_fd_sc_hd__nand2_2
XFILLER_21_147 VGND VGND VPWR VPWR sky130_fd_sc_hd__decap_3
XFILLER_21_169 VGND VGND VPWR VPWR sky130_fd_sc_hd__decap_3
Xinput60 B[5] VGND VGND VPWR VPWR _0952_/A sky130_fd_sc_hd__dlymetal6s2s_1
XFILLER_29_225 VGND VGND VPWR VPWR sky130_fd_sc_hd__fill_2
XFILLER_29_236 VGND VGND VPWR VPWR sky130_fd_sc_hd__fill_1
XFILLER_44_206 VGND VGND VPWR VPWR sky130_fd_sc_hd__decap_3
XFILLER_12_147 VGND VGND VPWR VPWR sky130_fd_sc_hd__decap_3
XFILLER_12_169 VGND VGND VPWR VPWR sky130_fd_sc_hd__decap_3
XFILLER_52_261 VGND VGND VPWR VPWR sky130_fd_sc_hd__decap_3
XFILLER_32_32 VGND VGND VPWR VPWR sky130_fd_sc_hd__fill_1
XFILLER_4_302 VGND VGND VPWR VPWR sky130_fd_sc_hd__decap_3
XTAP_TAPCELL_ROW_7_151 VGND VPWR sky130_fd_sc_hd__tapvpwrvgnd_1
XFILLER_35_228 VGND VGND VPWR VPWR sky130_fd_sc_hd__decap_3
XFILLER_35_239 VGND VGND VPWR VPWR sky130_fd_sc_hd__decap_3
XFILLER_43_250 VGND VGND VPWR VPWR sky130_fd_sc_hd__decap_3
XTAP_TAPCELL_ROW_13_186 VGND VPWR sky130_fd_sc_hd__tapvpwrvgnd_1
X_1652_ _0893_/Y _1650_/X _1104_/X VGND VGND VPWR VPWR _1652_/Y sky130_fd_sc_hd__a21oi_2
X_1583_ _1581_/A _1574_/X _1581_/B _0916_/Y VGND VGND VPWR VPWR _1597_/C sky130_fd_sc_hd__a31o_2
XFILLER_41_209 VGND VGND VPWR VPWR sky130_fd_sc_hd__decap_3
X_1017_ _1252_/C _1273_/A1 _1003_/X _1016_/Y VGND VGND VPWR VPWR _1017_/X sky130_fd_sc_hd__a211o_4
Xrebuffer215 _1076_/S VGND VGND VPWR VPWR _1644_/S sky130_fd_sc_hd__buf_2
Xrebuffer248 _1682_/B VGND VGND VPWR VPWR output93/A sky130_fd_sc_hd__buf_6
Xrebuffer237 _1086_/X VGND VGND VPWR VPWR _1110_/A2 sky130_fd_sc_hd__buf_2
Xrebuffer226 _1157_/X VGND VGND VPWR VPWR _1391_/A2 sky130_fd_sc_hd__buf_4
XFILLER_1_305 VGND VGND VPWR VPWR sky130_fd_sc_hd__decap_3
XFILLER_17_206 VGND VGND VPWR VPWR sky130_fd_sc_hd__decap_3
XFILLER_17_228 VGND VGND VPWR VPWR sky130_fd_sc_hd__fill_2
XFILLER_27_54 VGND VGND VPWR VPWR sky130_fd_sc_hd__fill_2
XFILLER_40_253 VGND VGND VPWR VPWR sky130_fd_sc_hd__decap_3
XTAP_TAPCELL_ROW_10_167 VGND VPWR sky130_fd_sc_hd__tapvpwrvgnd_1
XFILLER_16_250 VGND VGND VPWR VPWR sky130_fd_sc_hd__fill_2
XTAP_TAPCELL_ROW_18_212 VGND VPWR sky130_fd_sc_hd__tapvpwrvgnd_1
X_1635_ _1635_/A _1635_/B _1623_/C VGND VGND VPWR VPWR _1635_/X sky130_fd_sc_hd__or3b_2
X_1566_ _1585_/A3 _0920_/A _1647_/C1 _1565_/Y VGND VGND VPWR VPWR _1566_/X sky130_fd_sc_hd__a211o_2
X_1497_ _1509_/B _1478_/B _1496_/Y VGND VGND VPWR VPWR _1497_/X sky130_fd_sc_hd__a21o_2
XFILLER_14_209 VGND VGND VPWR VPWR sky130_fd_sc_hd__decap_3
XTAP_TAPCELL_ROW_49_381 VGND VPWR sky130_fd_sc_hd__tapvpwrvgnd_1
XFILLER_13_12 VGND VGND VPWR VPWR sky130_fd_sc_hd__decap_3
XTAP_TAPCELL_ROW_32_292 VGND VPWR sky130_fd_sc_hd__tapvpwrvgnd_1
XTAP_TAPCELL_ROW_24_248 VGND VPWR sky130_fd_sc_hd__tapvpwrvgnd_1
XFILLER_1_113 VGND VGND VPWR VPWR sky130_fd_sc_hd__fill_1
XFILLER_38_64 VGND VGND VPWR VPWR sky130_fd_sc_hd__decap_3
XFILLER_13_297 VGND VGND VPWR VPWR sky130_fd_sc_hd__fill_1
XFILLER_48_6 VGND VGND VPWR VPWR sky130_fd_sc_hd__decap_3
X_1420_ _1555_/B2 _1442_/B _1453_/A1 VGND VGND VPWR VPWR _1420_/X sky130_fd_sc_hd__a21o_2
X_1351_ _1351_/A _1351_/B _1368_/B VGND VGND VPWR VPWR _1351_/X sky130_fd_sc_hd__and3_2
XFILLER_48_194 VGND VGND VPWR VPWR sky130_fd_sc_hd__fill_2
X_1282_ _1107_/X _1430_/B _1430_/A VGND VGND VPWR VPWR _1282_/X sky130_fd_sc_hd__mux2_2
XTAP_TAPCELL_ROW_21_229 VGND VPWR sky130_fd_sc_hd__tapvpwrvgnd_1
X_1618_ _1552_/C _1552_/B _1573_/X _1617_/Y VGND VGND VPWR VPWR _1621_/B sky130_fd_sc_hd__a211oi_4
X_0997_ _0998_/A input6/X VGND VGND VPWR VPWR _0999_/A sky130_fd_sc_hd__nor2_2
XFILLER_39_161 VGND VGND VPWR VPWR sky130_fd_sc_hd__fill_2
XFILLER_5_90 VGND VGND VPWR VPWR sky130_fd_sc_hd__decap_3
Xfanout203 input3/X VGND VGND VPWR VPWR _1018_/B sky130_fd_sc_hd__clkbuf_2
X_1549_ _1410_/X _1549_/A2 _1481_/X _1548_/X VGND VGND VPWR VPWR _1549_/X sky130_fd_sc_hd__a211o_4
XFILLER_10_212 VGND VGND VPWR VPWR sky130_fd_sc_hd__decap_3
XFILLER_24_88 VGND VGND VPWR VPWR sky130_fd_sc_hd__decap_3
XFILLER_40_32 VGND VGND VPWR VPWR sky130_fd_sc_hd__decap_3
XTAP_TAPCELL_ROW_52_398 VGND VPWR sky130_fd_sc_hd__tapvpwrvgnd_1
XFILLER_49_30 VGND VGND VPWR VPWR sky130_fd_sc_hd__decap_3
XFILLER_1_15 VGND VGND VPWR VPWR sky130_fd_sc_hd__decap_3
XFILLER_45_153 VGND VGND VPWR VPWR sky130_fd_sc_hd__decap_3
X_0920_ _0920_/A _0920_/B VGND VGND VPWR VPWR _1575_/A sky130_fd_sc_hd__or2_2
XFILLER_5_271 VGND VGND VPWR VPWR sky130_fd_sc_hd__decap_3
X_0851_ _0849_/X _0850_/X _1265_/S VGND VGND VPWR VPWR _0851_/X sky130_fd_sc_hd__mux2_1
XFILLER_46_3 VGND VGND VPWR VPWR sky130_fd_sc_hd__decap_3
XFILLER_5_293 VGND VGND VPWR VPWR sky130_fd_sc_hd__decap_3
XPHY_EDGE_ROW_18_Right_18 VGND VGND VPWR VPWR sky130_fd_sc_hd__decap_3
X_1403_ _1404_/A _1404_/B _1404_/C VGND VGND VPWR VPWR _1405_/B sky130_fd_sc_hd__a21oi_2
X_1334_ _1255_/X _1334_/A2 _1333_/X VGND VGND VPWR VPWR _1334_/X sky130_fd_sc_hd__a21o_2
X_1265_ _1182_/X _1264_/X _1265_/S VGND VGND VPWR VPWR _1265_/X sky130_fd_sc_hd__mux2_1
XFILLER_36_153 VGND VGND VPWR VPWR sky130_fd_sc_hd__decap_3
XFILLER_36_197 VGND VGND VPWR VPWR sky130_fd_sc_hd__decap_3
Xinput3 A[11] VGND VGND VPWR VPWR input3/X sky130_fd_sc_hd__clkdlybuf4s25_1
X_1196_ _1416_/B _1195_/X _1194_/X VGND VGND VPWR VPWR _1196_/X sky130_fd_sc_hd__a21o_2
XPHY_EDGE_ROW_27_Right_27 VGND VGND VPWR VPWR sky130_fd_sc_hd__decap_3
XFILLER_10_24 VGND VGND VPWR VPWR sky130_fd_sc_hd__decap_3
XFILLER_10_35 VGND VGND VPWR VPWR sky130_fd_sc_hd__decap_3
XFILLER_10_46 VGND VGND VPWR VPWR sky130_fd_sc_hd__decap_3
XPHY_EDGE_ROW_36_Right_36 VGND VGND VPWR VPWR sky130_fd_sc_hd__decap_3
XFILLER_19_66 VGND VGND VPWR VPWR sky130_fd_sc_hd__decap_3
XFILLER_27_142 VGND VGND VPWR VPWR sky130_fd_sc_hd__decap_3
XFILLER_35_43 VGND VGND VPWR VPWR sky130_fd_sc_hd__decap_3
XFILLER_35_76 VGND VGND VPWR VPWR sky130_fd_sc_hd__decap_3
XFILLER_42_134 VGND VGND VPWR VPWR sky130_fd_sc_hd__decap_3
XFILLER_42_178 VGND VGND VPWR VPWR sky130_fd_sc_hd__fill_2
XTAP_TAPCELL_ROW_40_335 VGND VPWR sky130_fd_sc_hd__tapvpwrvgnd_1
XPHY_EDGE_ROW_45_Right_45 VGND VGND VPWR VPWR sky130_fd_sc_hd__decap_3
XFILLER_51_42 VGND VGND VPWR VPWR sky130_fd_sc_hd__decap_3
XFILLER_2_274 VGND VGND VPWR VPWR sky130_fd_sc_hd__decap_3
XFILLER_33_134 VGND VGND VPWR VPWR sky130_fd_sc_hd__decap_3
X_1050_ _1404_/A _1404_/B _1040_/Y _1049_/X VGND VGND VPWR VPWR _1050_/X sky130_fd_sc_hd__a211o_4
XFILLER_21_307 VGND VGND VPWR VPWR sky130_fd_sc_hd__decap_3
XFILLER_33_167 VGND VGND VPWR VPWR sky130_fd_sc_hd__fill_1
XFILLER_33_178 VGND VGND VPWR VPWR sky130_fd_sc_hd__decap_3
XFILLER_33_189 VGND VGND VPWR VPWR sky130_fd_sc_hd__decap_3
X_0903_ _0905_/A _0905_/B VGND VGND VPWR VPWR _1635_/B sky130_fd_sc_hd__and2_2
X_0834_ _1145_/S VGND VGND VPWR VPWR _1600_/S sky130_fd_sc_hd__inv_4
X_1317_ _1018_/B input2/X _1019_/B input31/X _1358_/S0 _1358_/S1 VGND VGND VPWR VPWR
+ _1317_/X sky130_fd_sc_hd__mux4_2
X_1248_ _1379_/A _1243_/X _1247_/Y _1313_/B _1598_/A VGND VGND VPWR VPWR _1249_/C
+ sky130_fd_sc_hd__o221a_2
XFILLER_24_112 VGND VGND VPWR VPWR sky130_fd_sc_hd__decap_3
XFILLER_24_134 VGND VGND VPWR VPWR sky130_fd_sc_hd__decap_3
X_1179_ _1174_/X _1176_/Y _1379_/A VGND VGND VPWR VPWR _1179_/X sky130_fd_sc_hd__mux2_1
XFILLER_21_67 VGND VGND VPWR VPWR sky130_fd_sc_hd__decap_3
XFILLER_15_134 VGND VGND VPWR VPWR sky130_fd_sc_hd__fill_2
XFILLER_46_64 VGND VGND VPWR VPWR sky130_fd_sc_hd__decap_3
XFILLER_47_259 VGND VGND VPWR VPWR sky130_fd_sc_hd__decap_3
XFILLER_7_36 VGND VGND VPWR VPWR sky130_fd_sc_hd__decap_3
X_1102_ _1102_/A _1102_/B VGND VGND VPWR VPWR _1102_/Y sky130_fd_sc_hd__nor2_2
XFILLER_21_126 VGND VGND VPWR VPWR sky130_fd_sc_hd__decap_3
XFILLER_46_292 VGND VGND VPWR VPWR sky130_fd_sc_hd__decap_3
X_1033_ _1034_/A _1034_/B VGND VGND VPWR VPWR _1035_/A sky130_fd_sc_hd__or2_2
XFILLER_21_159 VGND VGND VPWR VPWR sky130_fd_sc_hd__decap_3
Xinput50 B[25] VGND VGND VPWR VPWR _0919_/A sky130_fd_sc_hd__clkdlybuf4s25_1
Xinput61 B[6] VGND VGND VPWR VPWR _0981_/A sky130_fd_sc_hd__dlymetal6s4s_1
XFILLER_29_248 VGND VGND VPWR VPWR sky130_fd_sc_hd__decap_3
XFILLER_12_115 VGND VGND VPWR VPWR sky130_fd_sc_hd__decap_3
XFILLER_16_45 VGND VGND VPWR VPWR sky130_fd_sc_hd__decap_3
XFILLER_16_56 VGND VGND VPWR VPWR sky130_fd_sc_hd__decap_3
XFILLER_32_44 VGND VGND VPWR VPWR sky130_fd_sc_hd__decap_3
XFILLER_52_251 VGND VGND VPWR VPWR sky130_fd_sc_hd__fill_1
XFILLER_52_284 VGND VGND VPWR VPWR sky130_fd_sc_hd__decap_3
XFILLER_8_119 VGND VGND VPWR VPWR sky130_fd_sc_hd__decap_3
XPHY_EDGE_ROW_0_Right_0 VGND VGND VPWR VPWR sky130_fd_sc_hd__decap_3
XTAP_TAPCELL_ROW_7_152 VGND VPWR sky130_fd_sc_hd__tapvpwrvgnd_1
XFILLER_43_295 VGND VGND VPWR VPWR sky130_fd_sc_hd__decap_3
XFILLER_7_141 VGND VGND VPWR VPWR sky130_fd_sc_hd__decap_3
X_1651_ _1622_/Y _0904_/Y _0897_/A _0895_/Y _0893_/Y VGND VGND VPWR VPWR _1651_/X
+ sky130_fd_sc_hd__a311o_2
XTAP_TAPCELL_ROW_13_187 VGND VPWR sky130_fd_sc_hd__tapvpwrvgnd_1
X_1582_ _1620_/B _1620_/C _1574_/X VGND VGND VPWR VPWR _1582_/X sky130_fd_sc_hd__or3b_2
XFILLER_26_229 VGND VGND VPWR VPWR sky130_fd_sc_hd__decap_3
X_1016_ _1016_/A _1288_/A _1288_/B VGND VGND VPWR VPWR _1016_/Y sky130_fd_sc_hd__nand3_2
Xrebuffer216 _1070_/X VGND VGND VPWR VPWR _1193_/B sky130_fd_sc_hd__buf_2
Xrebuffer249 _1407_/X VGND VGND VPWR VPWR _1549_/A2 sky130_fd_sc_hd__buf_6
Xrebuffer238 _1257_/X VGND VGND VPWR VPWR _1334_/A2 sky130_fd_sc_hd__buf_2
Xrebuffer227 _0843_/X VGND VGND VPWR VPWR _1343_/A1 sky130_fd_sc_hd__buf_6
XTAP_TAPCELL_ROW_4_133 VGND VPWR sky130_fd_sc_hd__tapvpwrvgnd_1
XFILLER_17_218 VGND VGND VPWR VPWR sky130_fd_sc_hd__decap_3
XFILLER_25_240 VGND VGND VPWR VPWR sky130_fd_sc_hd__decap_3
XFILLER_25_262 VGND VGND VPWR VPWR sky130_fd_sc_hd__decap_3
XFILLER_27_77 VGND VGND VPWR VPWR sky130_fd_sc_hd__fill_1
XFILLER_27_99 VGND VGND VPWR VPWR sky130_fd_sc_hd__decap_3
XFILLER_43_21 VGND VGND VPWR VPWR sky130_fd_sc_hd__decap_3
XFILLER_40_232 VGND VGND VPWR VPWR sky130_fd_sc_hd__decap_3
XFILLER_40_265 VGND VGND VPWR VPWR sky130_fd_sc_hd__decap_3
XFILLER_40_287 VGND VGND VPWR VPWR sky130_fd_sc_hd__decap_3
XFILLER_43_43 VGND VGND VPWR VPWR sky130_fd_sc_hd__decap_3
XFILLER_4_15 VGND VGND VPWR VPWR sky130_fd_sc_hd__decap_3
XTAP_TAPCELL_ROW_10_168 VGND VPWR sky130_fd_sc_hd__tapvpwrvgnd_1
XTAP_TAPCELL_ROW_18_213 VGND VPWR sky130_fd_sc_hd__tapvpwrvgnd_1
XFILLER_16_262 VGND VGND VPWR VPWR sky130_fd_sc_hd__decap_3
XFILLER_31_221 VGND VGND VPWR VPWR sky130_fd_sc_hd__decap_3
X_1634_ _1591_/A _1362_/X _1419_/B _1360_/X _1633_/X VGND VGND VPWR VPWR _1634_/X
+ sky130_fd_sc_hd__a221o_2
X_1565_ _1601_/A _0920_/B _1575_/A _1133_/A VGND VGND VPWR VPWR _1565_/Y sky130_fd_sc_hd__o22ai_2
X_1496_ _1496_/A _1496_/B VGND VGND VPWR VPWR _1496_/Y sky130_fd_sc_hd__nand2_2
XTAP_TAPCELL_ROW_49_382 VGND VPWR sky130_fd_sc_hd__tapvpwrvgnd_1
XFILLER_13_24 VGND VGND VPWR VPWR sky130_fd_sc_hd__decap_3
XFILLER_13_57 VGND VGND VPWR VPWR sky130_fd_sc_hd__decap_3
XFILLER_22_221 VGND VGND VPWR VPWR sky130_fd_sc_hd__decap_3
XFILLER_8_6 VGND VGND VPWR VPWR sky130_fd_sc_hd__decap_3
XFILLER_38_43 VGND VGND VPWR VPWR sky130_fd_sc_hd__decap_3
XFILLER_38_76 VGND VGND VPWR VPWR sky130_fd_sc_hd__decap_3
XFILLER_45_302 VGND VGND VPWR VPWR sky130_fd_sc_hd__decap_3
XFILLER_49_129 VGND VGND VPWR VPWR sky130_fd_sc_hd__fill_1
XFILLER_13_221 VGND VGND VPWR VPWR sky130_fd_sc_hd__decap_3
XFILLER_13_243 VGND VGND VPWR VPWR sky130_fd_sc_hd__decap_3
XFILLER_9_225 VGND VGND VPWR VPWR sky130_fd_sc_hd__decap_3
X_1350_ _1327_/B _1327_/C _1003_/B VGND VGND VPWR VPWR _1368_/B sky130_fd_sc_hd__a21o_2
X_1281_ _1199_/X _1280_/X _1281_/S VGND VGND VPWR VPWR _1430_/B sky130_fd_sc_hd__mux2_1
XFILLER_51_305 VGND VGND VPWR VPWR sky130_fd_sc_hd__decap_3
X_0996_ _1352_/A _1354_/B VGND VGND VPWR VPWR _1003_/B sky130_fd_sc_hd__nand2_2
XFILLER_5_80 VGND VGND VPWR VPWR sky130_fd_sc_hd__fill_2
XFILLER_8_291 VGND VGND VPWR VPWR sky130_fd_sc_hd__fill_1
X_1617_ _1620_/A _1620_/B VGND VGND VPWR VPWR _1617_/Y sky130_fd_sc_hd__nand2_2
Xfanout204 input29/X VGND VGND VPWR VPWR _0981_/B sky130_fd_sc_hd__buf_6
X_1548_ _1548_/A _1548_/B _1548_/C VGND VGND VPWR VPWR _1548_/X sky130_fd_sc_hd__or3_2
X_1479_ _1479_/A _1479_/B VGND VGND VPWR VPWR _1481_/B sky130_fd_sc_hd__nand2_2
XFILLER_10_224 VGND VGND VPWR VPWR sky130_fd_sc_hd__fill_1
XFILLER_10_246 VGND VGND VPWR VPWR sky130_fd_sc_hd__decap_3
XFILLER_40_44 VGND VGND VPWR VPWR sky130_fd_sc_hd__decap_3
XFILLER_40_77 VGND VGND VPWR VPWR sky130_fd_sc_hd__decap_3
XTAP_TAPCELL_ROW_52_399 VGND VPWR sky130_fd_sc_hd__tapvpwrvgnd_1
XFILLER_6_3 VGND VGND VPWR VPWR sky130_fd_sc_hd__decap_3
XFILLER_1_27 VGND VGND VPWR VPWR sky130_fd_sc_hd__decap_3
XFILLER_33_305 VGND VGND VPWR VPWR sky130_fd_sc_hd__decap_3
XFILLER_45_165 VGND VGND VPWR VPWR sky130_fd_sc_hd__decap_3
X_0850_ _1160_/A1 _1019_/B _1006_/B _1018_/B _0850_/S0 _0850_/S1 VGND VGND VPWR VPWR
+ _0850_/X sky130_fd_sc_hd__mux4_2
X_1402_ _1351_/B _1388_/Y _1401_/X VGND VGND VPWR VPWR _1679_/A sky130_fd_sc_hd__a21o_2
Xinput4 A[12] VGND VGND VPWR VPWR input4/X sky130_fd_sc_hd__dlymetal6s2s_1
X_1333_ _1333_/A _1333_/B _1333_/C VGND VGND VPWR VPWR _1333_/X sky130_fd_sc_hd__or3_4
X_1264_ _1280_/A1 input30/X input29/X _0951_/B _1090_/S _1264_/S1 VGND VGND VPWR VPWR
+ _1264_/X sky130_fd_sc_hd__mux4_2
X_1195_ _1392_/A _1076_/X _1226_/C VGND VGND VPWR VPWR _1195_/X sky130_fd_sc_hd__mux2_1
XTAP_TAPCELL_ROW_34_300 VGND VPWR sky130_fd_sc_hd__tapvpwrvgnd_1
X_0979_ _0981_/A _0988_/B VGND VGND VPWR VPWR _1217_/B sky130_fd_sc_hd__nand2_2
XFILLER_10_58 VGND VGND VPWR VPWR sky130_fd_sc_hd__decap_3
XFILLER_19_45 VGND VGND VPWR VPWR sky130_fd_sc_hd__decap_3
XFILLER_19_78 VGND VGND VPWR VPWR sky130_fd_sc_hd__decap_3
XFILLER_27_154 VGND VGND VPWR VPWR sky130_fd_sc_hd__fill_2
XFILLER_27_165 VGND VGND VPWR VPWR sky130_fd_sc_hd__decap_3
XFILLER_35_11 VGND VGND VPWR VPWR sky130_fd_sc_hd__fill_2
XFILLER_35_55 VGND VGND VPWR VPWR sky130_fd_sc_hd__fill_1
XFILLER_42_113 VGND VGND VPWR VPWR sky130_fd_sc_hd__decap_3
XFILLER_51_21 VGND VGND VPWR VPWR sky130_fd_sc_hd__decap_3
XFILLER_51_54 VGND VGND VPWR VPWR sky130_fd_sc_hd__fill_2
XTAP_TAPCELL_ROW_40_336 VGND VPWR sky130_fd_sc_hd__tapvpwrvgnd_1
XFILLER_2_253 VGND VGND VPWR VPWR sky130_fd_sc_hd__decap_3
XFILLER_2_286 VGND VGND VPWR VPWR sky130_fd_sc_hd__decap_3
XFILLER_18_154 VGND VGND VPWR VPWR sky130_fd_sc_hd__decap_3
XFILLER_33_113 VGND VGND VPWR VPWR sky130_fd_sc_hd__decap_3
XFILLER_33_146 VGND VGND VPWR VPWR sky130_fd_sc_hd__decap_3
X_0902_ _1657_/A _1657_/B _0900_/X _0901_/X _0885_/Y VGND VGND VPWR VPWR _0902_/X
+ sky130_fd_sc_hd__o221a_2
X_0833_ _0833_/A VGND VGND VPWR VPWR _0833_/Y sky130_fd_sc_hd__inv_2
XFILLER_49_290 VGND VGND VPWR VPWR sky130_fd_sc_hd__decap_3
X_1316_ _1142_/X _1316_/A1 _1391_/A2 _1316_/A3 _1457_/S _1472_/A VGND VGND VPWR VPWR
+ _1316_/X sky130_fd_sc_hd__mux4_2
X_1247_ _1247_/A _1395_/B VGND VGND VPWR VPWR _1247_/Y sky130_fd_sc_hd__nand2_2
X_1178_ _1174_/X _1177_/Y _1178_/S VGND VGND VPWR VPWR _1178_/X sky130_fd_sc_hd__mux2_1
XFILLER_24_168 VGND VGND VPWR VPWR sky130_fd_sc_hd__decap_3
XFILLER_32_190 VGND VGND VPWR VPWR sky130_fd_sc_hd__decap_3
XFILLER_21_24 VGND VGND VPWR VPWR sky130_fd_sc_hd__decap_3
XFILLER_21_46 VGND VGND VPWR VPWR sky130_fd_sc_hd__decap_3
XFILLER_21_57 VGND VGND VPWR VPWR sky130_fd_sc_hd__fill_1
XFILLER_21_79 VGND VGND VPWR VPWR sky130_fd_sc_hd__decap_3
XFILLER_47_216 VGND VGND VPWR VPWR sky130_fd_sc_hd__fill_2
XFILLER_46_21 VGND VGND VPWR VPWR sky130_fd_sc_hd__decap_3
XFILLER_46_32 VGND VGND VPWR VPWR sky130_fd_sc_hd__decap_3
XFILLER_30_138 VGND VGND VPWR VPWR sky130_fd_sc_hd__fill_2
XFILLER_7_15 VGND VGND VPWR VPWR sky130_fd_sc_hd__decap_3
XFILLER_38_249 VGND VGND VPWR VPWR sky130_fd_sc_hd__decap_3
X_1101_ _1101_/A _1101_/B VGND VGND VPWR VPWR _1101_/Y sky130_fd_sc_hd__xnor2_2
X_1032_ _1001_/A _0829_/Y _1003_/X _1327_/B _1031_/X VGND VGND VPWR VPWR _1404_/B
+ sky130_fd_sc_hd__o221a_4
XFILLER_21_116 VGND VGND VPWR VPWR sky130_fd_sc_hd__fill_1
XFILLER_21_138 VGND VGND VPWR VPWR sky130_fd_sc_hd__decap_3
XFILLER_46_271 VGND VGND VPWR VPWR sky130_fd_sc_hd__decap_3
Xinput40 B[16] VGND VGND VPWR VPWR _1037_/A sky130_fd_sc_hd__clkdlybuf4s25_1
Xinput51 B[26] VGND VGND VPWR VPWR _0914_/A sky130_fd_sc_hd__clkdlybuf4s25_1
Xinput62 B[7] VGND VGND VPWR VPWR _0976_/A sky130_fd_sc_hd__clkdlybuf4s25_1
XFILLER_16_35 VGND VGND VPWR VPWR sky130_fd_sc_hd__fill_1
XFILLER_16_68 VGND VGND VPWR VPWR sky130_fd_sc_hd__decap_3
XFILLER_37_260 VGND VGND VPWR VPWR sky130_fd_sc_hd__fill_1
XFILLER_37_271 VGND VGND VPWR VPWR sky130_fd_sc_hd__decap_3
XFILLER_37_293 VGND VGND VPWR VPWR sky130_fd_sc_hd__decap_3
XFILLER_12_138 VGND VGND VPWR VPWR sky130_fd_sc_hd__fill_2
XFILLER_32_56 VGND VGND VPWR VPWR sky130_fd_sc_hd__decap_3
XFILLER_32_78 VGND VGND VPWR VPWR sky130_fd_sc_hd__decap_3
XFILLER_52_296 VGND VGND VPWR VPWR sky130_fd_sc_hd__decap_3
XTAP_TAPCELL_ROW_7_153 VGND VPWR sky130_fd_sc_hd__tapvpwrvgnd_1
XFILLER_28_293 VGND VGND VPWR VPWR sky130_fd_sc_hd__fill_2
XFILLER_43_274 VGND VGND VPWR VPWR sky130_fd_sc_hd__fill_1
XFILLER_11_160 VGND VGND VPWR VPWR sky130_fd_sc_hd__decap_3
XFILLER_7_153 VGND VGND VPWR VPWR sky130_fd_sc_hd__decap_3
XFILLER_7_197 VGND VGND VPWR VPWR sky130_fd_sc_hd__decap_3
X_1650_ _0897_/A _0904_/Y _1623_/C _0895_/Y VGND VGND VPWR VPWR _1650_/X sky130_fd_sc_hd__a31o_2
X_1581_ _1581_/A _1581_/B VGND VGND VPWR VPWR _1620_/C sky130_fd_sc_hd__nand2_2
XFILLER_26_219 VGND VGND VPWR VPWR sky130_fd_sc_hd__fill_1
X_1015_ _1015_/A _1015_/B VGND VGND VPWR VPWR _1288_/B sky130_fd_sc_hd__nand2_4
XFILLER_34_263 VGND VGND VPWR VPWR sky130_fd_sc_hd__decap_3
XFILLER_34_296 VGND VGND VPWR VPWR sky130_fd_sc_hd__decap_3
XPHY_EDGE_ROW_14_Left_67 VGND VGND VPWR VPWR sky130_fd_sc_hd__decap_3
Xrebuffer217 fanout186/A VGND VGND VPWR VPWR _1358_/S0 sky130_fd_sc_hd__buf_2
Xrebuffer228 _1158_/X VGND VGND VPWR VPWR _1316_/A3 sky130_fd_sc_hd__buf_2
XFILLER_8_91 VGND VGND VPWR VPWR sky130_fd_sc_hd__decap_3
Xrebuffer239 _1469_/S VGND VGND VPWR VPWR _1499_/S sky130_fd_sc_hd__buf_2
XFILLER_27_34 VGND VGND VPWR VPWR sky130_fd_sc_hd__decap_3
XTAP_TAPCELL_ROW_4_134 VGND VPWR sky130_fd_sc_hd__tapvpwrvgnd_1
XFILLER_40_200 VGND VGND VPWR VPWR sky130_fd_sc_hd__decap_3
XFILLER_43_33 VGND VGND VPWR VPWR sky130_fd_sc_hd__decap_3
XFILLER_43_55 VGND VGND VPWR VPWR sky130_fd_sc_hd__fill_1
XFILLER_40_299 VGND VGND VPWR VPWR sky130_fd_sc_hd__decap_3
XFILLER_43_66 VGND VGND VPWR VPWR sky130_fd_sc_hd__decap_3
XFILLER_43_99 VGND VGND VPWR VPWR sky130_fd_sc_hd__decap_3
XTAP_TAPCELL_ROW_10_169 VGND VPWR sky130_fd_sc_hd__tapvpwrvgnd_1
XFILLER_4_27 VGND VGND VPWR VPWR sky130_fd_sc_hd__fill_1
XFILLER_4_38 VGND VGND VPWR VPWR sky130_fd_sc_hd__decap_3
XTAP_TAPCELL_ROW_18_214 VGND VPWR sky130_fd_sc_hd__tapvpwrvgnd_1
XFILLER_31_244 VGND VGND VPWR VPWR sky130_fd_sc_hd__fill_1
X_1633_ _1416_/X _1501_/X _1632_/X VGND VGND VPWR VPWR _1633_/X sky130_fd_sc_hd__a21o_2
X_1564_ _1575_/A _0922_/B _1546_/Y _1563_/X _1637_/A2 VGND VGND VPWR VPWR _1564_/X
+ sky130_fd_sc_hd__o311a_4
X_1495_ _1478_/X _1637_/A2 _1485_/Y _1494_/X VGND VGND VPWR VPWR _1679_/C sky130_fd_sc_hd__a211o_4
XFILLER_22_200 VGND VGND VPWR VPWR sky130_fd_sc_hd__fill_2
XFILLER_22_233 VGND VGND VPWR VPWR sky130_fd_sc_hd__decap_3
XTAP_TAPCELL_ROW_49_383 VGND VPWR sky130_fd_sc_hd__tapvpwrvgnd_1
XFILLER_38_55 VGND VGND VPWR VPWR sky130_fd_sc_hd__decap_3
XFILLER_48_141 VGND VGND VPWR VPWR sky130_fd_sc_hd__fill_2
X_1280_ _1019_/B _1280_/A1 _0984_/B input29/X _1280_/S0 _1358_/S1 VGND VGND VPWR VPWR
+ _1280_/X sky130_fd_sc_hd__mux4_2
XFILLER_36_303 VGND VGND VPWR VPWR sky130_fd_sc_hd__decap_3
XTAP_TAPCELL_ROW_46_364 VGND VPWR sky130_fd_sc_hd__tapvpwrvgnd_1
X_0995_ _0995_/A _0995_/B VGND VGND VPWR VPWR _1354_/B sky130_fd_sc_hd__nand2_8
X_1616_ _1340_/X _1419_/B _1615_/X VGND VGND VPWR VPWR _1616_/X sky130_fd_sc_hd__a21o_2
Xfanout205 _0985_/B VGND VGND VPWR VPWR _0952_/B sky130_fd_sc_hd__buf_6
X_1547_ _1057_/Y _1573_/B _1637_/A2 VGND VGND VPWR VPWR _1547_/Y sky130_fd_sc_hd__o21ai_2
XFILLER_39_141 VGND VGND VPWR VPWR sky130_fd_sc_hd__fill_2
XFILLER_39_152 VGND VGND VPWR VPWR sky130_fd_sc_hd__decap_3
X_1478_ _1509_/B _1478_/B VGND VGND VPWR VPWR _1478_/X sky130_fd_sc_hd__xor2_2
XFILLER_10_203 VGND VGND VPWR VPWR sky130_fd_sc_hd__decap_3
XPHY_EDGE_ROW_17_Left_70 VGND VGND VPWR VPWR sky130_fd_sc_hd__decap_3
XFILLER_40_12 VGND VGND VPWR VPWR sky130_fd_sc_hd__decap_3
XFILLER_40_56 VGND VGND VPWR VPWR sky130_fd_sc_hd__fill_1
XFILLER_6_207 VGND VGND VPWR VPWR sky130_fd_sc_hd__decap_3
XFILLER_6_229 VGND VGND VPWR VPWR sky130_fd_sc_hd__fill_2
XFILLER_49_21 VGND VGND VPWR VPWR sky130_fd_sc_hd__decap_3
XFILLER_49_98 VGND VGND VPWR VPWR sky130_fd_sc_hd__fill_2
XFILLER_1_39 VGND VGND VPWR VPWR sky130_fd_sc_hd__decap_3
XFILLER_45_144 VGND VGND VPWR VPWR sky130_fd_sc_hd__decap_3
XFILLER_45_177 VGND VGND VPWR VPWR sky130_fd_sc_hd__decap_3
XFILLER_5_262 VGND VGND VPWR VPWR sky130_fd_sc_hd__decap_3
XFILLER_5_284 VGND VGND VPWR VPWR sky130_fd_sc_hd__decap_3
X_1401_ _1513_/A1 _1389_/X _1390_/Y _1400_/X VGND VGND VPWR VPWR _1401_/X sky130_fd_sc_hd__a31o_2
XFILLER_36_144 VGND VGND VPWR VPWR sky130_fd_sc_hd__decap_3
Xinput5 A[13] VGND VGND VPWR VPWR input5/X sky130_fd_sc_hd__clkbuf_2
X_1332_ _1333_/A _1333_/B _1295_/C _1331_/Y VGND VGND VPWR VPWR _1332_/X sky130_fd_sc_hd__o31a_2
X_1263_ _1661_/A1 _1015_/B _1261_/X _1262_/Y VGND VGND VPWR VPWR _1271_/B sky130_fd_sc_hd__a211o_2
X_1194_ _1631_/A1 _1075_/X _1193_/X _1526_/S VGND VGND VPWR VPWR _1194_/X sky130_fd_sc_hd__o211a_2
XFILLER_51_169 VGND VGND VPWR VPWR sky130_fd_sc_hd__decap_3
XTAP_TAPCELL_ROW_34_301 VGND VPWR sky130_fd_sc_hd__tapvpwrvgnd_1
XFILLER_10_15 VGND VGND VPWR VPWR sky130_fd_sc_hd__decap_3
X_0978_ _0978_/A _1238_/B VGND VGND VPWR VPWR _1254_/C sky130_fd_sc_hd__nand2_4
XFILLER_19_35 VGND VGND VPWR VPWR sky130_fd_sc_hd__decap_3
XFILLER_19_57 VGND VGND VPWR VPWR sky130_fd_sc_hd__decap_3
XFILLER_27_111 VGND VGND VPWR VPWR sky130_fd_sc_hd__fill_1
XFILLER_27_133 VGND VGND VPWR VPWR sky130_fd_sc_hd__decap_3
XFILLER_35_34 VGND VGND VPWR VPWR sky130_fd_sc_hd__decap_3
XFILLER_35_67 VGND VGND VPWR VPWR sky130_fd_sc_hd__decap_3
XFILLER_42_103 VGND VGND VPWR VPWR sky130_fd_sc_hd__decap_3
XFILLER_30_309 VGND VGND VPWR VPWR sky130_fd_sc_hd__fill_1
XFILLER_42_147 VGND VGND VPWR VPWR sky130_fd_sc_hd__decap_3
XFILLER_51_33 VGND VGND VPWR VPWR sky130_fd_sc_hd__decap_3
XPHY_EDGE_ROW_2_Left_55 VGND VGND VPWR VPWR sky130_fd_sc_hd__decap_3
XFILLER_2_221 VGND VGND VPWR VPWR sky130_fd_sc_hd__decap_3
XFILLER_2_232 VGND VGND VPWR VPWR sky130_fd_sc_hd__decap_3
XFILLER_2_265 VGND VGND VPWR VPWR sky130_fd_sc_hd__decap_3
XFILLER_2_298 VGND VGND VPWR VPWR sky130_fd_sc_hd__decap_3
XFILLER_18_166 VGND VGND VPWR VPWR sky130_fd_sc_hd__decap_3
XFILLER_33_158 VGND VGND VPWR VPWR sky130_fd_sc_hd__decap_3
X_0901_ _1657_/A _0901_/B VGND VGND VPWR VPWR _0901_/X sky130_fd_sc_hd__or2_2
X_0832_ _1178_/S VGND VGND VPWR VPWR _0832_/Y sky130_fd_sc_hd__inv_2
XFILLER_51_3 VGND VGND VPWR VPWR sky130_fd_sc_hd__decap_3
X_1315_ _1591_/A _1598_/B VGND VGND VPWR VPWR _1315_/Y sky130_fd_sc_hd__nor2_2
X_1246_ _1313_/A _1246_/B _1246_/C _1246_/D VGND VGND VPWR VPWR _1395_/B sky130_fd_sc_hd__or4_2
X_1177_ _1177_/A _1177_/B VGND VGND VPWR VPWR _1177_/Y sky130_fd_sc_hd__nand2_2
XFILLER_12_309 VGND VGND VPWR VPWR sky130_fd_sc_hd__fill_1
XFILLER_24_147 VGND VGND VPWR VPWR sky130_fd_sc_hd__fill_2
XFILLER_24_158 VGND VGND VPWR VPWR sky130_fd_sc_hd__fill_2
XPHY_EDGE_ROW_44_Left_97 VGND VGND VPWR VPWR sky130_fd_sc_hd__decap_3
XFILLER_15_125 VGND VGND VPWR VPWR sky130_fd_sc_hd__decap_3
XFILLER_15_169 VGND VGND VPWR VPWR sky130_fd_sc_hd__fill_1
XFILLER_46_44 VGND VGND VPWR VPWR sky130_fd_sc_hd__decap_3
XFILLER_46_88 VGND VGND VPWR VPWR sky130_fd_sc_hd__decap_3
XFILLER_7_27 VGND VGND VPWR VPWR sky130_fd_sc_hd__decap_3
XFILLER_11_80 VGND VGND VPWR VPWR sky130_fd_sc_hd__decap_3
XFILLER_38_206 VGND VGND VPWR VPWR sky130_fd_sc_hd__decap_3
XFILLER_38_228 VGND VGND VPWR VPWR sky130_fd_sc_hd__fill_2
XFILLER_46_283 VGND VGND VPWR VPWR sky130_fd_sc_hd__decap_3
X_1100_ _1116_/D _1100_/B VGND VGND VPWR VPWR _1464_/A sky130_fd_sc_hd__nand2_2
X_1031_ _1389_/B _1031_/B VGND VGND VPWR VPWR _1031_/X sky130_fd_sc_hd__or2_2
Xinput30 A[7] VGND VGND VPWR VPWR input30/X sky130_fd_sc_hd__clkbuf_2
Xinput41 B[17] VGND VGND VPWR VPWR _1034_/A sky130_fd_sc_hd__clkdlybuf4s25_1
Xinput52 B[27] VGND VGND VPWR VPWR _0910_/A sky130_fd_sc_hd__clkdlybuf4s25_1
Xinput63 B[8] VGND VGND VPWR VPWR _1014_/A sky130_fd_sc_hd__clkdlybuf4s25_1
XFILLER_44_209 VGND VGND VPWR VPWR sky130_fd_sc_hd__decap_3
XFILLER_52_264 VGND VGND VPWR VPWR sky130_fd_sc_hd__decap_3
X_1229_ _1228_/X _1270_/A _1222_/X _1218_/X VGND VGND VPWR VPWR _1229_/X sky130_fd_sc_hd__a211o_4
XFILLER_20_150 VGND VGND VPWR VPWR sky130_fd_sc_hd__fill_1
XFILLER_20_172 VGND VGND VPWR VPWR sky130_fd_sc_hd__fill_1
XFILLER_32_24 VGND VGND VPWR VPWR sky130_fd_sc_hd__decap_3
XFILLER_4_305 VGND VGND VPWR VPWR sky130_fd_sc_hd__decap_3
XTAP_TAPCELL_ROW_7_154 VGND VPWR sky130_fd_sc_hd__tapvpwrvgnd_1
XFILLER_28_272 VGND VGND VPWR VPWR sky130_fd_sc_hd__fill_1
XFILLER_43_253 VGND VGND VPWR VPWR sky130_fd_sc_hd__decap_3
XFILLER_43_286 VGND VGND VPWR VPWR sky130_fd_sc_hd__decap_3
X_1580_ _1579_/C _1579_/B _1620_/B VGND VGND VPWR VPWR _1580_/X sky130_fd_sc_hd__a21o_4
XFILLER_14_3 VGND VGND VPWR VPWR sky130_fd_sc_hd__decap_3
XFILLER_19_261 VGND VGND VPWR VPWR sky130_fd_sc_hd__fill_2
XFILLER_34_231 VGND VGND VPWR VPWR sky130_fd_sc_hd__decap_3
XFILLER_34_253 VGND VGND VPWR VPWR sky130_fd_sc_hd__decap_3
X_1014_ _1014_/A _1020_/B VGND VGND VPWR VPWR _1015_/B sky130_fd_sc_hd__or2_4
Xrebuffer229 _1070_/S0 VGND VGND VPWR VPWR _1486_/S sky130_fd_sc_hd__buf_2
Xrebuffer218 _0983_/X VGND VGND VPWR VPWR _1273_/A1 sky130_fd_sc_hd__buf_6
XFILLER_1_308 VGND VGND VPWR VPWR sky130_fd_sc_hd__fill_2
XFILLER_17_209 VGND VGND VPWR VPWR sky130_fd_sc_hd__decap_3
XTAP_TAPCELL_ROW_4_135 VGND VPWR sky130_fd_sc_hd__tapvpwrvgnd_1
XFILLER_25_231 VGND VGND VPWR VPWR sky130_fd_sc_hd__decap_3
XFILLER_25_275 VGND VGND VPWR VPWR sky130_fd_sc_hd__fill_1
XFILLER_40_256 VGND VGND VPWR VPWR sky130_fd_sc_hd__decap_3
XFILLER_48_301 VGND VGND VPWR VPWR sky130_fd_sc_hd__decap_3
XPHY_EDGE_ROW_31_Left_84 VGND VGND VPWR VPWR sky130_fd_sc_hd__decap_3
XFILLER_16_242 VGND VGND VPWR VPWR sky130_fd_sc_hd__decap_3
XFILLER_16_253 VGND VGND VPWR VPWR sky130_fd_sc_hd__decap_3
XFILLER_16_275 VGND VGND VPWR VPWR sky130_fd_sc_hd__fill_2
XFILLER_17_90 VGND VGND VPWR VPWR sky130_fd_sc_hd__decap_3
XFILLER_31_201 VGND VGND VPWR VPWR sky130_fd_sc_hd__decap_3
XTAP_TAPCELL_ROW_18_215 VGND VPWR sky130_fd_sc_hd__tapvpwrvgnd_1
X_1632_ _0896_/A _0896_/B _1632_/A3 _1628_/X _1631_/X VGND VGND VPWR VPWR _1632_/X
+ sky130_fd_sc_hd__a311o_2
X_1563_ _1056_/X _1050_/X _1063_/C _0949_/Y VGND VGND VPWR VPWR _1563_/X sky130_fd_sc_hd__a211o_4
X_1494_ _0831_/Y _1490_/X _1493_/X VGND VGND VPWR VPWR _1494_/X sky130_fd_sc_hd__a21o_2
XFILLER_39_301 VGND VGND VPWR VPWR sky130_fd_sc_hd__decap_3
XTAP_TAPCELL_ROW_49_384 VGND VPWR sky130_fd_sc_hd__tapvpwrvgnd_1
XFILLER_13_15 VGND VGND VPWR VPWR sky130_fd_sc_hd__decap_3
XFILLER_22_245 VGND VGND VPWR VPWR sky130_fd_sc_hd__decap_3
XFILLER_1_127 VGND VGND VPWR VPWR sky130_fd_sc_hd__fill_2
XFILLER_38_34 VGND VGND VPWR VPWR sky130_fd_sc_hd__decap_3
XFILLER_38_67 VGND VGND VPWR VPWR sky130_fd_sc_hd__decap_3
XFILLER_9_238 VGND VGND VPWR VPWR sky130_fd_sc_hd__decap_3
XTAP_TAPCELL_ROW_23_240 VGND VPWR sky130_fd_sc_hd__tapvpwrvgnd_1
XFILLER_48_9 VGND VGND VPWR VPWR sky130_fd_sc_hd__decap_3
XFILLER_0_160 VGND VGND VPWR VPWR sky130_fd_sc_hd__fill_2
XFILLER_48_175 VGND VGND VPWR VPWR sky130_fd_sc_hd__decap_3
XTAP_TAPCELL_ROW_46_365 VGND VPWR sky130_fd_sc_hd__tapvpwrvgnd_1
XFILLER_8_271 VGND VGND VPWR VPWR sky130_fd_sc_hd__decap_3
X_0994_ _0994_/A _1025_/B VGND VGND VPWR VPWR _0995_/B sky130_fd_sc_hd__nand2_4
XFILLER_5_60 VGND VGND VPWR VPWR sky130_fd_sc_hd__fill_1
XFILLER_5_93 VGND VGND VPWR VPWR sky130_fd_sc_hd__decap_3
X_1615_ _1416_/X _1488_/X _1614_/X _1647_/A1 _1611_/X VGND VGND VPWR VPWR _1615_/X
+ sky130_fd_sc_hd__a221o_2
Xfanout206 input27/X VGND VGND VPWR VPWR _1219_/A2 sky130_fd_sc_hd__buf_6
X_1546_ _1477_/A _1056_/X _1061_/Y _0949_/Y VGND VGND VPWR VPWR _1546_/Y sky130_fd_sc_hd__a211oi_2
X_1477_ _1477_/A _1477_/B VGND VGND VPWR VPWR _1478_/B sky130_fd_sc_hd__nand2_2
XFILLER_10_215 VGND VGND VPWR VPWR sky130_fd_sc_hd__decap_3
XTAP_TAPCELL_ROW_20_221 VGND VPWR sky130_fd_sc_hd__tapvpwrvgnd_1
XFILLER_40_35 VGND VGND VPWR VPWR sky130_fd_sc_hd__fill_1
XFILLER_1_18 VGND VGND VPWR VPWR sky130_fd_sc_hd__decap_3
XFILLER_49_33 VGND VGND VPWR VPWR sky130_fd_sc_hd__decap_3
XFILLER_45_156 VGND VGND VPWR VPWR sky130_fd_sc_hd__decap_3
XFILLER_14_80 VGND VGND VPWR VPWR sky130_fd_sc_hd__decap_3
XFILLER_14_91 VGND VGND VPWR VPWR sky130_fd_sc_hd__decap_3
XFILLER_46_6 VGND VGND VPWR VPWR sky130_fd_sc_hd__decap_3
XFILLER_5_274 VGND VGND VPWR VPWR sky130_fd_sc_hd__decap_3
XFILLER_5_296 VGND VGND VPWR VPWR sky130_fd_sc_hd__decap_3
Xrebuffer390 input44/X VGND VGND VPWR VPWR _1116_/C sky130_fd_sc_hd__buf_2
X_1400_ _1374_/A _1391_/X _1399_/X VGND VGND VPWR VPWR _1400_/X sky130_fd_sc_hd__a21o_2
X_1331_ _1004_/A _1018_/B _1330_/X VGND VGND VPWR VPWR _1331_/Y sky130_fd_sc_hd__a21oi_2
XFILLER_36_156 VGND VGND VPWR VPWR sky130_fd_sc_hd__decap_3
XFILLER_36_167 VGND VGND VPWR VPWR sky130_fd_sc_hd__decap_3
Xinput6 A[14] VGND VGND VPWR VPWR input6/X sky130_fd_sc_hd__dlymetal6s4s_1
X_1262_ _1659_/A _1015_/A _1288_/B _1133_/A VGND VGND VPWR VPWR _1262_/Y sky130_fd_sc_hd__o22ai_2
X_1193_ _1193_/A _1193_/B VGND VGND VPWR VPWR _1193_/X sky130_fd_sc_hd__or2_2
XTAP_TAPCELL_ROW_34_302 VGND VPWR sky130_fd_sc_hd__tapvpwrvgnd_1
XFILLER_10_27 VGND VGND VPWR VPWR sky130_fd_sc_hd__fill_1
XFILLER_10_38 VGND VGND VPWR VPWR sky130_fd_sc_hd__fill_1
XFILLER_10_49 VGND VGND VPWR VPWR sky130_fd_sc_hd__decap_3
X_0977_ _0978_/A _1238_/B VGND VGND VPWR VPWR _0983_/B sky130_fd_sc_hd__and2_2
XFILLER_19_69 VGND VGND VPWR VPWR sky130_fd_sc_hd__decap_3
X_1529_ _1656_/A _1533_/C _1519_/Y _1528_/X VGND VGND VPWR VPWR _1529_/X sky130_fd_sc_hd__a31o_2
XFILLER_27_145 VGND VGND VPWR VPWR sky130_fd_sc_hd__decap_3
XFILLER_27_189 VGND VGND VPWR VPWR sky130_fd_sc_hd__decap_3
XFILLER_35_46 VGND VGND VPWR VPWR sky130_fd_sc_hd__decap_3
XFILLER_35_57 VGND VGND VPWR VPWR sky130_fd_sc_hd__fill_1
XFILLER_42_137 VGND VGND VPWR VPWR sky130_fd_sc_hd__decap_3
XFILLER_51_12 VGND VGND VPWR VPWR sky130_fd_sc_hd__decap_3
XFILLER_51_45 VGND VGND VPWR VPWR sky130_fd_sc_hd__decap_3
XFILLER_51_89 VGND VGND VPWR VPWR sky130_fd_sc_hd__decap_3
XPHY_EDGE_ROW_14_Right_14 VGND VGND VPWR VPWR sky130_fd_sc_hd__decap_3
XFILLER_2_200 VGND VGND VPWR VPWR sky130_fd_sc_hd__decap_3
XFILLER_2_277 VGND VGND VPWR VPWR sky130_fd_sc_hd__decap_3
XPHY_EDGE_ROW_23_Right_23 VGND VGND VPWR VPWR sky130_fd_sc_hd__decap_3
XFILLER_33_126 VGND VGND VPWR VPWR sky130_fd_sc_hd__decap_3
XFILLER_33_137 VGND VGND VPWR VPWR sky130_fd_sc_hd__decap_3
X_0900_ _0896_/A _0825_/Y _0899_/X VGND VGND VPWR VPWR _0900_/X sky130_fd_sc_hd__o21a_2
XPHY_EDGE_ROW_32_Right_32 VGND VGND VPWR VPWR sky130_fd_sc_hd__decap_3
X_0831_ _1598_/A VGND VGND VPWR VPWR _0831_/Y sky130_fd_sc_hd__inv_2
XFILLER_2_50 VGND VGND VPWR VPWR sky130_fd_sc_hd__decap_3
X_1314_ _1148_/X _1275_/X _1313_/X _1244_/X VGND VGND VPWR VPWR _1598_/B sky130_fd_sc_hd__a211oi_2
XPHY_EDGE_ROW_41_Right_41 VGND VGND VPWR VPWR sky130_fd_sc_hd__decap_3
XFILLER_24_115 VGND VGND VPWR VPWR sky130_fd_sc_hd__decap_3
XFILLER_24_137 VGND VGND VPWR VPWR sky130_fd_sc_hd__decap_3
XFILLER_2_83 VGND VGND VPWR VPWR sky130_fd_sc_hd__fill_1
XFILLER_49_281 VGND VGND VPWR VPWR sky130_fd_sc_hd__decap_3
X_1245_ _1392_/A _1416_/B _1392_/C VGND VGND VPWR VPWR _1247_/A sky130_fd_sc_hd__nand3_2
X_1176_ _1177_/B VGND VGND VPWR VPWR _1176_/Y sky130_fd_sc_hd__inv_2
XPHY_EDGE_ROW_50_Right_50 VGND VGND VPWR VPWR sky130_fd_sc_hd__decap_3
XFILLER_46_12 VGND VGND VPWR VPWR sky130_fd_sc_hd__decap_3
XFILLER_46_67 VGND VGND VPWR VPWR sky130_fd_sc_hd__fill_1
XFILLER_15_104 VGND VGND VPWR VPWR sky130_fd_sc_hd__decap_3
XFILLER_30_129 VGND VGND VPWR VPWR sky130_fd_sc_hd__fill_1
XFILLER_7_39 VGND VGND VPWR VPWR sky130_fd_sc_hd__fill_1
XFILLER_11_92 VGND VGND VPWR VPWR sky130_fd_sc_hd__decap_3
XFILLER_46_251 VGND VGND VPWR VPWR sky130_fd_sc_hd__fill_1
XFILLER_46_262 VGND VGND VPWR VPWR sky130_fd_sc_hd__decap_3
XFILLER_46_295 VGND VGND VPWR VPWR sky130_fd_sc_hd__decap_3
X_1030_ _1406_/A _1028_/X _1029_/X VGND VGND VPWR VPWR _1031_/B sky130_fd_sc_hd__a21oi_2
XFILLER_21_107 VGND VGND VPWR VPWR sky130_fd_sc_hd__decap_3
XFILLER_21_129 VGND VGND VPWR VPWR sky130_fd_sc_hd__decap_3
Xinput20 A[27] VGND VGND VPWR VPWR _0910_/B sky130_fd_sc_hd__clkdlybuf4s25_1
Xinput31 A[8] VGND VGND VPWR VPWR input31/X sky130_fd_sc_hd__dlygate4sd1_1
Xinput42 B[18] VGND VGND VPWR VPWR _1042_/A sky130_fd_sc_hd__clkdlybuf4s25_1
Xinput53 B[28] VGND VGND VPWR VPWR _0905_/A sky130_fd_sc_hd__clkdlybuf4s25_1
Xinput64 B[9] VGND VGND VPWR VPWR _1010_/A sky130_fd_sc_hd__clkdlybuf4s25_1
X_1228_ _1225_/X _1392_/C _1227_/X _1080_/Y VGND VGND VPWR VPWR _1228_/X sky130_fd_sc_hd__a22o_4
XFILLER_12_118 VGND VGND VPWR VPWR sky130_fd_sc_hd__decap_3
XFILLER_16_26 VGND VGND VPWR VPWR sky130_fd_sc_hd__fill_2
XFILLER_16_59 VGND VGND VPWR VPWR sky130_fd_sc_hd__decap_3
XFILLER_52_287 VGND VGND VPWR VPWR sky130_fd_sc_hd__decap_3
X_1159_ _1157_/X _1158_/X _1281_/S VGND VGND VPWR VPWR _1159_/X sky130_fd_sc_hd__mux2_2
XFILLER_32_47 VGND VGND VPWR VPWR sky130_fd_sc_hd__decap_3
XFILLER_43_210 VGND VGND VPWR VPWR sky130_fd_sc_hd__decap_3
XFILLER_43_265 VGND VGND VPWR VPWR sky130_fd_sc_hd__fill_1
XFILLER_43_298 VGND VGND VPWR VPWR sky130_fd_sc_hd__decap_3
XFILLER_7_111 VGND VGND VPWR VPWR sky130_fd_sc_hd__fill_1
XFILLER_22_80 VGND VGND VPWR VPWR sky130_fd_sc_hd__decap_3
XFILLER_7_144 VGND VGND VPWR VPWR sky130_fd_sc_hd__decap_3
XFILLER_34_287 VGND VGND VPWR VPWR sky130_fd_sc_hd__decap_3
X_1013_ _1014_/A _1020_/B VGND VGND VPWR VPWR _1015_/A sky130_fd_sc_hd__nand2_4
XFILLER_8_82 VGND VGND VPWR VPWR sky130_fd_sc_hd__fill_2
Xrebuffer219 _1538_/S VGND VGND VPWR VPWR _1586_/S sky130_fd_sc_hd__buf_4
XPHY_EDGE_ROW_4_Right_4 VGND VGND VPWR VPWR sky130_fd_sc_hd__decap_3
XTAP_TAPCELL_ROW_4_136 VGND VPWR sky130_fd_sc_hd__tapvpwrvgnd_1
XFILLER_25_243 VGND VGND VPWR VPWR sky130_fd_sc_hd__decap_3
XFILLER_25_265 VGND VGND VPWR VPWR sky130_fd_sc_hd__decap_3
XFILLER_40_235 VGND VGND VPWR VPWR sky130_fd_sc_hd__decap_3
XFILLER_40_268 VGND VGND VPWR VPWR sky130_fd_sc_hd__decap_3
XFILLER_43_24 VGND VGND VPWR VPWR sky130_fd_sc_hd__decap_3
XFILLER_43_46 VGND VGND VPWR VPWR sky130_fd_sc_hd__decap_3
XFILLER_4_114 VGND VGND VPWR VPWR sky130_fd_sc_hd__decap_3
XFILLER_4_125 VGND VGND VPWR VPWR sky130_fd_sc_hd__fill_1
XFILLER_4_18 VGND VGND VPWR VPWR sky130_fd_sc_hd__decap_3
XFILLER_4_29 VGND VGND VPWR VPWR sky130_fd_sc_hd__decap_3
XFILLER_16_210 VGND VGND VPWR VPWR sky130_fd_sc_hd__decap_3
XFILLER_16_265 VGND VGND VPWR VPWR sky130_fd_sc_hd__decap_3
X_1631_ _1631_/A1 _1568_/X _1630_/X VGND VGND VPWR VPWR _1631_/X sky130_fd_sc_hd__o21a_2
X_1562_ _1546_/Y _1547_/Y _1561_/X VGND VGND VPWR VPWR _1676_/A sky130_fd_sc_hd__o21ai_2
X_1493_ _1183_/X _1418_/X _1491_/X _1492_/X VGND VGND VPWR VPWR _1493_/X sky130_fd_sc_hd__a211o_2
XTAP_TAPCELL_ROW_49_385 VGND VPWR sky130_fd_sc_hd__tapvpwrvgnd_1
XTAP_TAPCELL_ROW_1_117 VGND VPWR sky130_fd_sc_hd__tapvpwrvgnd_1
XFILLER_13_27 VGND VGND VPWR VPWR sky130_fd_sc_hd__decap_3
XFILLER_22_224 VGND VGND VPWR VPWR sky130_fd_sc_hd__decap_3
XFILLER_38_46 VGND VGND VPWR VPWR sky130_fd_sc_hd__decap_3
XFILLER_38_79 VGND VGND VPWR VPWR sky130_fd_sc_hd__decap_3
XFILLER_8_9 VGND VGND VPWR VPWR sky130_fd_sc_hd__decap_3
XFILLER_45_305 VGND VGND VPWR VPWR sky130_fd_sc_hd__decap_3
XFILLER_13_246 VGND VGND VPWR VPWR sky130_fd_sc_hd__decap_3
XTAP_TAPCELL_ROW_23_241 VGND VPWR sky130_fd_sc_hd__tapvpwrvgnd_1
XFILLER_51_308 VGND VGND VPWR VPWR sky130_fd_sc_hd__fill_2
X_0993_ _1025_/B _0994_/A VGND VGND VPWR VPWR _0995_/A sky130_fd_sc_hd__or2_4
XTAP_TAPCELL_ROW_46_366 VGND VPWR sky130_fd_sc_hd__tapvpwrvgnd_1
X_1614_ _1631_/A1 _1557_/X _1613_/X _1246_/C _1612_/X VGND VGND VPWR VPWR _1614_/X
+ sky130_fd_sc_hd__o221a_2
X_1545_ _1637_/A2 _1532_/Y _1542_/X _1544_/X VGND VGND VPWR VPWR _1681_/A sky130_fd_sc_hd__a211o_4
X_1476_ _1475_/X _1476_/B _1476_/C VGND VGND VPWR VPWR _1680_/A sky130_fd_sc_hd__nand3b_4
XFILLER_39_187 VGND VGND VPWR VPWR sky130_fd_sc_hd__fill_2
XFILLER_10_249 VGND VGND VPWR VPWR sky130_fd_sc_hd__decap_3
XFILLER_24_59 VGND VGND VPWR VPWR sky130_fd_sc_hd__decap_3
XTAP_TAPCELL_ROW_20_222 VGND VPWR sky130_fd_sc_hd__tapvpwrvgnd_1
XFILLER_40_47 VGND VGND VPWR VPWR sky130_fd_sc_hd__decap_3
XFILLER_49_12 VGND VGND VPWR VPWR sky130_fd_sc_hd__decap_3
XFILLER_6_6 VGND VGND VPWR VPWR sky130_fd_sc_hd__decap_3
XFILLER_45_102 VGND VGND VPWR VPWR sky130_fd_sc_hd__decap_3
XFILLER_49_78 VGND VGND VPWR VPWR sky130_fd_sc_hd__fill_1
XFILLER_33_308 VGND VGND VPWR VPWR sky130_fd_sc_hd__fill_2
Xrebuffer391 rebuffer392/X VGND VGND VPWR VPWR rebuffer391/X sky130_fd_sc_hd__buf_6
Xrebuffer380 rebuffer384/X VGND VGND VPWR VPWR _1579_/C sky130_fd_sc_hd__buf_6
X_1330_ _1004_/A _1018_/B _1006_/A _1006_/B VGND VGND VPWR VPWR _1330_/X sky130_fd_sc_hd__o211a_2
X_1261_ _1261_/A _1275_/C _1261_/C VGND VGND VPWR VPWR _1261_/X sky130_fd_sc_hd__and3_4
XFILLER_36_124 VGND VGND VPWR VPWR sky130_fd_sc_hd__decap_3
Xinput7 A[15] VGND VGND VPWR VPWR input7/X sky130_fd_sc_hd__clkdlybuf4s25_1
X_1192_ _1192_/A _1192_/B VGND VGND VPWR VPWR _1192_/Y sky130_fd_sc_hd__xnor2_2
XTAP_TAPCELL_ROW_34_303 VGND VPWR sky130_fd_sc_hd__tapvpwrvgnd_1
X_0976_ _0976_/A _0976_/B VGND VGND VPWR VPWR _1238_/B sky130_fd_sc_hd__nand2_4
XFILLER_19_48 VGND VGND VPWR VPWR sky130_fd_sc_hd__decap_3
XFILLER_27_102 VGND VGND VPWR VPWR sky130_fd_sc_hd__decap_3
XFILLER_27_113 VGND VGND VPWR VPWR sky130_fd_sc_hd__decap_3
X_1528_ _1591_/A _1527_/X _1522_/X VGND VGND VPWR VPWR _1528_/X sky130_fd_sc_hd__a21o_2
X_1459_ _1418_/C _1458_/X _1121_/X VGND VGND VPWR VPWR _1459_/X sky130_fd_sc_hd__a21o_2
XFILLER_42_116 VGND VGND VPWR VPWR sky130_fd_sc_hd__decap_3
XFILLER_51_24 VGND VGND VPWR VPWR sky130_fd_sc_hd__decap_3
XFILLER_2_256 VGND VGND VPWR VPWR sky130_fd_sc_hd__decap_3
XFILLER_2_289 VGND VGND VPWR VPWR sky130_fd_sc_hd__decap_3
XFILLER_4_3 VGND VGND VPWR VPWR sky130_fd_sc_hd__decap_3
XFILLER_18_157 VGND VGND VPWR VPWR sky130_fd_sc_hd__decap_3
XFILLER_33_105 VGND VGND VPWR VPWR sky130_fd_sc_hd__decap_3
XFILLER_33_116 VGND VGND VPWR VPWR sky130_fd_sc_hd__fill_1
XFILLER_33_149 VGND VGND VPWR VPWR sky130_fd_sc_hd__decap_3
XFILLER_41_193 VGND VGND VPWR VPWR sky130_fd_sc_hd__decap_3
X_0830_ _1006_/A VGND VGND VPWR VPWR _0830_/Y sky130_fd_sc_hd__inv_2
XFILLER_37_3 VGND VGND VPWR VPWR sky130_fd_sc_hd__decap_3
XFILLER_49_260 VGND VGND VPWR VPWR sky130_fd_sc_hd__decap_3
XFILLER_49_293 VGND VGND VPWR VPWR sky130_fd_sc_hd__decap_3
X_1313_ _1313_/A _1313_/B _1313_/C VGND VGND VPWR VPWR _1313_/X sky130_fd_sc_hd__and3_2
X_1244_ _1392_/A _1416_/B _1392_/C VGND VGND VPWR VPWR _1244_/X sky130_fd_sc_hd__and3_2
X_1175_ _1175_/A _1175_/B VGND VGND VPWR VPWR _1177_/B sky130_fd_sc_hd__nand2_2
XFILLER_21_49 VGND VGND VPWR VPWR sky130_fd_sc_hd__decap_3
XFILLER_32_193 VGND VGND VPWR VPWR sky130_fd_sc_hd__decap_3
X_0959_ input1/X _0959_/B VGND VGND VPWR VPWR _1101_/B sky130_fd_sc_hd__nand2b_2
XFILLER_46_24 VGND VGND VPWR VPWR sky130_fd_sc_hd__decap_3
XFILLER_46_35 VGND VGND VPWR VPWR sky130_fd_sc_hd__decap_3
XFILLER_7_18 VGND VGND VPWR VPWR sky130_fd_sc_hd__decap_3
XFILLER_11_60 VGND VGND VPWR VPWR sky130_fd_sc_hd__fill_2
XFILLER_46_274 VGND VGND VPWR VPWR sky130_fd_sc_hd__decap_3
Xinput10 A[18] VGND VGND VPWR VPWR _1052_/B sky130_fd_sc_hd__clkdlybuf4s25_1
Xinput21 A[28] VGND VGND VPWR VPWR _0905_/B sky130_fd_sc_hd__clkdlybuf4s25_1
Xinput32 A[9] VGND VGND VPWR VPWR input32/X sky130_fd_sc_hd__clkdlybuf4s25_1
Xinput43 B[19] VGND VGND VPWR VPWR _1046_/A sky130_fd_sc_hd__clkdlybuf4s25_1
Xinput54 B[29] VGND VGND VPWR VPWR _0896_/A sky130_fd_sc_hd__clkdlybuf4s25_1
XTAP_TAPCELL_ROW_16_199 VGND VPWR sky130_fd_sc_hd__tapvpwrvgnd_1
Xinput65 control[0] VGND VGND VPWR VPWR _1116_/D sky130_fd_sc_hd__clkdlybuf4s25_1
XFILLER_37_274 VGND VGND VPWR VPWR sky130_fd_sc_hd__decap_3
X_1227_ _1275_/A _1223_/X _1226_/X VGND VGND VPWR VPWR _1227_/X sky130_fd_sc_hd__a21o_2
X_1158_ _1018_/B _1358_/A1 _1358_/A0 input6/X _1158_/S0 _1432_/S1 VGND VGND VPWR VPWR
+ _1158_/X sky130_fd_sc_hd__mux4_2
XFILLER_20_141 VGND VGND VPWR VPWR sky130_fd_sc_hd__decap_3
XFILLER_37_296 VGND VGND VPWR VPWR sky130_fd_sc_hd__decap_3
XFILLER_52_299 VGND VGND VPWR VPWR sky130_fd_sc_hd__decap_3
X_1089_ _1087_/X _1088_/X _1281_/S VGND VGND VPWR VPWR _1089_/X sky130_fd_sc_hd__mux2_4
XFILLER_32_59 VGND VGND VPWR VPWR sky130_fd_sc_hd__decap_3
XFILLER_43_222 VGND VGND VPWR VPWR sky130_fd_sc_hd__fill_2
XFILLER_43_233 VGND VGND VPWR VPWR sky130_fd_sc_hd__decap_3
XFILLER_11_163 VGND VGND VPWR VPWR sky130_fd_sc_hd__decap_3
XFILLER_7_167 VGND VGND VPWR VPWR sky130_fd_sc_hd__fill_1
XFILLER_19_252 VGND VGND VPWR VPWR sky130_fd_sc_hd__decap_3
XFILLER_34_200 VGND VGND VPWR VPWR sky130_fd_sc_hd__decap_3
X_1012_ _1012_/A _1012_/B VGND VGND VPWR VPWR _1288_/A sky130_fd_sc_hd__nand2_2
XFILLER_34_299 VGND VGND VPWR VPWR sky130_fd_sc_hd__decap_3
XFILLER_8_94 VGND VGND VPWR VPWR sky130_fd_sc_hd__decap_3
XTAP_TAPCELL_ROW_12_180 VGND VPWR sky130_fd_sc_hd__tapvpwrvgnd_1
XTAP_TAPCELL_ROW_4_137 VGND VPWR sky130_fd_sc_hd__tapvpwrvgnd_1
XFILLER_27_37 VGND VGND VPWR VPWR sky130_fd_sc_hd__decap_3
XFILLER_40_203 VGND VGND VPWR VPWR sky130_fd_sc_hd__decap_3
XFILLER_43_69 VGND VGND VPWR VPWR sky130_fd_sc_hd__fill_1
XFILLER_16_200 VGND VGND VPWR VPWR sky130_fd_sc_hd__fill_2
X_1630_ _1612_/A _1599_/X _1629_/X _1246_/C _1647_/A1 VGND VGND VPWR VPWR _1630_/X
+ sky130_fd_sc_hd__o221a_2
X_1561_ _1561_/A1 _1552_/X _1553_/Y _1560_/Y VGND VGND VPWR VPWR _1561_/X sky130_fd_sc_hd__o31a_4
X_1492_ _0931_/A _0943_/B _1585_/A3 _1537_/A VGND VGND VPWR VPWR _1492_/X sky130_fd_sc_hd__a31o_2
XTAP_TAPCELL_ROW_1_118 VGND VPWR sky130_fd_sc_hd__tapvpwrvgnd_1
XFILLER_38_58 VGND VGND VPWR VPWR sky130_fd_sc_hd__decap_3
XTAP_TAPCELL_ROW_23_242 VGND VPWR sky130_fd_sc_hd__tapvpwrvgnd_1
XFILLER_28_80 VGND VGND VPWR VPWR sky130_fd_sc_hd__decap_3
XFILLER_28_91 VGND VGND VPWR VPWR sky130_fd_sc_hd__decap_3
XFILLER_36_306 VGND VGND VPWR VPWR sky130_fd_sc_hd__fill_2
X_0992_ _0992_/A _0992_/B VGND VGND VPWR VPWR _1026_/A sky130_fd_sc_hd__xnor2_4
XTAP_TAPCELL_ROW_46_367 VGND VPWR sky130_fd_sc_hd__tapvpwrvgnd_1
XFILLER_8_251 VGND VGND VPWR VPWR sky130_fd_sc_hd__fill_1
XFILLER_8_262 VGND VGND VPWR VPWR sky130_fd_sc_hd__fill_2
X_1613_ _0905_/B _0910_/B _1644_/S VGND VGND VPWR VPWR _1613_/X sky130_fd_sc_hd__mux2_1
X_1544_ _1656_/A _1533_/Y _1534_/X _1543_/X VGND VGND VPWR VPWR _1544_/X sky130_fd_sc_hd__a31o_2
XFILLER_39_100 VGND VGND VPWR VPWR sky130_fd_sc_hd__fill_2
XFILLER_39_111 VGND VGND VPWR VPWR sky130_fd_sc_hd__fill_1
XFILLER_39_155 VGND VGND VPWR VPWR sky130_fd_sc_hd__decap_3
Xfanout208 input25/X VGND VGND VPWR VPWR _1392_/A sky130_fd_sc_hd__dlymetal6s2s_1
X_1475_ _1537_/A _1475_/B _1468_/X VGND VGND VPWR VPWR _1475_/X sky130_fd_sc_hd__or3b_4
XFILLER_24_27 VGND VGND VPWR VPWR sky130_fd_sc_hd__fill_1
XFILLER_42_309 VGND VGND VPWR VPWR sky130_fd_sc_hd__fill_1
XFILLER_10_206 VGND VGND VPWR VPWR sky130_fd_sc_hd__decap_3
XTAP_TAPCELL_ROW_20_223 VGND VPWR sky130_fd_sc_hd__tapvpwrvgnd_1
XFILLER_49_24 VGND VGND VPWR VPWR sky130_fd_sc_hd__decap_3
XFILLER_49_57 VGND VGND VPWR VPWR sky130_fd_sc_hd__decap_3
XFILLER_45_147 VGND VGND VPWR VPWR sky130_fd_sc_hd__decap_3
XTAP_TAPCELL_ROW_43_348 VGND VPWR sky130_fd_sc_hd__tapvpwrvgnd_1
XFILLER_30_70 VGND VGND VPWR VPWR sky130_fd_sc_hd__decap_3
XFILLER_5_265 VGND VGND VPWR VPWR sky130_fd_sc_hd__decap_3
XFILLER_5_287 VGND VGND VPWR VPWR sky130_fd_sc_hd__decap_3
Xrebuffer392 rebuffer393/X VGND VGND VPWR VPWR rebuffer392/X sky130_fd_sc_hd__buf_6
Xrebuffer381 _1017_/X VGND VGND VPWR VPWR _1404_/A sky130_fd_sc_hd__buf_6
XTAP_TAPCELL_ROW_51_392 VGND VPWR sky130_fd_sc_hd__tapvpwrvgnd_1
Xinput8 A[16] VGND VGND VPWR VPWR input8/X sky130_fd_sc_hd__clkdlybuf4s25_1
X_1260_ _1275_/A _0844_/X _1244_/X VGND VGND VPWR VPWR _1261_/C sky130_fd_sc_hd__a21o_2
X_1191_ _1191_/A _1191_/B VGND VGND VPWR VPWR _1192_/B sky130_fd_sc_hd__nand2_2
XFILLER_24_309 VGND VGND VPWR VPWR sky130_fd_sc_hd__fill_1
XFILLER_36_147 VGND VGND VPWR VPWR sky130_fd_sc_hd__decap_3
XFILLER_51_106 VGND VGND VPWR VPWR sky130_fd_sc_hd__fill_2
X_0975_ _0976_/A _0984_/B VGND VGND VPWR VPWR _0978_/A sky130_fd_sc_hd__or2_4
XFILLER_10_18 VGND VGND VPWR VPWR sky130_fd_sc_hd__decap_3
XFILLER_10_29 VGND VGND VPWR VPWR sky130_fd_sc_hd__decap_3
X_1527_ _1418_/C _1526_/X _1527_/B1 VGND VGND VPWR VPWR _1527_/X sky130_fd_sc_hd__a21o_2
XFILLER_27_136 VGND VGND VPWR VPWR sky130_fd_sc_hd__decap_3
X_1458_ _1300_/X _1457_/X _1472_/A VGND VGND VPWR VPWR _1458_/X sky130_fd_sc_hd__mux2_1
X_1389_ _1408_/A _1389_/B _1389_/C VGND VGND VPWR VPWR _1389_/X sky130_fd_sc_hd__or3_2
XFILLER_27_169 VGND VGND VPWR VPWR sky130_fd_sc_hd__fill_2
XFILLER_35_37 VGND VGND VPWR VPWR sky130_fd_sc_hd__decap_3
XFILLER_42_106 VGND VGND VPWR VPWR sky130_fd_sc_hd__fill_1
XFILLER_50_183 VGND VGND VPWR VPWR sky130_fd_sc_hd__decap_3
XFILLER_51_36 VGND VGND VPWR VPWR sky130_fd_sc_hd__decap_3
XFILLER_2_224 VGND VGND VPWR VPWR sky130_fd_sc_hd__fill_1
XFILLER_2_268 VGND VGND VPWR VPWR sky130_fd_sc_hd__decap_3
XFILLER_18_169 VGND VGND VPWR VPWR sky130_fd_sc_hd__decap_3
XFILLER_41_172 VGND VGND VPWR VPWR sky130_fd_sc_hd__decap_3
XFILLER_51_6 VGND VGND VPWR VPWR sky130_fd_sc_hd__decap_3
XFILLER_1_290 VGND VGND VPWR VPWR sky130_fd_sc_hd__decap_3
XFILLER_2_41 VGND VGND VPWR VPWR sky130_fd_sc_hd__decap_3
XFILLER_49_272 VGND VGND VPWR VPWR sky130_fd_sc_hd__decap_3
X_1312_ _1312_/A _1312_/B VGND VGND VPWR VPWR _1312_/Y sky130_fd_sc_hd__nor2_2
X_1243_ _1142_/X _1145_/X _1243_/S VGND VGND VPWR VPWR _1243_/X sky130_fd_sc_hd__mux2_2
X_1174_ _0838_/X _0843_/X _1193_/A VGND VGND VPWR VPWR _1174_/X sky130_fd_sc_hd__mux2_4
XFILLER_17_191 VGND VGND VPWR VPWR sky130_fd_sc_hd__decap_3
XFILLER_24_128 VGND VGND VPWR VPWR sky130_fd_sc_hd__decap_3
X_0958_ _0958_/A _0958_/B VGND VGND VPWR VPWR _0958_/Y sky130_fd_sc_hd__xnor2_4
X_0889_ _0891_/A _0891_/B VGND VGND VPWR VPWR _1657_/B sky130_fd_sc_hd__nand2b_2
XFILLER_15_128 VGND VGND VPWR VPWR sky130_fd_sc_hd__decap_3
XFILLER_46_47 VGND VGND VPWR VPWR sky130_fd_sc_hd__fill_2
XPHY_EDGE_ROW_6_Left_59 VGND VGND VPWR VPWR sky130_fd_sc_hd__decap_3
XFILLER_11_83 VGND VGND VPWR VPWR sky130_fd_sc_hd__decap_3
XFILLER_46_220 VGND VGND VPWR VPWR sky130_fd_sc_hd__fill_1
XFILLER_46_231 VGND VGND VPWR VPWR sky130_fd_sc_hd__decap_3
XFILLER_46_253 VGND VGND VPWR VPWR sky130_fd_sc_hd__decap_3
XFILLER_46_286 VGND VGND VPWR VPWR sky130_fd_sc_hd__decap_3
XFILLER_14_194 VGND VGND VPWR VPWR sky130_fd_sc_hd__fill_2
Xinput11 A[19] VGND VGND VPWR VPWR _1051_/B sky130_fd_sc_hd__clkdlybuf4s25_1
Xinput22 A[29] VGND VGND VPWR VPWR _0896_/B sky130_fd_sc_hd__clkdlybuf4s25_1
Xinput33 B[0] VGND VGND VPWR VPWR input33/X sky130_fd_sc_hd__buf_8
Xinput44 B[1] VGND VGND VPWR VPWR input44/X sky130_fd_sc_hd__buf_8
Xinput55 B[2] VGND VGND VPWR VPWR input55/X sky130_fd_sc_hd__clkbuf_2
Xinput66 control[1] VGND VGND VPWR VPWR _0874_/C sky130_fd_sc_hd__clkdlybuf4s25_1
XFILLER_37_220 VGND VGND VPWR VPWR sky130_fd_sc_hd__decap_3
XFILLER_52_223 VGND VGND VPWR VPWR sky130_fd_sc_hd__fill_1
X_1226_ _1379_/A _1226_/B _1226_/C VGND VGND VPWR VPWR _1226_/X sky130_fd_sc_hd__and3_2
X_1157_ input7/X _1053_/B _1034_/B _1052_/B _1158_/S0 _1432_/S1 VGND VGND VPWR VPWR
+ _1157_/X sky130_fd_sc_hd__mux4_2
XFILLER_20_131 VGND VGND VPWR VPWR sky130_fd_sc_hd__decap_3
XFILLER_32_27 VGND VGND VPWR VPWR sky130_fd_sc_hd__fill_1
XFILLER_32_38 VGND VGND VPWR VPWR sky130_fd_sc_hd__decap_3
XFILLER_52_245 VGND VGND VPWR VPWR sky130_fd_sc_hd__decap_3
XFILLER_52_267 VGND VGND VPWR VPWR sky130_fd_sc_hd__decap_3
X_1088_ _1019_/B _1006_/B _1018_/B _1358_/A1 _1455_/S _1432_/S1 VGND VGND VPWR VPWR
+ _1088_/X sky130_fd_sc_hd__mux4_2
XFILLER_20_197 VGND VGND VPWR VPWR sky130_fd_sc_hd__decap_3
XFILLER_43_289 VGND VGND VPWR VPWR sky130_fd_sc_hd__decap_3
XFILLER_7_102 VGND VGND VPWR VPWR sky130_fd_sc_hd__decap_3
XFILLER_14_6 VGND VGND VPWR VPWR sky130_fd_sc_hd__fill_1
XFILLER_34_212 VGND VGND VPWR VPWR sky130_fd_sc_hd__decap_3
XFILLER_34_234 VGND VGND VPWR VPWR sky130_fd_sc_hd__fill_2
X_1011_ _1012_/A _1012_/B VGND VGND VPWR VPWR _1272_/A sky130_fd_sc_hd__and2_2
XTAP_TAPCELL_ROW_12_181 VGND VPWR sky130_fd_sc_hd__tapvpwrvgnd_1
XTAP_TAPCELL_ROW_4_138 VGND VPWR sky130_fd_sc_hd__tapvpwrvgnd_1
XFILLER_25_234 VGND VGND VPWR VPWR sky130_fd_sc_hd__decap_3
XFILLER_40_226 VGND VGND VPWR VPWR sky130_fd_sc_hd__decap_3
X_1209_ _1513_/A1 _1192_/Y _1208_/Y _1351_/B VGND VGND VPWR VPWR _1210_/C sky130_fd_sc_hd__a22o_2
XFILLER_40_259 VGND VGND VPWR VPWR sky130_fd_sc_hd__decap_3
XFILLER_48_304 VGND VGND VPWR VPWR sky130_fd_sc_hd__decap_3
XFILLER_16_256 VGND VGND VPWR VPWR sky130_fd_sc_hd__decap_3
XFILLER_17_60 VGND VGND VPWR VPWR sky130_fd_sc_hd__decap_3
XFILLER_31_204 VGND VGND VPWR VPWR sky130_fd_sc_hd__decap_3
XPHY_EDGE_ROW_9_Left_62 VGND VGND VPWR VPWR sky130_fd_sc_hd__decap_3
X_1560_ _1560_/A1 _1261_/C _1267_/X _1598_/A _1559_/X VGND VGND VPWR VPWR _1560_/Y
+ sky130_fd_sc_hd__a221oi_2
XFILLER_12_3 VGND VGND VPWR VPWR sky130_fd_sc_hd__decap_3
XFILLER_39_304 VGND VGND VPWR VPWR sky130_fd_sc_hd__decap_3
X_1491_ _1535_/A _1509_/B _0932_/A _1643_/A1 VGND VGND VPWR VPWR _1491_/X sky130_fd_sc_hd__a2bb2o_2
XTAP_TAPCELL_ROW_1_119 VGND VPWR sky130_fd_sc_hd__tapvpwrvgnd_1
XFILLER_13_18 VGND VGND VPWR VPWR sky130_fd_sc_hd__decap_3
XFILLER_22_248 VGND VGND VPWR VPWR sky130_fd_sc_hd__decap_3
XTAP_TAPCELL_ROW_32_287 VGND VPWR sky130_fd_sc_hd__tapvpwrvgnd_1
Xmax_cap130 _1208_/A VGND VGND VPWR VPWR _1254_/A sky130_fd_sc_hd__buf_6
XFILLER_38_15 VGND VGND VPWR VPWR sky130_fd_sc_hd__decap_3
XFILLER_38_37 VGND VGND VPWR VPWR sky130_fd_sc_hd__decap_3
XFILLER_13_215 VGND VGND VPWR VPWR sky130_fd_sc_hd__decap_3
XPHY_EDGE_ROW_35_Left_88 VGND VGND VPWR VPWR sky130_fd_sc_hd__decap_3
Xrebuffer530 _1158_/S0 VGND VGND VPWR VPWR _1337_/S sky130_fd_sc_hd__buf_2
XFILLER_48_112 VGND VGND VPWR VPWR sky130_fd_sc_hd__fill_2
XFILLER_48_178 VGND VGND VPWR VPWR sky130_fd_sc_hd__decap_3
XTAP_TAPCELL_ROW_46_368 VGND VPWR sky130_fd_sc_hd__tapvpwrvgnd_1
XFILLER_8_241 VGND VGND VPWR VPWR sky130_fd_sc_hd__decap_3
X_0991_ _0992_/A _1027_/B VGND VGND VPWR VPWR _0991_/Y sky130_fd_sc_hd__nand2_2
XFILLER_5_30 VGND VGND VPWR VPWR sky130_fd_sc_hd__decap_3
XFILLER_5_96 VGND VGND VPWR VPWR sky130_fd_sc_hd__decap_3
XFILLER_8_274 VGND VGND VPWR VPWR sky130_fd_sc_hd__decap_3
X_1612_ _1612_/A _1612_/B VGND VGND VPWR VPWR _1612_/X sky130_fd_sc_hd__or2_2
Xfanout209 input25/X VGND VGND VPWR VPWR _1116_/A sky130_fd_sc_hd__clkdlybuf4s25_1
X_1543_ _1416_/B _1243_/X _1247_/Y _1313_/B _1591_/A VGND VGND VPWR VPWR _1543_/X
+ sky130_fd_sc_hd__o221a_2
X_1474_ _1150_/X _1473_/X _0831_/Y VGND VGND VPWR VPWR _1475_/B sky130_fd_sc_hd__o21a_4
XFILLER_10_218 VGND VGND VPWR VPWR sky130_fd_sc_hd__decap_3
XTAP_TAPCELL_ROW_20_224 VGND VPWR sky130_fd_sc_hd__tapvpwrvgnd_1
XFILLER_49_36 VGND VGND VPWR VPWR sky130_fd_sc_hd__decap_3
XFILLER_45_126 VGND VGND VPWR VPWR sky130_fd_sc_hd__fill_2
XFILLER_45_159 VGND VGND VPWR VPWR sky130_fd_sc_hd__decap_3
XFILLER_14_83 VGND VGND VPWR VPWR sky130_fd_sc_hd__fill_1
XFILLER_14_94 VGND VGND VPWR VPWR sky130_fd_sc_hd__decap_3
XTAP_TAPCELL_ROW_51_393 VGND VPWR sky130_fd_sc_hd__tapvpwrvgnd_1
XTAP_TAPCELL_ROW_43_349 VGND VPWR sky130_fd_sc_hd__tapvpwrvgnd_1
XFILLER_30_82 VGND VGND VPWR VPWR sky130_fd_sc_hd__fill_2
XFILLER_46_9 VGND VGND VPWR VPWR sky130_fd_sc_hd__decap_3
XFILLER_5_222 VGND VGND VPWR VPWR sky130_fd_sc_hd__fill_2
XFILLER_5_277 VGND VGND VPWR VPWR sky130_fd_sc_hd__decap_3
XFILLER_5_299 VGND VGND VPWR VPWR sky130_fd_sc_hd__decap_3
Xrebuffer393 rebuffer394/X VGND VGND VPWR VPWR rebuffer393/X sky130_fd_sc_hd__buf_6
Xrebuffer382 _0960_/X VGND VGND VPWR VPWR _1132_/A sky130_fd_sc_hd__buf_2
Xinput9 A[17] VGND VGND VPWR VPWR input9/X sky130_fd_sc_hd__clkdlybuf4s25_1
X_1190_ _1513_/A1 _1172_/Y _1191_/B _1189_/X VGND VGND VPWR VPWR _1671_/D sky130_fd_sc_hd__a31o_2
XFILLER_36_159 VGND VGND VPWR VPWR sky130_fd_sc_hd__fill_2
XFILLER_44_181 VGND VGND VPWR VPWR sky130_fd_sc_hd__fill_1
X_0974_ _0976_/A _0976_/B VGND VGND VPWR VPWR _0974_/Y sky130_fd_sc_hd__nor2_2
X_1526_ _1377_/X _1525_/X _1526_/S VGND VGND VPWR VPWR _1526_/X sky130_fd_sc_hd__mux2_1
X_1457_ _1376_/X _1456_/X _1457_/S VGND VGND VPWR VPWR _1457_/X sky130_fd_sc_hd__mux2_2
XFILLER_27_148 VGND VGND VPWR VPWR sky130_fd_sc_hd__decap_3
XFILLER_35_49 VGND VGND VPWR VPWR sky130_fd_sc_hd__decap_3
X_1388_ _1389_/B _1388_/B VGND VGND VPWR VPWR _1388_/Y sky130_fd_sc_hd__xnor2_2
XFILLER_35_192 VGND VGND VPWR VPWR sky130_fd_sc_hd__fill_1
XFILLER_51_15 VGND VGND VPWR VPWR sky130_fd_sc_hd__decap_3
XFILLER_51_48 VGND VGND VPWR VPWR sky130_fd_sc_hd__decap_3
XFILLER_2_203 VGND VGND VPWR VPWR sky130_fd_sc_hd__fill_2
XFILLER_18_137 VGND VGND VPWR VPWR sky130_fd_sc_hd__decap_3
XFILLER_18_148 VGND VGND VPWR VPWR sky130_fd_sc_hd__decap_3
XFILLER_25_60 VGND VGND VPWR VPWR sky130_fd_sc_hd__decap_3
XPHY_EDGE_ROW_38_Left_91 VGND VGND VPWR VPWR sky130_fd_sc_hd__decap_3
XPHY_EDGE_ROW_22_Left_75 VGND VGND VPWR VPWR sky130_fd_sc_hd__decap_3
X_1311_ _1333_/A _1007_/B _1296_/X _1561_/A1 VGND VGND VPWR VPWR _1312_/B sky130_fd_sc_hd__a31o_2
XFILLER_49_251 VGND VGND VPWR VPWR sky130_fd_sc_hd__decap_3
XFILLER_49_284 VGND VGND VPWR VPWR sky130_fd_sc_hd__decap_3
XPHY_EDGE_ROW_10_Right_10 VGND VGND VPWR VPWR sky130_fd_sc_hd__decap_3
X_1242_ _1560_/A1 _1237_/X _1241_/X _1647_/A1 VGND VGND VPWR VPWR _1249_/B sky130_fd_sc_hd__a22o_2
X_1173_ _1173_/A _1181_/B _1173_/C VGND VGND VPWR VPWR _1191_/B sky130_fd_sc_hd__or3_2
XFILLER_24_118 VGND VGND VPWR VPWR sky130_fd_sc_hd__fill_1
XFILLER_21_18 VGND VGND VPWR VPWR sky130_fd_sc_hd__decap_3
X_0957_ _1145_/S _0957_/B VGND VGND VPWR VPWR _0957_/Y sky130_fd_sc_hd__nand2_2
X_0888_ _1659_/B _0888_/B VGND VGND VPWR VPWR _1657_/A sky130_fd_sc_hd__and2_2
XFILLER_46_15 VGND VGND VPWR VPWR sky130_fd_sc_hd__decap_3
X_1509_ _1511_/A _1509_/B VGND VGND VPWR VPWR _1548_/C sky130_fd_sc_hd__or2_2
XFILLER_15_107 VGND VGND VPWR VPWR sky130_fd_sc_hd__decap_3
XFILLER_11_95 VGND VGND VPWR VPWR sky130_fd_sc_hd__decap_3
XFILLER_46_265 VGND VGND VPWR VPWR sky130_fd_sc_hd__decap_3
XFILLER_36_92 VGND VGND VPWR VPWR sky130_fd_sc_hd__decap_3
XFILLER_46_298 VGND VGND VPWR VPWR sky130_fd_sc_hd__decap_3
Xinput12 A[1] VGND VGND VPWR VPWR _0958_/A sky130_fd_sc_hd__buf_1
Xinput23 A[2] VGND VGND VPWR VPWR _0965_/B sky130_fd_sc_hd__clkdlybuf4s25_1
Xinput34 B[10] VGND VGND VPWR VPWR _1006_/A sky130_fd_sc_hd__clkdlybuf4s25_1
Xinput45 B[20] VGND VGND VPWR VPWR _0931_/A sky130_fd_sc_hd__clkdlybuf4s25_1
Xinput56 B[30] VGND VGND VPWR VPWR _0891_/A sky130_fd_sc_hd__clkdlybuf4s25_1
Xinput67 control[2] VGND VGND VPWR VPWR _1069_/B sky130_fd_sc_hd__clkdlybuf4s25_1
XFILLER_37_232 VGND VGND VPWR VPWR sky130_fd_sc_hd__fill_2
XFILLER_37_287 VGND VGND VPWR VPWR sky130_fd_sc_hd__decap_3
XFILLER_52_235 VGND VGND VPWR VPWR sky130_fd_sc_hd__fill_2
X_1225_ _1223_/X _1379_/B _1379_/A VGND VGND VPWR VPWR _1225_/X sky130_fd_sc_hd__mux2_4
X_1156_ _1154_/A _1154_/B _1464_/A _1155_/X VGND VGND VPWR VPWR _1169_/B sky130_fd_sc_hd__a211oi_2
X_1087_ _1375_/A1 input6/X input7/X _1053_/B _1413_/S _1432_/S1 VGND VGND VPWR VPWR
+ _1087_/X sky130_fd_sc_hd__mux4_2
XFILLER_4_309 VGND VGND VPWR VPWR sky130_fd_sc_hd__fill_1
XFILLER_28_243 VGND VGND VPWR VPWR sky130_fd_sc_hd__decap_3
XFILLER_11_121 VGND VGND VPWR VPWR sky130_fd_sc_hd__decap_3
XFILLER_43_213 VGND VGND VPWR VPWR sky130_fd_sc_hd__decap_3
XFILLER_51_290 VGND VGND VPWR VPWR sky130_fd_sc_hd__decap_3
XFILLER_22_83 VGND VGND VPWR VPWR sky130_fd_sc_hd__fill_1
XFILLER_7_147 VGND VGND VPWR VPWR sky130_fd_sc_hd__decap_3
XFILLER_7_169 VGND VGND VPWR VPWR sky130_fd_sc_hd__decap_3
X_1010_ _1010_/A _1019_/B VGND VGND VPWR VPWR _1012_/B sky130_fd_sc_hd__nand2_2
XTAP_TAPCELL_ROW_29_271 VGND VPWR sky130_fd_sc_hd__tapvpwrvgnd_1
XFILLER_8_41 VGND VGND VPWR VPWR sky130_fd_sc_hd__decap_3
XFILLER_8_85 VGND VGND VPWR VPWR sky130_fd_sc_hd__decap_3
XTAP_TAPCELL_ROW_12_182 VGND VPWR sky130_fd_sc_hd__tapvpwrvgnd_1
X_1208_ _1208_/A _1208_/B VGND VGND VPWR VPWR _1208_/Y sky130_fd_sc_hd__xnor2_2
XFILLER_25_246 VGND VGND VPWR VPWR sky130_fd_sc_hd__decap_3
XFILLER_25_268 VGND VGND VPWR VPWR sky130_fd_sc_hd__fill_2
XFILLER_33_290 VGND VGND VPWR VPWR sky130_fd_sc_hd__decap_3
XFILLER_40_238 VGND VGND VPWR VPWR sky130_fd_sc_hd__decap_3
XFILLER_43_27 VGND VGND VPWR VPWR sky130_fd_sc_hd__decap_3
XFILLER_43_49 VGND VGND VPWR VPWR sky130_fd_sc_hd__decap_3
X_1139_ _1137_/A _0965_/B _1632_/A3 _1138_/X VGND VGND VPWR VPWR _1139_/X sky130_fd_sc_hd__a31o_2
XFILLER_16_213 VGND VGND VPWR VPWR sky130_fd_sc_hd__decap_3
XFILLER_33_60 VGND VGND VPWR VPWR sky130_fd_sc_hd__decap_3
X_1490_ _1418_/C _1489_/X _1180_/X VGND VGND VPWR VPWR _1490_/X sky130_fd_sc_hd__a21o_2
XFILLER_22_227 VGND VGND VPWR VPWR sky130_fd_sc_hd__decap_3
XPHY_EDGE_ROW_8_Right_8 VGND VGND VPWR VPWR sky130_fd_sc_hd__decap_3
XFILLER_30_271 VGND VGND VPWR VPWR sky130_fd_sc_hd__decap_3
XTAP_TAPCELL_ROW_32_288 VGND VPWR sky130_fd_sc_hd__tapvpwrvgnd_1
XPHY_EDGE_ROW_39_Right_39 VGND VGND VPWR VPWR sky130_fd_sc_hd__decap_3
XFILLER_38_49 VGND VGND VPWR VPWR sky130_fd_sc_hd__decap_3
XFILLER_45_308 VGND VGND VPWR VPWR sky130_fd_sc_hd__fill_2
XFILLER_13_249 VGND VGND VPWR VPWR sky130_fd_sc_hd__decap_3
XPHY_EDGE_ROW_48_Right_48 VGND VGND VPWR VPWR sky130_fd_sc_hd__decap_3
Xrebuffer520 _1112_/X VGND VGND VPWR VPWR _1373_/A0 sky130_fd_sc_hd__buf_6
XFILLER_48_157 VGND VGND VPWR VPWR sky130_fd_sc_hd__decap_3
XTAP_TAPCELL_ROW_46_369 VGND VPWR sky130_fd_sc_hd__tapvpwrvgnd_1
XFILLER_8_253 VGND VGND VPWR VPWR sky130_fd_sc_hd__decap_3
X_1611_ _1632_/A3 _1635_/B _1647_/C1 _1610_/X VGND VGND VPWR VPWR _1611_/X sky130_fd_sc_hd__a211o_2
X_0990_ _1254_/C _0989_/Y _0984_/X VGND VGND VPWR VPWR _1252_/C sky130_fd_sc_hd__a21oi_2
XFILLER_5_42 VGND VGND VPWR VPWR sky130_fd_sc_hd__decap_3
X_1542_ _1241_/X _1418_/X _1537_/X _1541_/X VGND VGND VPWR VPWR _1542_/X sky130_fd_sc_hd__a211o_2
X_1473_ _1266_/A _1471_/X _1472_/X _1418_/C VGND VGND VPWR VPWR _1473_/X sky130_fd_sc_hd__o211a_2
XFILLER_39_113 VGND VGND VPWR VPWR sky130_fd_sc_hd__decap_3
XFILLER_24_29 VGND VGND VPWR VPWR sky130_fd_sc_hd__fill_1
XTAP_TAPCELL_ROW_20_225 VGND VPWR sky130_fd_sc_hd__tapvpwrvgnd_1
XFILLER_49_15 VGND VGND VPWR VPWR sky130_fd_sc_hd__decap_3
XFILLER_6_9 VGND VGND VPWR VPWR sky130_fd_sc_hd__decap_3
XFILLER_38_190 VGND VGND VPWR VPWR sky130_fd_sc_hd__fill_2
XFILLER_45_105 VGND VGND VPWR VPWR sky130_fd_sc_hd__fill_2
XFILLER_5_201 VGND VGND VPWR VPWR sky130_fd_sc_hd__fill_2
XTAP_TAPCELL_ROW_51_394 VGND VPWR sky130_fd_sc_hd__tapvpwrvgnd_1
XFILLER_5_256 VGND VGND VPWR VPWR sky130_fd_sc_hd__decap_3
Xrebuffer394 _1678_/B VGND VGND VPWR VPWR rebuffer394/X sky130_fd_sc_hd__buf_2
Xrebuffer383 fanout168/X VGND VGND VPWR VPWR _0962_/A sky130_fd_sc_hd__buf_2
XFILLER_36_127 VGND VGND VPWR VPWR sky130_fd_sc_hd__decap_3
X_0973_ _0983_/A _1181_/A VGND VGND VPWR VPWR _1215_/A sky130_fd_sc_hd__nand2b_2
X_1525_ _1456_/X _1524_/X _1588_/S VGND VGND VPWR VPWR _1525_/X sky130_fd_sc_hd__mux2_1
X_1456_ _1413_/X _1455_/X _1568_/S VGND VGND VPWR VPWR _1456_/X sky130_fd_sc_hd__mux2_1
X_1387_ _1406_/A _1369_/B _1029_/X VGND VGND VPWR VPWR _1388_/B sky130_fd_sc_hd__a21o_2
XFILLER_27_105 VGND VGND VPWR VPWR sky130_fd_sc_hd__decap_3
XFILLER_27_116 VGND VGND VPWR VPWR sky130_fd_sc_hd__fill_2
XFILLER_27_127 VGND VGND VPWR VPWR sky130_fd_sc_hd__decap_3
XFILLER_35_28 VGND VGND VPWR VPWR sky130_fd_sc_hd__decap_3
XFILLER_42_119 VGND VGND VPWR VPWR sky130_fd_sc_hd__fill_2
XFILLER_50_141 VGND VGND VPWR VPWR sky130_fd_sc_hd__decap_3
XFILLER_51_27 VGND VGND VPWR VPWR sky130_fd_sc_hd__decap_3
XFILLER_2_248 VGND VGND VPWR VPWR sky130_fd_sc_hd__decap_3
XFILLER_2_259 VGND VGND VPWR VPWR sky130_fd_sc_hd__decap_3
XFILLER_4_6 VGND VGND VPWR VPWR sky130_fd_sc_hd__decap_3
XFILLER_26_171 VGND VGND VPWR VPWR sky130_fd_sc_hd__fill_2
XFILLER_33_108 VGND VGND VPWR VPWR sky130_fd_sc_hd__decap_3
XFILLER_41_196 VGND VGND VPWR VPWR sky130_fd_sc_hd__decap_3
XFILLER_41_60 VGND VGND VPWR VPWR sky130_fd_sc_hd__decap_3
XFILLER_1_270 VGND VGND VPWR VPWR sky130_fd_sc_hd__decap_3
XFILLER_1_281 VGND VGND VPWR VPWR sky130_fd_sc_hd__decap_3
XFILLER_2_21 VGND VGND VPWR VPWR sky130_fd_sc_hd__decap_3
XFILLER_2_32 VGND VGND VPWR VPWR sky130_fd_sc_hd__decap_3
XFILLER_37_6 VGND VGND VPWR VPWR sky130_fd_sc_hd__decap_3
XFILLER_49_230 VGND VGND VPWR VPWR sky130_fd_sc_hd__decap_3
X_1310_ _1007_/B _1296_/X _1333_/A VGND VGND VPWR VPWR _1312_/A sky130_fd_sc_hd__a21oi_2
X_1241_ _1165_/B _1240_/X _1265_/S VGND VGND VPWR VPWR _1241_/X sky130_fd_sc_hd__mux2_2
XFILLER_17_182 VGND VGND VPWR VPWR sky130_fd_sc_hd__decap_3
XFILLER_49_263 VGND VGND VPWR VPWR sky130_fd_sc_hd__decap_3
XFILLER_49_296 VGND VGND VPWR VPWR sky130_fd_sc_hd__decap_3
X_1172_ _1173_/A _1173_/C _1181_/B VGND VGND VPWR VPWR _1172_/Y sky130_fd_sc_hd__o21ai_2
X_0956_ _0958_/B _0957_/B VGND VGND VPWR VPWR _0956_/X sky130_fd_sc_hd__and2b_2
Xoutput100 _1673_/C VGND VGND VPWR VPWR result[9] sky130_fd_sc_hd__buf_6
X_0887_ _0887_/A _1392_/A VGND VGND VPWR VPWR _0888_/B sky130_fd_sc_hd__or2_2
XFILLER_46_27 VGND VGND VPWR VPWR sky130_fd_sc_hd__fill_1
XFILLER_46_38 VGND VGND VPWR VPWR sky130_fd_sc_hd__decap_3
X_1508_ _0931_/A _0943_/B _1496_/A _1485_/A VGND VGND VPWR VPWR _1508_/X sky130_fd_sc_hd__a211o_2
X_1439_ _1442_/A _1442_/B VGND VGND VPWR VPWR _1439_/Y sky130_fd_sc_hd__nand2_2
XFILLER_23_141 VGND VGND VPWR VPWR sky130_fd_sc_hd__decap_3
XFILLER_11_30 VGND VGND VPWR VPWR sky130_fd_sc_hd__decap_3
XFILLER_11_74 VGND VGND VPWR VPWR sky130_fd_sc_hd__decap_3
XFILLER_2_3 VGND VGND VPWR VPWR sky130_fd_sc_hd__decap_3
XFILLER_36_60 VGND VGND VPWR VPWR sky130_fd_sc_hd__fill_1
XFILLER_36_82 VGND VGND VPWR VPWR sky130_fd_sc_hd__fill_2
XFILLER_46_277 VGND VGND VPWR VPWR sky130_fd_sc_hd__decap_3
XFILLER_14_141 VGND VGND VPWR VPWR sky130_fd_sc_hd__decap_3
Xinput13 A[20] VGND VGND VPWR VPWR input13/X sky130_fd_sc_hd__clkdlybuf4s25_1
Xinput24 A[30] VGND VGND VPWR VPWR _0891_/B sky130_fd_sc_hd__clkdlybuf4s25_1
Xinput35 B[11] VGND VGND VPWR VPWR _1004_/A sky130_fd_sc_hd__clkdlybuf4s25_1
Xinput46 B[21] VGND VGND VPWR VPWR _0928_/A sky130_fd_sc_hd__clkdlybuf4s25_1
Xinput57 B[31] VGND VGND VPWR VPWR _0887_/A sky130_fd_sc_hd__clkdlybuf4s25_1
Xinput68 control[3] VGND VGND VPWR VPWR _0869_/B sky130_fd_sc_hd__clkdlybuf4s25_1
X_1224_ _1116_/A _1226_/B _1226_/C VGND VGND VPWR VPWR _1379_/B sky130_fd_sc_hd__mux2_1
XFILLER_37_277 VGND VGND VPWR VPWR sky130_fd_sc_hd__decap_3
XFILLER_37_299 VGND VGND VPWR VPWR sky130_fd_sc_hd__decap_3
XFILLER_52_214 VGND VGND VPWR VPWR sky130_fd_sc_hd__fill_1
XFILLER_52_225 VGND VGND VPWR VPWR sky130_fd_sc_hd__fill_2
X_1155_ _1154_/A _1154_/Y _1155_/S VGND VGND VPWR VPWR _1155_/X sky130_fd_sc_hd__mux2_1
X_1086_ _1079_/X _1392_/C _1080_/Y _1085_/X VGND VGND VPWR VPWR _1086_/X sky130_fd_sc_hd__a22o_4
XFILLER_20_100 VGND VGND VPWR VPWR sky130_fd_sc_hd__decap_3
XFILLER_20_144 VGND VGND VPWR VPWR sky130_fd_sc_hd__decap_3
XFILLER_32_29 VGND VGND VPWR VPWR sky130_fd_sc_hd__decap_3
X_0939_ _0939_/A _0939_/B VGND VGND VPWR VPWR _1548_/B sky130_fd_sc_hd__nand2_2
XFILLER_11_111 VGND VGND VPWR VPWR sky130_fd_sc_hd__fill_1
XFILLER_43_236 VGND VGND VPWR VPWR sky130_fd_sc_hd__fill_2
XFILLER_11_166 VGND VGND VPWR VPWR sky130_fd_sc_hd__fill_2
XFILLER_11_188 VGND VGND VPWR VPWR sky130_fd_sc_hd__fill_1
XFILLER_22_40 VGND VGND VPWR VPWR sky130_fd_sc_hd__decap_3
XFILLER_22_62 VGND VGND VPWR VPWR sky130_fd_sc_hd__decap_3
Xfanout190 fanout192/X VGND VGND VPWR VPWR fanout190/X sky130_fd_sc_hd__buf_6
XFILLER_19_255 VGND VGND VPWR VPWR sky130_fd_sc_hd__decap_3
XFILLER_34_203 VGND VGND VPWR VPWR sky130_fd_sc_hd__decap_3
XFILLER_47_70 VGND VGND VPWR VPWR sky130_fd_sc_hd__fill_2
XTAP_TAPCELL_ROW_29_272 VGND VPWR sky130_fd_sc_hd__tapvpwrvgnd_1
XFILLER_42_280 VGND VGND VPWR VPWR sky130_fd_sc_hd__fill_2
XFILLER_8_53 VGND VGND VPWR VPWR sky130_fd_sc_hd__decap_3
XFILLER_8_97 VGND VGND VPWR VPWR sky130_fd_sc_hd__decap_3
XFILLER_6_170 VGND VGND VPWR VPWR sky130_fd_sc_hd__decap_3
X_1207_ _1181_/A _1181_/B _0986_/X VGND VGND VPWR VPWR _1208_/B sky130_fd_sc_hd__a21oi_2
XFILLER_25_225 VGND VGND VPWR VPWR sky130_fd_sc_hd__decap_3
XFILLER_40_206 VGND VGND VPWR VPWR sky130_fd_sc_hd__fill_2
X_1138_ _1453_/A1 _0963_/A _1137_/Y _1647_/A1 _1133_/Y VGND VGND VPWR VPWR _1138_/X
+ sky130_fd_sc_hd__a221o_2
X_1069_ _0878_/D _1069_/B _1069_/C _1116_/D VGND VGND VPWR VPWR _1392_/C sky130_fd_sc_hd__and4b_2
XFILLER_0_302 VGND VGND VPWR VPWR sky130_fd_sc_hd__decap_3
XFILLER_17_84 VGND VGND VPWR VPWR sky130_fd_sc_hd__decap_3
Xmax_cap110 _1620_/A VGND VGND VPWR VPWR _1594_/A sky130_fd_sc_hd__clkbuf_2
XTAP_TAPCELL_ROW_32_289 VGND VPWR sky130_fd_sc_hd__tapvpwrvgnd_1
XTAP_TAPCELL_ROW_0_110 VGND VPWR sky130_fd_sc_hd__tapvpwrvgnd_1
Xrebuffer521 _1670_/B VGND VGND VPWR VPWR output70/A sky130_fd_sc_hd__buf_6
XFILLER_28_61 VGND VGND VPWR VPWR sky130_fd_sc_hd__decap_3
XFILLER_28_83 VGND VGND VPWR VPWR sky130_fd_sc_hd__fill_1
XFILLER_36_309 VGND VGND VPWR VPWR sky130_fd_sc_hd__fill_1
XFILLER_48_103 VGND VGND VPWR VPWR sky130_fd_sc_hd__fill_1
XFILLER_28_94 VGND VGND VPWR VPWR sky130_fd_sc_hd__decap_3
XFILLER_12_261 VGND VGND VPWR VPWR sky130_fd_sc_hd__fill_1
XFILLER_5_21 VGND VGND VPWR VPWR sky130_fd_sc_hd__decap_3
XFILLER_8_232 VGND VGND VPWR VPWR sky130_fd_sc_hd__decap_3
X_1610_ _1601_/A _0906_/B _1621_/A _1660_/A1 VGND VGND VPWR VPWR _1610_/X sky130_fd_sc_hd__a2bb2o_2
X_1541_ _1397_/X _1416_/X _1540_/X _1647_/A1 VGND VGND VPWR VPWR _1541_/X sky130_fd_sc_hd__a22o_2
X_1472_ _1472_/A _1472_/B VGND VGND VPWR VPWR _1472_/X sky130_fd_sc_hd__or2_2
XFILLER_39_158 VGND VGND VPWR VPWR sky130_fd_sc_hd__decap_3
XTAP_TAPCELL_ROW_37_315 VGND VPWR sky130_fd_sc_hd__tapvpwrvgnd_1
XFILLER_10_209 VGND VGND VPWR VPWR sky130_fd_sc_hd__decap_3
XFILLER_50_301 VGND VGND VPWR VPWR sky130_fd_sc_hd__decap_3
XTAP_TAPCELL_ROW_20_226 VGND VPWR sky130_fd_sc_hd__tapvpwrvgnd_1
XFILLER_40_29 VGND VGND VPWR VPWR sky130_fd_sc_hd__decap_3
XFILLER_49_27 VGND VGND VPWR VPWR sky130_fd_sc_hd__decap_3
XFILLER_18_309 VGND VGND VPWR VPWR sky130_fd_sc_hd__fill_1
XFILLER_41_301 VGND VGND VPWR VPWR sky130_fd_sc_hd__decap_3
XFILLER_14_63 VGND VGND VPWR VPWR sky130_fd_sc_hd__decap_3
XFILLER_14_85 VGND VGND VPWR VPWR sky130_fd_sc_hd__decap_3
Xrebuffer384 rebuffer388/X VGND VGND VPWR VPWR rebuffer384/X sky130_fd_sc_hd__buf_6
Xrebuffer340 _1219_/A2 VGND VGND VPWR VPWR _0986_/B sky130_fd_sc_hd__buf_2
XTAP_TAPCELL_ROW_51_395 VGND VPWR sky130_fd_sc_hd__tapvpwrvgnd_1
XFILLER_30_73 VGND VGND VPWR VPWR sky130_fd_sc_hd__decap_3
XFILLER_5_268 VGND VGND VPWR VPWR sky130_fd_sc_hd__decap_3
XFILLER_36_106 VGND VGND VPWR VPWR sky130_fd_sc_hd__fill_1
XFILLER_39_82 VGND VGND VPWR VPWR sky130_fd_sc_hd__decap_3
X_0972_ _1254_/A _0972_/B VGND VGND VPWR VPWR _0983_/A sky130_fd_sc_hd__nand2_2
X_1524_ _1486_/X _1523_/X _1568_/S VGND VGND VPWR VPWR _1524_/X sky130_fd_sc_hd__mux2_1
XFILLER_4_290 VGND VGND VPWR VPWR sky130_fd_sc_hd__decap_3
X_1455_ _1052_/B input9/X _1455_/S VGND VGND VPWR VPWR _1455_/X sky130_fd_sc_hd__mux2_1
X_1386_ _1464_/A _1369_/Y _1385_/X VGND VGND VPWR VPWR _1675_/B sky130_fd_sc_hd__o21ai_2
XFILLER_27_139 VGND VGND VPWR VPWR sky130_fd_sc_hd__decap_3
XFILLER_35_172 VGND VGND VPWR VPWR sky130_fd_sc_hd__fill_1
XFILLER_50_197 VGND VGND VPWR VPWR sky130_fd_sc_hd__decap_3
XFILLER_51_39 VGND VGND VPWR VPWR sky130_fd_sc_hd__decap_3
XFILLER_25_95 VGND VGND VPWR VPWR sky130_fd_sc_hd__fill_2
XFILLER_26_150 VGND VGND VPWR VPWR sky130_fd_sc_hd__fill_2
XFILLER_26_161 VGND VGND VPWR VPWR sky130_fd_sc_hd__fill_2
XFILLER_26_194 VGND VGND VPWR VPWR sky130_fd_sc_hd__fill_2
XFILLER_51_9 VGND VGND VPWR VPWR sky130_fd_sc_hd__decap_3
XFILLER_1_293 VGND VGND VPWR VPWR sky130_fd_sc_hd__decap_3
XFILLER_2_44 VGND VGND VPWR VPWR sky130_fd_sc_hd__decap_3
XFILLER_49_220 VGND VGND VPWR VPWR sky130_fd_sc_hd__decap_3
XFILLER_49_242 VGND VGND VPWR VPWR sky130_fd_sc_hd__decap_3
XFILLER_49_275 VGND VGND VPWR VPWR sky130_fd_sc_hd__decap_3
X_1240_ input30/X _0988_/B _0951_/B _0970_/B _1090_/S _1264_/S1 VGND VGND VPWR VPWR
+ _1240_/X sky130_fd_sc_hd__mux4_2
X_1171_ _1133_/B _1129_/X _0953_/Y _0963_/B VGND VGND VPWR VPWR _1173_/C sky130_fd_sc_hd__o211a_4
XFILLER_17_172 VGND VGND VPWR VPWR sky130_fd_sc_hd__fill_1
XFILLER_17_194 VGND VGND VPWR VPWR sky130_fd_sc_hd__decap_3
XFILLER_24_109 VGND VGND VPWR VPWR sky130_fd_sc_hd__decap_3
X_0955_ _0955_/A _0955_/B VGND VGND VPWR VPWR _0955_/Y sky130_fd_sc_hd__xnor2_2
X_0886_ _0887_/A _1392_/A VGND VGND VPWR VPWR _1659_/B sky130_fd_sc_hd__nand2_2
Xoutput101 _1682_/Y VGND VGND VPWR VPWR zero sky130_fd_sc_hd__buf_6
X_1507_ _1537_/A _1507_/B _1506_/X VGND VGND VPWR VPWR _1507_/X sky130_fd_sc_hd__or3b_2
X_1438_ _1537_/A _1438_/B _1438_/C _1438_/D VGND VGND VPWR VPWR _1445_/C sky130_fd_sc_hd__or4_4
X_1369_ _1406_/A _1369_/B VGND VGND VPWR VPWR _1369_/Y sky130_fd_sc_hd__xnor2_2
XFILLER_11_86 VGND VGND VPWR VPWR sky130_fd_sc_hd__decap_3
XFILLER_14_131 VGND VGND VPWR VPWR sky130_fd_sc_hd__decap_3
XFILLER_46_256 VGND VGND VPWR VPWR sky130_fd_sc_hd__decap_3
XFILLER_46_289 VGND VGND VPWR VPWR sky130_fd_sc_hd__decap_3
XFILLER_14_197 VGND VGND VPWR VPWR sky130_fd_sc_hd__decap_3
XFILLER_52_60 VGND VGND VPWR VPWR sky130_fd_sc_hd__decap_3
Xinput14 A[21] VGND VGND VPWR VPWR input14/X sky130_fd_sc_hd__clkdlybuf4s25_1
Xinput25 A[31] VGND VGND VPWR VPWR input25/X sky130_fd_sc_hd__clkdlybuf4s25_1
Xinput36 B[12] VGND VGND VPWR VPWR _0994_/A sky130_fd_sc_hd__clkdlybuf4s25_1
Xinput47 B[22] VGND VGND VPWR VPWR _0934_/A sky130_fd_sc_hd__clkdlybuf4s25_1
Xinput58 B[3] VGND VGND VPWR VPWR _1379_/A sky130_fd_sc_hd__clkbuf_4
XFILLER_37_223 VGND VGND VPWR VPWR sky130_fd_sc_hd__fill_1
X_1223_ _1223_/A0 _1115_/X _1243_/S VGND VGND VPWR VPWR _1223_/X sky130_fd_sc_hd__mux2_4
X_1154_ _1154_/A _1154_/B VGND VGND VPWR VPWR _1154_/Y sky130_fd_sc_hd__nor2_2
XFILLER_52_248 VGND VGND VPWR VPWR sky130_fd_sc_hd__decap_3
X_1085_ _1072_/X _1084_/X _1416_/B VGND VGND VPWR VPWR _1085_/X sky130_fd_sc_hd__mux2_4
XFILLER_20_134 VGND VGND VPWR VPWR sky130_fd_sc_hd__decap_3
X_0938_ _0938_/A _0947_/B VGND VGND VPWR VPWR _0939_/B sky130_fd_sc_hd__nand2_2
X_0869_ _0878_/C _0869_/B _1104_/B VGND VGND VPWR VPWR _0869_/Y sky130_fd_sc_hd__nor3_2
XFILLER_28_234 VGND VGND VPWR VPWR sky130_fd_sc_hd__decap_3
XFILLER_43_204 VGND VGND VPWR VPWR sky130_fd_sc_hd__decap_3
XFILLER_22_52 VGND VGND VPWR VPWR sky130_fd_sc_hd__fill_2
XFILLER_51_270 VGND VGND VPWR VPWR sky130_fd_sc_hd__decap_3
XFILLER_51_281 VGND VGND VPWR VPWR sky130_fd_sc_hd__decap_3
XFILLER_7_138 VGND VGND VPWR VPWR sky130_fd_sc_hd__decap_3
XFILLER_19_212 VGND VGND VPWR VPWR sky130_fd_sc_hd__fill_2
XFILLER_19_223 VGND VGND VPWR VPWR sky130_fd_sc_hd__fill_1
Xfanout180 input44/X VGND VGND VPWR VPWR fanout180/X sky130_fd_sc_hd__buf_8
XFILLER_34_215 VGND VGND VPWR VPWR sky130_fd_sc_hd__decap_3
XTAP_TAPCELL_ROW_29_273 VGND VPWR sky130_fd_sc_hd__tapvpwrvgnd_1
XFILLER_8_21 VGND VGND VPWR VPWR sky130_fd_sc_hd__decap_3
XFILLER_8_32 VGND VGND VPWR VPWR sky130_fd_sc_hd__decap_3
XFILLER_6_182 VGND VGND VPWR VPWR sky130_fd_sc_hd__decap_3
XFILLER_25_237 VGND VGND VPWR VPWR sky130_fd_sc_hd__decap_3
XFILLER_27_19 VGND VGND VPWR VPWR sky130_fd_sc_hd__fill_2
X_1206_ _1261_/A _1198_/X _1205_/X _1560_/A1 VGND VGND VPWR VPWR _1210_/B sky130_fd_sc_hd__a22o_2
X_1137_ _1137_/A _1137_/B VGND VGND VPWR VPWR _1137_/Y sky130_fd_sc_hd__nor2_2
XFILLER_25_259 VGND VGND VPWR VPWR sky130_fd_sc_hd__decap_3
XFILLER_33_281 VGND VGND VPWR VPWR sky130_fd_sc_hd__decap_3
XFILLER_40_229 VGND VGND VPWR VPWR sky130_fd_sc_hd__decap_3
XFILLER_43_18 VGND VGND VPWR VPWR sky130_fd_sc_hd__decap_3
X_1068_ _0878_/C _0878_/D _1067_/X _0884_/X VGND VGND VPWR VPWR _1678_/A sky130_fd_sc_hd__a31o_4
XFILLER_48_307 VGND VGND VPWR VPWR sky130_fd_sc_hd__fill_1
XTAP_TAPCELL_ROW_3_130 VGND VPWR sky130_fd_sc_hd__tapvpwrvgnd_1
XFILLER_16_259 VGND VGND VPWR VPWR sky130_fd_sc_hd__decap_3
XFILLER_17_52 VGND VGND VPWR VPWR sky130_fd_sc_hd__decap_3
XFILLER_17_63 VGND VGND VPWR VPWR sky130_fd_sc_hd__decap_3
XFILLER_31_207 VGND VGND VPWR VPWR sky130_fd_sc_hd__decap_3
XFILLER_31_218 VGND VGND VPWR VPWR sky130_fd_sc_hd__decap_3
XTAP_TAPCELL_ROW_26_254 VGND VPWR sky130_fd_sc_hd__tapvpwrvgnd_1
XFILLER_39_307 VGND VGND VPWR VPWR sky130_fd_sc_hd__decap_3
XFILLER_12_6 VGND VGND VPWR VPWR sky130_fd_sc_hd__decap_3
XFILLER_22_218 VGND VGND VPWR VPWR sky130_fd_sc_hd__decap_3
XFILLER_30_262 VGND VGND VPWR VPWR sky130_fd_sc_hd__fill_1
XFILLER_38_18 VGND VGND VPWR VPWR sky130_fd_sc_hd__fill_1
XFILLER_13_218 VGND VGND VPWR VPWR sky130_fd_sc_hd__decap_3
XTAP_TAPCELL_ROW_0_111 VGND VPWR sky130_fd_sc_hd__tapvpwrvgnd_1
Xrebuffer522 fanout192/X VGND VGND VPWR VPWR fanout186/A sky130_fd_sc_hd__buf_2
XFILLER_12_251 VGND VGND VPWR VPWR sky130_fd_sc_hd__fill_1
XFILLER_44_50 VGND VGND VPWR VPWR sky130_fd_sc_hd__decap_3
XFILLER_8_200 VGND VGND VPWR VPWR sky130_fd_sc_hd__decap_3
XFILLER_5_33 VGND VGND VPWR VPWR sky130_fd_sc_hd__decap_3
XFILLER_8_244 VGND VGND VPWR VPWR sky130_fd_sc_hd__fill_2
XFILLER_8_277 VGND VGND VPWR VPWR sky130_fd_sc_hd__fill_1
X_1540_ _1470_/X _1539_/X _1588_/S VGND VGND VPWR VPWR _1540_/X sky130_fd_sc_hd__mux2_1
XFILLER_10_3 VGND VGND VPWR VPWR sky130_fd_sc_hd__decap_3
XFILLER_5_99 VGND VGND VPWR VPWR sky130_fd_sc_hd__fill_2
X_1471_ _1602_/A0 _1470_/X _1588_/S VGND VGND VPWR VPWR _1471_/X sky130_fd_sc_hd__mux2_1
XTAP_TAPCELL_ROW_45_360 VGND VPWR sky130_fd_sc_hd__tapvpwrvgnd_1
XTAP_TAPCELL_ROW_37_316 VGND VPWR sky130_fd_sc_hd__tapvpwrvgnd_1
XFILLER_49_39 VGND VGND VPWR VPWR sky130_fd_sc_hd__decap_3
X_1669_ _1669_/A _1669_/B _1669_/C _1669_/D VGND VGND VPWR VPWR _1674_/D sky130_fd_sc_hd__or4_4
Xload_slew191 fanout190/X VGND VGND VPWR VPWR fanout188/A sky130_fd_sc_hd__buf_6
XFILLER_14_97 VGND VGND VPWR VPWR sky130_fd_sc_hd__decap_3
XFILLER_30_52 VGND VGND VPWR VPWR sky130_fd_sc_hd__decap_3
XFILLER_5_225 VGND VGND VPWR VPWR sky130_fd_sc_hd__decap_3
Xrebuffer385 fanout178/A VGND VGND VPWR VPWR _1134_/A sky130_fd_sc_hd__buf_2
Xrebuffer341 _1219_/A2 VGND VGND VPWR VPWR _0970_/B sky130_fd_sc_hd__buf_6
XTAP_TAPCELL_ROW_51_396 VGND VPWR sky130_fd_sc_hd__tapvpwrvgnd_1
XFILLER_30_85 VGND VGND VPWR VPWR sky130_fd_sc_hd__fill_2
XFILLER_32_302 VGND VGND VPWR VPWR sky130_fd_sc_hd__decap_3
X_0971_ _0971_/A _0971_/B VGND VGND VPWR VPWR _0972_/B sky130_fd_sc_hd__nand2_4
X_1523_ _0941_/B input14/X _1523_/S VGND VGND VPWR VPWR _1523_/X sky130_fd_sc_hd__mux2_1
X_1454_ _1137_/Y _1418_/X _1452_/Y _1453_/X VGND VGND VPWR VPWR _1461_/B sky130_fd_sc_hd__a211o_2
X_1385_ _1389_/C _1372_/X _1374_/Y _1384_/Y VGND VGND VPWR VPWR _1385_/X sky130_fd_sc_hd__o211a_2
XFILLER_35_151 VGND VGND VPWR VPWR sky130_fd_sc_hd__decap_3
XFILLER_51_18 VGND VGND VPWR VPWR sky130_fd_sc_hd__decap_3
XFILLER_25_30 VGND VGND VPWR VPWR sky130_fd_sc_hd__fill_1
XFILLER_25_52 VGND VGND VPWR VPWR sky130_fd_sc_hd__decap_3
XFILLER_25_63 VGND VGND VPWR VPWR sky130_fd_sc_hd__decap_3
XFILLER_41_132 VGND VGND VPWR VPWR sky130_fd_sc_hd__decap_3
XFILLER_1_261 VGND VGND VPWR VPWR sky130_fd_sc_hd__decap_3
XFILLER_2_12 VGND VGND VPWR VPWR sky130_fd_sc_hd__decap_3
XFILLER_49_254 VGND VGND VPWR VPWR sky130_fd_sc_hd__decap_3
XFILLER_49_287 VGND VGND VPWR VPWR sky130_fd_sc_hd__decap_3
X_1170_ _1270_/A _1150_/X _1169_/X VGND VGND VPWR VPWR _1671_/C sky130_fd_sc_hd__a21o_2
XFILLER_17_162 VGND VGND VPWR VPWR sky130_fd_sc_hd__decap_3
X_0954_ _1178_/S _0966_/B VGND VGND VPWR VPWR _1173_/A sky130_fd_sc_hd__nor2_2
X_0885_ _0887_/A _1116_/A VGND VGND VPWR VPWR _0885_/Y sky130_fd_sc_hd__nand2b_2
X_1506_ _1201_/A _1419_/Y _1503_/Y _1598_/A VGND VGND VPWR VPWR _1506_/X sky130_fd_sc_hd__o22a_2
X_1437_ _1034_/A input9/X _1585_/A3 _1107_/X _1418_/X VGND VGND VPWR VPWR _1438_/D
+ sky130_fd_sc_hd__a32o_2
XFILLER_46_18 VGND VGND VPWR VPWR sky130_fd_sc_hd__decap_3
XFILLER_46_29 VGND VGND VPWR VPWR sky130_fd_sc_hd__decap_3
X_1368_ _1028_/X _1368_/B VGND VGND VPWR VPWR _1369_/B sky130_fd_sc_hd__nand2b_2
X_1299_ _1006_/B _1019_/B input31/X _0984_/B _1358_/S0 _1358_/S1 VGND VGND VPWR VPWR
+ _1299_/X sky130_fd_sc_hd__mux4_2
XFILLER_23_132 VGND VGND VPWR VPWR sky130_fd_sc_hd__decap_3
XFILLER_11_21 VGND VGND VPWR VPWR sky130_fd_sc_hd__decap_3
XFILLER_11_98 VGND VGND VPWR VPWR sky130_fd_sc_hd__fill_2
XFILLER_46_202 VGND VGND VPWR VPWR sky130_fd_sc_hd__fill_1
XFILLER_36_51 VGND VGND VPWR VPWR sky130_fd_sc_hd__decap_3
XFILLER_36_95 VGND VGND VPWR VPWR sky130_fd_sc_hd__fill_2
XFILLER_46_268 VGND VGND VPWR VPWR sky130_fd_sc_hd__decap_3
XFILLER_52_50 VGND VGND VPWR VPWR sky130_fd_sc_hd__decap_3
Xinput15 A[22] VGND VGND VPWR VPWR _0941_/B sky130_fd_sc_hd__clkdlybuf4s25_1
Xinput26 A[3] VGND VGND VPWR VPWR _0955_/B sky130_fd_sc_hd__buf_1
Xinput37 B[13] VGND VGND VPWR VPWR _0992_/A sky130_fd_sc_hd__dlymetal6s2s_1
Xinput48 B[23] VGND VGND VPWR VPWR _0938_/A sky130_fd_sc_hd__clkdlybuf4s25_1
Xinput59 B[4] VGND VGND VPWR VPWR _1392_/B sky130_fd_sc_hd__buf_8
XPHY_EDGE_ROW_26_Left_79 VGND VGND VPWR VPWR sky130_fd_sc_hd__decap_3
XFILLER_52_205 VGND VGND VPWR VPWR sky130_fd_sc_hd__fill_2
X_1222_ _1560_/A1 _1216_/X _1221_/Y _0880_/X VGND VGND VPWR VPWR _1222_/X sky130_fd_sc_hd__a22o_2
X_1153_ _1154_/A _1151_/X _1152_/Y VGND VGND VPWR VPWR _1169_/A sky130_fd_sc_hd__o21a_2
X_1084_ _1075_/X _1083_/X _1193_/A VGND VGND VPWR VPWR _1084_/X sky130_fd_sc_hd__mux2_2
XFILLER_45_290 VGND VGND VPWR VPWR sky130_fd_sc_hd__decap_3
X_0937_ _0939_/A VGND VGND VPWR VPWR _0937_/Y sky130_fd_sc_hd__inv_2
X_0868_ _1313_/A _1069_/C VGND VGND VPWR VPWR _1104_/B sky130_fd_sc_hd__or2_2
XFILLER_28_246 VGND VGND VPWR VPWR sky130_fd_sc_hd__fill_2
XFILLER_43_216 VGND VGND VPWR VPWR sky130_fd_sc_hd__decap_3
XFILLER_11_124 VGND VGND VPWR VPWR sky130_fd_sc_hd__fill_1
XFILLER_11_157 VGND VGND VPWR VPWR sky130_fd_sc_hd__decap_3
XFILLER_51_293 VGND VGND VPWR VPWR sky130_fd_sc_hd__decap_3
XFILLER_19_279 VGND VGND VPWR VPWR sky130_fd_sc_hd__fill_1
XFILLER_47_83 VGND VGND VPWR VPWR sky130_fd_sc_hd__decap_3
Xfanout192 input33/X VGND VGND VPWR VPWR fanout192/X sky130_fd_sc_hd__buf_8
XFILLER_42_271 VGND VGND VPWR VPWR sky130_fd_sc_hd__decap_3
XTAP_TAPCELL_ROW_29_274 VGND VPWR sky130_fd_sc_hd__tapvpwrvgnd_1
XFILLER_8_44 VGND VGND VPWR VPWR sky130_fd_sc_hd__decap_3
XFILLER_8_88 VGND VGND VPWR VPWR sky130_fd_sc_hd__decap_3
XFILLER_25_249 VGND VGND VPWR VPWR sky130_fd_sc_hd__fill_2
X_1205_ _1071_/X _1357_/A2 _1088_/X _1091_/X _1205_/S0 _1275_/A VGND VGND VPWR VPWR
+ _1205_/X sky130_fd_sc_hd__mux4_2
X_1136_ _1600_/S _1135_/X _1134_/Y _1135_/S VGND VGND VPWR VPWR _1137_/B sky130_fd_sc_hd__o2bb2a_2
X_1067_ _1104_/B _0885_/Y _1065_/X _1066_/Y VGND VGND VPWR VPWR _1067_/X sky130_fd_sc_hd__a2bb2o_4
XFILLER_33_293 VGND VGND VPWR VPWR sky130_fd_sc_hd__decap_3
XTAP_TAPCELL_ROW_3_131 VGND VPWR sky130_fd_sc_hd__tapvpwrvgnd_1
XFILLER_16_216 VGND VGND VPWR VPWR sky130_fd_sc_hd__fill_1
XTAP_TAPCELL_ROW_26_255 VGND VPWR sky130_fd_sc_hd__tapvpwrvgnd_1
XPHY_EDGE_ROW_29_Left_82 VGND VGND VPWR VPWR sky130_fd_sc_hd__decap_3
XPHY_EDGE_ROW_13_Left_66 VGND VGND VPWR VPWR sky130_fd_sc_hd__decap_3
X_1119_ _1116_/X _1118_/X _1275_/C VGND VGND VPWR VPWR _1120_/A sky130_fd_sc_hd__o21ai_2
XTAP_TAPCELL_ROW_48_380 VGND VPWR sky130_fd_sc_hd__tapvpwrvgnd_1
XTAP_TAPCELL_ROW_0_112 VGND VPWR sky130_fd_sc_hd__tapvpwrvgnd_1
XFILLER_21_263 VGND VGND VPWR VPWR sky130_fd_sc_hd__fill_1
XPHY_EDGE_ROW_17_Right_17 VGND VGND VPWR VPWR sky130_fd_sc_hd__decap_3
Xrebuffer523 _1112_/S0 VGND VGND VPWR VPWR _1142_/S0 sky130_fd_sc_hd__buf_4
XPHY_EDGE_ROW_26_Right_26 VGND VGND VPWR VPWR sky130_fd_sc_hd__decap_3
XFILLER_28_85 VGND VGND VPWR VPWR sky130_fd_sc_hd__decap_3
XFILLER_44_62 VGND VGND VPWR VPWR sky130_fd_sc_hd__decap_3
XFILLER_8_212 VGND VGND VPWR VPWR sky130_fd_sc_hd__decap_3
XFILLER_8_223 VGND VGND VPWR VPWR sky130_fd_sc_hd__decap_3
XPHY_EDGE_ROW_35_Right_35 VGND VGND VPWR VPWR sky130_fd_sc_hd__decap_3
XFILLER_5_12 VGND VGND VPWR VPWR sky130_fd_sc_hd__decap_3
XFILLER_5_45 VGND VGND VPWR VPWR sky130_fd_sc_hd__decap_3
XFILLER_8_256 VGND VGND VPWR VPWR sky130_fd_sc_hd__decap_3
X_1470_ _1431_/X _1469_/X _1568_/S VGND VGND VPWR VPWR _1470_/X sky130_fd_sc_hd__mux2_1
XFILLER_39_116 VGND VGND VPWR VPWR sky130_fd_sc_hd__decap_3
XFILLER_39_138 VGND VGND VPWR VPWR sky130_fd_sc_hd__decap_3
XPHY_EDGE_ROW_44_Right_44 VGND VGND VPWR VPWR sky130_fd_sc_hd__decap_3
XFILLER_47_182 VGND VGND VPWR VPWR sky130_fd_sc_hd__decap_3
XTAP_TAPCELL_ROW_45_361 VGND VPWR sky130_fd_sc_hd__tapvpwrvgnd_1
XTAP_TAPCELL_ROW_37_317 VGND VPWR sky130_fd_sc_hd__tapvpwrvgnd_1
XFILLER_49_18 VGND VGND VPWR VPWR sky130_fd_sc_hd__decap_3
X_1668_ _1668_/A _1668_/B _1668_/C _1668_/D VGND VGND VPWR VPWR _1682_/B sky130_fd_sc_hd__or4_4
X_1599_ _0910_/B _0914_/B _1599_/S VGND VGND VPWR VPWR _1599_/X sky130_fd_sc_hd__mux2_1
Xload_slew181 fanout180/X VGND VGND VPWR VPWR fanout178/A sky130_fd_sc_hd__buf_8
XFILLER_14_10 VGND VGND VPWR VPWR sky130_fd_sc_hd__fill_1
XFILLER_14_32 VGND VGND VPWR VPWR sky130_fd_sc_hd__fill_1
XFILLER_5_259 VGND VGND VPWR VPWR sky130_fd_sc_hd__decap_3
Xrebuffer386 _1580_/X VGND VGND VPWR VPWR _1595_/A2 sky130_fd_sc_hd__buf_6
Xrebuffer364 _1627_/X VGND VGND VPWR VPWR _1640_/A3 sky130_fd_sc_hd__buf_2
Xrebuffer342 _1219_/A2 VGND VGND VPWR VPWR _1093_/A1 sky130_fd_sc_hd__buf_2
XFILLER_29_182 VGND VGND VPWR VPWR sky130_fd_sc_hd__decap_3
XFILLER_44_141 VGND VGND VPWR VPWR sky130_fd_sc_hd__decap_3
X_0970_ _0970_/A _0970_/B VGND VGND VPWR VPWR _0971_/B sky130_fd_sc_hd__or2_4
XTAP_TAPCELL_ROW_42_342 VGND VPWR sky130_fd_sc_hd__tapvpwrvgnd_1
XFILLER_4_281 VGND VGND VPWR VPWR sky130_fd_sc_hd__decap_3
X_1522_ _1221_/Y _1418_/X _1520_/X _1521_/X VGND VGND VPWR VPWR _1522_/X sky130_fd_sc_hd__a211o_2
X_1453_ _1453_/A1 _1043_/A _1479_/A _1555_/B2 VGND VGND VPWR VPWR _1453_/X sky130_fd_sc_hd__a22o_2
XFILLER_27_108 VGND VGND VPWR VPWR sky130_fd_sc_hd__decap_3
X_1384_ _1570_/A1 _1378_/X _1383_/X VGND VGND VPWR VPWR _1384_/Y sky130_fd_sc_hd__a21oi_2
XFILLER_50_166 VGND VGND VPWR VPWR sky130_fd_sc_hd__decap_3
XFILLER_4_9 VGND VGND VPWR VPWR sky130_fd_sc_hd__decap_3
XFILLER_25_42 VGND VGND VPWR VPWR sky130_fd_sc_hd__decap_3
XFILLER_26_130 VGND VGND VPWR VPWR sky130_fd_sc_hd__decap_3
XFILLER_26_141 VGND VGND VPWR VPWR sky130_fd_sc_hd__decap_3
XFILLER_41_122 VGND VGND VPWR VPWR sky130_fd_sc_hd__fill_1
XFILLER_25_75 VGND VGND VPWR VPWR sky130_fd_sc_hd__fill_2
XFILLER_41_199 VGND VGND VPWR VPWR sky130_fd_sc_hd__fill_1
XFILLER_41_63 VGND VGND VPWR VPWR sky130_fd_sc_hd__decap_3
XFILLER_1_240 VGND VGND VPWR VPWR sky130_fd_sc_hd__decap_3
XFILLER_37_9 VGND VGND VPWR VPWR sky130_fd_sc_hd__fill_1
XFILLER_1_273 VGND VGND VPWR VPWR sky130_fd_sc_hd__decap_3
XFILLER_1_284 VGND VGND VPWR VPWR sky130_fd_sc_hd__decap_3
XFILLER_2_24 VGND VGND VPWR VPWR sky130_fd_sc_hd__decap_3
XFILLER_2_35 VGND VGND VPWR VPWR sky130_fd_sc_hd__decap_3
XFILLER_49_233 VGND VGND VPWR VPWR sky130_fd_sc_hd__decap_3
XFILLER_49_266 VGND VGND VPWR VPWR sky130_fd_sc_hd__decap_3
XFILLER_49_299 VGND VGND VPWR VPWR sky130_fd_sc_hd__decap_3
XFILLER_17_185 VGND VGND VPWR VPWR sky130_fd_sc_hd__decap_3
XFILLER_32_122 VGND VGND VPWR VPWR sky130_fd_sc_hd__decap_3
XFILLER_32_133 VGND VGND VPWR VPWR sky130_fd_sc_hd__decap_3
X_0953_ _1178_/S _0966_/B VGND VGND VPWR VPWR _0953_/Y sky130_fd_sc_hd__nand2_2
X_0884_ _1374_/A _0863_/X _0883_/X _0848_/X VGND VGND VPWR VPWR _0884_/X sky130_fd_sc_hd__a211o_2
X_1505_ _0928_/A _0942_/B _1585_/A3 _1504_/X VGND VGND VPWR VPWR _1507_/B sky130_fd_sc_hd__a31o_2
X_1436_ _1535_/A _1442_/A _1035_/A _1453_/A1 VGND VGND VPWR VPWR _1438_/B sky130_fd_sc_hd__a2bb2o_2
X_1367_ _1349_/X _1351_/X _1356_/X _1366_/X VGND VGND VPWR VPWR _1669_/B sky130_fd_sc_hd__a211o_2
XFILLER_23_100 VGND VGND VPWR VPWR sky130_fd_sc_hd__fill_2
XFILLER_23_111 VGND VGND VPWR VPWR sky130_fd_sc_hd__fill_1
XFILLER_23_122 VGND VGND VPWR VPWR sky130_fd_sc_hd__fill_1
X_1298_ _1114_/X _1124_/X _1430_/A VGND VGND VPWR VPWR _1298_/X sky130_fd_sc_hd__mux2_4
XFILLER_23_144 VGND VGND VPWR VPWR sky130_fd_sc_hd__decap_3
XFILLER_11_77 VGND VGND VPWR VPWR sky130_fd_sc_hd__decap_3
XFILLER_2_6 VGND VGND VPWR VPWR sky130_fd_sc_hd__decap_3
XFILLER_46_214 VGND VGND VPWR VPWR sky130_fd_sc_hd__decap_3
XFILLER_14_122 VGND VGND VPWR VPWR sky130_fd_sc_hd__fill_1
XFILLER_14_144 VGND VGND VPWR VPWR sky130_fd_sc_hd__fill_2
XPHY_EDGE_ROW_1_Left_54 VGND VGND VPWR VPWR sky130_fd_sc_hd__decap_3
Xinput16 A[23] VGND VGND VPWR VPWR _0947_/B sky130_fd_sc_hd__clkdlybuf4s25_1
Xinput27 A[4] VGND VGND VPWR VPWR input27/X sky130_fd_sc_hd__buf_6
Xinput38 B[14] VGND VGND VPWR VPWR _0998_/A sky130_fd_sc_hd__clkdlybuf4s25_1
Xinput49 B[24] VGND VGND VPWR VPWR _1059_/A sky130_fd_sc_hd__clkdlybuf4s25_1
X_1221_ _1220_/A _1137_/B _1220_/Y VGND VGND VPWR VPWR _1221_/Y sky130_fd_sc_hd__o21ai_2
XFILLER_37_203 VGND VGND VPWR VPWR sky130_fd_sc_hd__decap_3
X_1152_ _1154_/A _1151_/X _1561_/A1 VGND VGND VPWR VPWR _1152_/Y sky130_fd_sc_hd__a21oi_2
X_1083_ _1076_/X _1081_/X _1145_/S VGND VGND VPWR VPWR _1083_/X sky130_fd_sc_hd__mux2_2
XFILLER_20_125 VGND VGND VPWR VPWR sky130_fd_sc_hd__decap_3
XFILLER_20_147 VGND VGND VPWR VPWR sky130_fd_sc_hd__decap_3
XFILLER_20_169 VGND VGND VPWR VPWR sky130_fd_sc_hd__decap_3
X_0936_ _0938_/A _0947_/B VGND VGND VPWR VPWR _0939_/A sky130_fd_sc_hd__or2_2
XTAP_TAPCELL_ROW_15_194 VGND VPWR sky130_fd_sc_hd__tapvpwrvgnd_1
XFILLER_9_181 VGND VGND VPWR VPWR sky130_fd_sc_hd__fill_1
X_0867_ _0867_/A input1/X VGND VGND VPWR VPWR _1102_/A sky130_fd_sc_hd__nand2_2
X_1419_ _1526_/S _1419_/B VGND VGND VPWR VPWR _1419_/Y sky130_fd_sc_hd__nand2_2
XPHY_EDGE_ROW_43_Left_96 VGND VGND VPWR VPWR sky130_fd_sc_hd__decap_3
XFILLER_36_291 VGND VGND VPWR VPWR sky130_fd_sc_hd__decap_3
XFILLER_51_261 VGND VGND VPWR VPWR sky130_fd_sc_hd__decap_3
XFILLER_11_169 VGND VGND VPWR VPWR sky130_fd_sc_hd__fill_1
XFILLER_22_43 VGND VGND VPWR VPWR sky130_fd_sc_hd__decap_3
XFILLER_22_65 VGND VGND VPWR VPWR sky130_fd_sc_hd__fill_2
XFILLER_3_302 VGND VGND VPWR VPWR sky130_fd_sc_hd__decap_3
XFILLER_7_129 VGND VGND VPWR VPWR sky130_fd_sc_hd__fill_2
XFILLER_0_3 VGND VGND VPWR VPWR sky130_fd_sc_hd__decap_3
XFILLER_19_258 VGND VGND VPWR VPWR sky130_fd_sc_hd__decap_3
XFILLER_34_206 VGND VGND VPWR VPWR sky130_fd_sc_hd__decap_3
XFILLER_34_228 VGND VGND VPWR VPWR sky130_fd_sc_hd__decap_3
XFILLER_47_51 VGND VGND VPWR VPWR sky130_fd_sc_hd__decap_3
Xfanout193 _0959_/B VGND VGND VPWR VPWR _0859_/S sky130_fd_sc_hd__buf_6
XTAP_TAPCELL_ROW_29_275 VGND VPWR sky130_fd_sc_hd__tapvpwrvgnd_1
XFILLER_27_291 VGND VGND VPWR VPWR sky130_fd_sc_hd__fill_2
XFILLER_42_294 VGND VGND VPWR VPWR sky130_fd_sc_hd__decap_3
XFILLER_8_12 VGND VGND VPWR VPWR sky130_fd_sc_hd__decap_3
XFILLER_8_56 VGND VGND VPWR VPWR sky130_fd_sc_hd__decap_3
XFILLER_6_173 VGND VGND VPWR VPWR sky130_fd_sc_hd__decap_3
X_1204_ _1204_/A _1204_/B VGND VGND VPWR VPWR _1210_/A sky130_fd_sc_hd__nand2_2
XFILLER_25_206 VGND VGND VPWR VPWR sky130_fd_sc_hd__decap_3
XFILLER_25_228 VGND VGND VPWR VPWR sky130_fd_sc_hd__decap_3
X_1135_ _0965_/B _0957_/B _1135_/S VGND VGND VPWR VPWR _1135_/X sky130_fd_sc_hd__mux2_1
X_1066_ _1275_/B _1657_/A _1069_/C VGND VGND VPWR VPWR _1066_/Y sky130_fd_sc_hd__a21oi_2
X_0919_ _0919_/A _0919_/B VGND VGND VPWR VPWR _0920_/B sky130_fd_sc_hd__nor2_2
XFILLER_0_305 VGND VGND VPWR VPWR sky130_fd_sc_hd__decap_3
XFILLER_16_239 VGND VGND VPWR VPWR sky130_fd_sc_hd__decap_3
XFILLER_48_309 VGND VGND VPWR VPWR sky130_fd_sc_hd__fill_1
XTAP_TAPCELL_ROW_3_132 VGND VPWR sky130_fd_sc_hd__tapvpwrvgnd_1
XFILLER_17_87 VGND VGND VPWR VPWR sky130_fd_sc_hd__decap_3
XFILLER_24_250 VGND VGND VPWR VPWR sky130_fd_sc_hd__fill_2
XFILLER_24_261 VGND VGND VPWR VPWR sky130_fd_sc_hd__decap_3
XFILLER_33_31 VGND VGND VPWR VPWR sky130_fd_sc_hd__decap_3
XTAP_TAPCELL_ROW_26_256 VGND VPWR sky130_fd_sc_hd__tapvpwrvgnd_1
XFILLER_30_253 VGND VGND VPWR VPWR sky130_fd_sc_hd__decap_3
XTAP_TAPCELL_ROW_0_113 VGND VPWR sky130_fd_sc_hd__tapvpwrvgnd_1
X_1118_ _1175_/A _1115_/X _1117_/X _1226_/B VGND VGND VPWR VPWR _1118_/X sky130_fd_sc_hd__a22o_2
X_1049_ _1479_/A _1479_/B VGND VGND VPWR VPWR _1049_/X sky130_fd_sc_hd__or2_2
Xrebuffer524 _1669_/C VGND VGND VPWR VPWR output76/A sky130_fd_sc_hd__buf_6
XFILLER_0_113 VGND VGND VPWR VPWR sky130_fd_sc_hd__decap_3
XFILLER_28_64 VGND VGND VPWR VPWR sky130_fd_sc_hd__fill_1
XFILLER_28_97 VGND VGND VPWR VPWR sky130_fd_sc_hd__fill_1
XFILLER_44_41 VGND VGND VPWR VPWR sky130_fd_sc_hd__decap_3
XFILLER_44_74 VGND VGND VPWR VPWR sky130_fd_sc_hd__decap_3
XFILLER_8_235 VGND VGND VPWR VPWR sky130_fd_sc_hd__decap_3
XPHY_EDGE_ROW_30_Left_83 VGND VGND VPWR VPWR sky130_fd_sc_hd__decap_3
XFILLER_5_24 VGND VGND VPWR VPWR sky130_fd_sc_hd__decap_3
XFILLER_5_57 VGND VGND VPWR VPWR sky130_fd_sc_hd__decap_3
XTAP_TAPCELL_ROW_37_318 VGND VPWR sky130_fd_sc_hd__tapvpwrvgnd_1
XFILLER_47_194 VGND VGND VPWR VPWR sky130_fd_sc_hd__decap_3
XFILLER_50_304 VGND VGND VPWR VPWR sky130_fd_sc_hd__decap_3
XTAP_TAPCELL_ROW_45_362 VGND VPWR sky130_fd_sc_hd__tapvpwrvgnd_1
X_1667_ _1395_/Y _1666_/X _0831_/Y VGND VGND VPWR VPWR _1668_/D sky130_fd_sc_hd__o21a_2
Xload_slew160 _0852_/A VGND VGND VPWR VPWR _1598_/A sky130_fd_sc_hd__buf_4
Xload_slew171 input55/X VGND VGND VPWR VPWR _1243_/S sky130_fd_sc_hd__clkbuf_4
X_1598_ _1598_/A _1598_/B VGND VGND VPWR VPWR _1598_/Y sky130_fd_sc_hd__nor2_2
XFILLER_38_172 VGND VGND VPWR VPWR sky130_fd_sc_hd__decap_3
XFILLER_41_304 VGND VGND VPWR VPWR sky130_fd_sc_hd__decap_3
XFILLER_14_66 VGND VGND VPWR VPWR sky130_fd_sc_hd__decap_3
XFILLER_14_88 VGND VGND VPWR VPWR sky130_fd_sc_hd__decap_3
XFILLER_30_21 VGND VGND VPWR VPWR sky130_fd_sc_hd__fill_1
XFILLER_30_32 VGND VGND VPWR VPWR sky130_fd_sc_hd__fill_2
XFILLER_30_43 VGND VGND VPWR VPWR sky130_fd_sc_hd__decap_3
XFILLER_30_76 VGND VGND VPWR VPWR sky130_fd_sc_hd__decap_3
XFILLER_5_216 VGND VGND VPWR VPWR sky130_fd_sc_hd__decap_3
Xrebuffer387 _1580_/X VGND VGND VPWR VPWR _1594_/C sky130_fd_sc_hd__buf_2
Xrebuffer343 _1254_/B VGND VGND VPWR VPWR _1181_/B sky130_fd_sc_hd__buf_2
XFILLER_29_161 VGND VGND VPWR VPWR sky130_fd_sc_hd__decap_3
XFILLER_39_85 VGND VGND VPWR VPWR sky130_fd_sc_hd__decap_3
XFILLER_44_175 VGND VGND VPWR VPWR sky130_fd_sc_hd__decap_3
XFILLER_44_197 VGND VGND VPWR VPWR sky130_fd_sc_hd__decap_3
XTAP_TAPCELL_ROW_42_343 VGND VPWR sky130_fd_sc_hd__tapvpwrvgnd_1
XFILLER_4_260 VGND VGND VPWR VPWR sky130_fd_sc_hd__decap_3
XFILLER_4_293 VGND VGND VPWR VPWR sky130_fd_sc_hd__decap_3
X_1521_ _0934_/A _0941_/B _1585_/A3 _1537_/A VGND VGND VPWR VPWR _1521_/X sky130_fd_sc_hd__a31o_2
X_1452_ _1452_/A _1452_/B VGND VGND VPWR VPWR _1452_/Y sky130_fd_sc_hd__nor2_2
X_1383_ _1585_/A3 _1408_/A _1381_/X _1261_/A _1382_/Y VGND VGND VPWR VPWR _1383_/X
+ sky130_fd_sc_hd__a221o_2
XFILLER_41_167 VGND VGND VPWR VPWR sky130_fd_sc_hd__fill_1
XFILLER_41_31 VGND VGND VPWR VPWR sky130_fd_sc_hd__decap_3
XFILLER_1_252 VGND VGND VPWR VPWR sky130_fd_sc_hd__decap_3
XFILLER_49_223 VGND VGND VPWR VPWR sky130_fd_sc_hd__fill_1
XFILLER_1_296 VGND VGND VPWR VPWR sky130_fd_sc_hd__decap_3
XFILLER_2_47 VGND VGND VPWR VPWR sky130_fd_sc_hd__decap_3
XFILLER_49_245 VGND VGND VPWR VPWR sky130_fd_sc_hd__decap_3
XFILLER_49_278 VGND VGND VPWR VPWR sky130_fd_sc_hd__fill_2
XFILLER_20_307 VGND VGND VPWR VPWR sky130_fd_sc_hd__fill_1
X_0952_ _0952_/A _0952_/B VGND VGND VPWR VPWR _1208_/A sky130_fd_sc_hd__xnor2_4
X_1504_ _1643_/A1 _0929_/A _1496_/A _1555_/B2 VGND VGND VPWR VPWR _1504_/X sky130_fd_sc_hd__a22o_2
X_0883_ _0959_/B input1/X _1632_/A3 _0882_/Y _0873_/X VGND VGND VPWR VPWR _0883_/X
+ sky130_fd_sc_hd__a311o_2
X_1435_ _1434_/X _1086_/X _0831_/Y VGND VGND VPWR VPWR _1438_/C sky130_fd_sc_hd__o21a_4
X_1366_ _1570_/A1 _1360_/X _1365_/X VGND VGND VPWR VPWR _1366_/X sky130_fd_sc_hd__a21o_2
X_1297_ _1416_/B _1120_/A _1247_/A VGND VGND VPWR VPWR _1591_/B sky130_fd_sc_hd__o21ai_2
XFILLER_23_167 VGND VGND VPWR VPWR sky130_fd_sc_hd__fill_1
XFILLER_11_89 VGND VGND VPWR VPWR sky130_fd_sc_hd__decap_3
XFILLER_46_248 VGND VGND VPWR VPWR sky130_fd_sc_hd__decap_3
XFILLER_46_259 VGND VGND VPWR VPWR sky130_fd_sc_hd__decap_3
XFILLER_14_134 VGND VGND VPWR VPWR sky130_fd_sc_hd__decap_3
XFILLER_52_41 VGND VGND VPWR VPWR sky130_fd_sc_hd__decap_3
XFILLER_52_63 VGND VGND VPWR VPWR sky130_fd_sc_hd__decap_3
XFILLER_52_85 VGND VGND VPWR VPWR sky130_fd_sc_hd__fill_2
Xinput17 A[24] VGND VGND VPWR VPWR _1059_/B sky130_fd_sc_hd__clkdlybuf4s25_1
Xinput28 A[5] VGND VGND VPWR VPWR _0985_/B sky130_fd_sc_hd__clkbuf_2
Xinput39 B[15] VGND VGND VPWR VPWR _1001_/A sky130_fd_sc_hd__clkdlybuf4s25_1
X_1220_ _1220_/A _1220_/B VGND VGND VPWR VPWR _1220_/Y sky130_fd_sc_hd__nand2_2
X_1151_ _1133_/B _1129_/X _0963_/B VGND VGND VPWR VPWR _1151_/X sky130_fd_sc_hd__o21a_2
XFILLER_45_281 VGND VGND VPWR VPWR sky130_fd_sc_hd__decap_3
X_1082_ _1116_/A _1082_/B VGND VGND VPWR VPWR _1246_/D sky130_fd_sc_hd__nand2_2
XFILLER_20_137 VGND VGND VPWR VPWR sky130_fd_sc_hd__decap_3
X_0935_ _0935_/A _1533_/A VGND VGND VPWR VPWR _1548_/A sky130_fd_sc_hd__nand2_2
X_0866_ _1275_/B _1069_/B _0878_/D _1069_/C VGND VGND VPWR VPWR _1601_/A sky130_fd_sc_hd__or4b_2
XTAP_TAPCELL_ROW_15_195 VGND VPWR sky130_fd_sc_hd__tapvpwrvgnd_1
XFILLER_43_207 VGND VGND VPWR VPWR sky130_fd_sc_hd__decap_3
X_1418_ _1598_/A _1526_/S _1418_/C VGND VGND VPWR VPWR _1418_/X sky130_fd_sc_hd__and3_2
X_1349_ _1352_/A _1349_/B _1329_/C VGND VGND VPWR VPWR _1349_/X sky130_fd_sc_hd__or3b_2
XFILLER_11_137 VGND VGND VPWR VPWR sky130_fd_sc_hd__fill_2
XFILLER_51_273 VGND VGND VPWR VPWR sky130_fd_sc_hd__decap_3
XFILLER_51_284 VGND VGND VPWR VPWR sky130_fd_sc_hd__decap_3
XFILLER_47_30 VGND VGND VPWR VPWR sky130_fd_sc_hd__decap_3
Xfanout150 _0831_/Y VGND VGND VPWR VPWR _1591_/A sky130_fd_sc_hd__clkbuf_4
Xfanout161 _1379_/A VGND VGND VPWR VPWR _1416_/B sky130_fd_sc_hd__clkdlybuf4s25_1
Xfanout172 input5/X VGND VGND VPWR VPWR _1358_/A0 sky130_fd_sc_hd__buf_6
Xfanout183 input4/X VGND VGND VPWR VPWR _1358_/A1 sky130_fd_sc_hd__buf_6
XFILLER_27_270 VGND VGND VPWR VPWR sky130_fd_sc_hd__fill_1
XFILLER_34_218 VGND VGND VPWR VPWR sky130_fd_sc_hd__decap_3
XFILLER_42_251 VGND VGND VPWR VPWR sky130_fd_sc_hd__fill_1
XFILLER_42_262 VGND VGND VPWR VPWR sky130_fd_sc_hd__decap_3
XFILLER_8_24 VGND VGND VPWR VPWR sky130_fd_sc_hd__decap_3
XFILLER_8_35 VGND VGND VPWR VPWR sky130_fd_sc_hd__decap_3
XFILLER_8_68 VGND VGND VPWR VPWR sky130_fd_sc_hd__fill_2
XFILLER_8_79 VGND VGND VPWR VPWR sky130_fd_sc_hd__decap_3
XFILLER_10_192 VGND VGND VPWR VPWR sky130_fd_sc_hd__decap_3
XFILLER_6_141 VGND VGND VPWR VPWR sky130_fd_sc_hd__fill_2
X_1203_ _1133_/A _1192_/A _1201_/A _0882_/B VGND VGND VPWR VPWR _1204_/B sky130_fd_sc_hd__o22a_2
X_1134_ _1134_/A input1/X VGND VGND VPWR VPWR _1134_/Y sky130_fd_sc_hd__nand2_2
XFILLER_33_284 VGND VGND VPWR VPWR sky130_fd_sc_hd__decap_3
X_1065_ _1657_/A _0901_/B _1627_/A _1627_/B _0902_/X VGND VGND VPWR VPWR _1065_/X
+ sky130_fd_sc_hd__o41a_4
X_0918_ _0919_/A _0919_/B VGND VGND VPWR VPWR _1581_/A sky130_fd_sc_hd__nand2_2
X_0849_ _1337_/A0 _1358_/A0 input6/X input7/X _1158_/S0 _1432_/S1 VGND VGND VPWR VPWR
+ _0849_/X sky130_fd_sc_hd__mux4_2
XFILLER_17_33 VGND VGND VPWR VPWR sky130_fd_sc_hd__fill_2
XFILLER_17_55 VGND VGND VPWR VPWR sky130_fd_sc_hd__fill_1
XFILLER_33_76 VGND VGND VPWR VPWR sky130_fd_sc_hd__fill_2
XTAP_TAPCELL_ROW_26_257 VGND VPWR sky130_fd_sc_hd__tapvpwrvgnd_1
XFILLER_12_9 VGND VGND VPWR VPWR sky130_fd_sc_hd__decap_3
XFILLER_30_298 VGND VGND VPWR VPWR sky130_fd_sc_hd__fill_1
X_1117_ _1116_/C _1243_/S VGND VGND VPWR VPWR _1117_/X sky130_fd_sc_hd__and2b_2
XTAP_TAPCELL_ROW_0_114 VGND VPWR sky130_fd_sc_hd__tapvpwrvgnd_1
XFILLER_21_210 VGND VGND VPWR VPWR sky130_fd_sc_hd__decap_3
X_1048_ _1048_/A _1048_/B VGND VGND VPWR VPWR _1048_/Y sky130_fd_sc_hd__nand2_2
XTAP_TAPCELL_ROW_23_238 VGND VPWR sky130_fd_sc_hd__tapvpwrvgnd_1
XPHY_EDGE_ROW_3_Right_3 VGND VGND VPWR VPWR sky130_fd_sc_hd__decap_3
Xrebuffer525 fanout178/X VGND VGND VPWR VPWR _0958_/B sky130_fd_sc_hd__buf_8
XTAP_TAPCELL_ROW_31_282 VGND VPWR sky130_fd_sc_hd__tapvpwrvgnd_1
XFILLER_0_169 VGND VGND VPWR VPWR sky130_fd_sc_hd__fill_1
XFILLER_44_20 VGND VGND VPWR VPWR sky130_fd_sc_hd__decap_3
XFILLER_44_53 VGND VGND VPWR VPWR sky130_fd_sc_hd__fill_2
XFILLER_12_232 VGND VGND VPWR VPWR sky130_fd_sc_hd__decap_3
XFILLER_8_203 VGND VGND VPWR VPWR sky130_fd_sc_hd__decap_3
XFILLER_5_36 VGND VGND VPWR VPWR sky130_fd_sc_hd__decap_3
XFILLER_10_6 VGND VGND VPWR VPWR sky130_fd_sc_hd__decap_3
XTAP_TAPCELL_ROW_37_319 VGND VPWR sky130_fd_sc_hd__tapvpwrvgnd_1
XTAP_TAPCELL_ROW_45_363 VGND VPWR sky130_fd_sc_hd__tapvpwrvgnd_1
X_1666_ _1526_/S _1540_/X _1665_/X _0877_/X VGND VGND VPWR VPWR _1666_/X sky130_fd_sc_hd__o211a_2
Xload_slew194 _0859_/S VGND VGND VPWR VPWR _1090_/S sky130_fd_sc_hd__buf_6
X_1597_ _1620_/A _1597_/B _1597_/C VGND VGND VPWR VPWR _1597_/Y sky130_fd_sc_hd__nand3b_2
XFILLER_38_195 VGND VGND VPWR VPWR sky130_fd_sc_hd__fill_1
XFILLER_14_23 VGND VGND VPWR VPWR sky130_fd_sc_hd__decap_3
XFILLER_5_228 VGND VGND VPWR VPWR sky130_fd_sc_hd__decap_3
Xrebuffer344 _0972_/B VGND VGND VPWR VPWR _1254_/B sky130_fd_sc_hd__buf_2
XFILLER_30_55 VGND VGND VPWR VPWR sky130_fd_sc_hd__decap_3
Xrebuffer388 _1563_/X VGND VGND VPWR VPWR rebuffer388/X sky130_fd_sc_hd__buf_6
XFILLER_29_140 VGND VGND VPWR VPWR sky130_fd_sc_hd__decap_3
XFILLER_39_97 VGND VGND VPWR VPWR sky130_fd_sc_hd__decap_3
XFILLER_44_110 VGND VGND VPWR VPWR sky130_fd_sc_hd__decap_3
XFILLER_44_121 VGND VGND VPWR VPWR sky130_fd_sc_hd__decap_3
XFILLER_32_305 VGND VGND VPWR VPWR sky130_fd_sc_hd__decap_3
XTAP_TAPCELL_ROW_42_344 VGND VPWR sky130_fd_sc_hd__tapvpwrvgnd_1
X_1520_ _1535_/A _1548_/A _0935_/A _1643_/A1 VGND VGND VPWR VPWR _1520_/X sky130_fd_sc_hd__a2bb2o_2
XFILLER_4_272 VGND VGND VPWR VPWR sky130_fd_sc_hd__decap_3
X_1451_ _1450_/B _1450_/C _1479_/A VGND VGND VPWR VPWR _1451_/X sky130_fd_sc_hd__a21bo_2
X_1382_ _1601_/A _0999_/A _1406_/A _1535_/A VGND VGND VPWR VPWR _1382_/Y sky130_fd_sc_hd__o22ai_2
XFILLER_35_132 VGND VGND VPWR VPWR sky130_fd_sc_hd__decap_3
XFILLER_35_154 VGND VGND VPWR VPWR sky130_fd_sc_hd__fill_2
XFILLER_35_165 VGND VGND VPWR VPWR sky130_fd_sc_hd__decap_3
XFILLER_50_102 VGND VGND VPWR VPWR sky130_fd_sc_hd__decap_3
X_1649_ _1378_/X _1419_/B _1648_/X VGND VGND VPWR VPWR _1649_/X sky130_fd_sc_hd__a21o_2
XFILLER_25_55 VGND VGND VPWR VPWR sky130_fd_sc_hd__fill_1
XFILLER_41_113 VGND VGND VPWR VPWR sky130_fd_sc_hd__decap_3
XFILLER_41_135 VGND VGND VPWR VPWR sky130_fd_sc_hd__fill_1
XFILLER_41_43 VGND VGND VPWR VPWR sky130_fd_sc_hd__decap_3
XFILLER_1_231 VGND VGND VPWR VPWR sky130_fd_sc_hd__decap_3
XFILLER_1_264 VGND VGND VPWR VPWR sky130_fd_sc_hd__decap_3
XFILLER_2_15 VGND VGND VPWR VPWR sky130_fd_sc_hd__decap_3
XFILLER_49_257 VGND VGND VPWR VPWR sky130_fd_sc_hd__decap_3
XFILLER_17_143 VGND VGND VPWR VPWR sky130_fd_sc_hd__fill_1
XFILLER_17_165 VGND VGND VPWR VPWR sky130_fd_sc_hd__decap_3
XFILLER_32_102 VGND VGND VPWR VPWR sky130_fd_sc_hd__decap_3
X_0951_ _0952_/A _0951_/B VGND VGND VPWR VPWR _0951_/Y sky130_fd_sc_hd__nand2_2
X_0882_ _1266_/B _0882_/B VGND VGND VPWR VPWR _0882_/Y sky130_fd_sc_hd__nor2_2
X_1503_ _1418_/C _1502_/X _1198_/X VGND VGND VPWR VPWR _1503_/Y sky130_fd_sc_hd__a21oi_2
X_1434_ _1266_/A _1433_/X _1430_/X _1418_/C VGND VGND VPWR VPWR _1434_/X sky130_fd_sc_hd__o211a_2
X_1365_ _1374_/A _1357_/X _1362_/X _1261_/A _1364_/Y VGND VGND VPWR VPWR _1365_/X
+ sky130_fd_sc_hd__a221o_2
X_1296_ _1295_/B _1295_/C _1333_/B VGND VGND VPWR VPWR _1296_/X sky130_fd_sc_hd__a21o_2
XFILLER_23_113 VGND VGND VPWR VPWR sky130_fd_sc_hd__decap_3
XFILLER_23_135 VGND VGND VPWR VPWR sky130_fd_sc_hd__decap_3
XFILLER_11_24 VGND VGND VPWR VPWR sky130_fd_sc_hd__decap_3
XFILLER_11_46 VGND VGND VPWR VPWR sky130_fd_sc_hd__decap_3
XFILLER_11_57 VGND VGND VPWR VPWR sky130_fd_sc_hd__decap_3
XFILLER_31_190 VGND VGND VPWR VPWR sky130_fd_sc_hd__fill_1
XFILLER_36_32 VGND VGND VPWR VPWR sky130_fd_sc_hd__decap_3
XFILLER_36_54 VGND VGND VPWR VPWR sky130_fd_sc_hd__decap_3
XFILLER_36_76 VGND VGND VPWR VPWR sky130_fd_sc_hd__decap_3
XFILLER_52_53 VGND VGND VPWR VPWR sky130_fd_sc_hd__decap_3
Xinput18 A[25] VGND VGND VPWR VPWR _0919_/B sky130_fd_sc_hd__clkdlybuf4s25_1
Xinput29 A[6] VGND VGND VPWR VPWR input29/X sky130_fd_sc_hd__dlygate4sd1_1
X_1150_ _1392_/C _1147_/X _1149_/X _1080_/Y VGND VGND VPWR VPWR _1150_/X sky130_fd_sc_hd__a22o_4
XTAP_TAPCELL_ROW_9_161 VGND VPWR sky130_fd_sc_hd__tapvpwrvgnd_1
XFILLER_45_293 VGND VGND VPWR VPWR sky130_fd_sc_hd__decap_3
X_1081_ _1076_/S _1392_/A VGND VGND VPWR VPWR _1081_/X sky130_fd_sc_hd__and2b_2
XFILLER_9_161 VGND VGND VPWR VPWR sky130_fd_sc_hd__decap_3
XFILLER_9_172 VGND VGND VPWR VPWR sky130_fd_sc_hd__decap_3
X_0934_ _0934_/A _0941_/B VGND VGND VPWR VPWR _1533_/A sky130_fd_sc_hd__nand2_2
X_0865_ _0878_/D _1069_/C _1313_/A _0878_/C VGND VGND VPWR VPWR _0865_/X sky130_fd_sc_hd__and4b_2
XTAP_TAPCELL_ROW_15_196 VGND VPWR sky130_fd_sc_hd__tapvpwrvgnd_1
X_1417_ _1591_/A _1417_/B VGND VGND VPWR VPWR _1419_/B sky130_fd_sc_hd__nor2_2
XFILLER_28_205 VGND VGND VPWR VPWR sky130_fd_sc_hd__decap_3
XFILLER_3_80 VGND VGND VPWR VPWR sky130_fd_sc_hd__fill_1
XFILLER_43_219 VGND VGND VPWR VPWR sky130_fd_sc_hd__decap_3
X_1348_ _1348_/A _1348_/B _1348_/C VGND VGND VPWR VPWR _1669_/D sky130_fd_sc_hd__or3_4
X_1279_ _1072_/X _1089_/X _1472_/A VGND VGND VPWR VPWR _1279_/X sky130_fd_sc_hd__mux2_2
XFILLER_22_34 VGND VGND VPWR VPWR sky130_fd_sc_hd__fill_1
XFILLER_36_282 VGND VGND VPWR VPWR sky130_fd_sc_hd__decap_3
XFILLER_51_296 VGND VGND VPWR VPWR sky130_fd_sc_hd__decap_3
XFILLER_47_42 VGND VGND VPWR VPWR sky130_fd_sc_hd__decap_3
Xfanout162 _1379_/A VGND VGND VPWR VPWR _1266_/A sky130_fd_sc_hd__clkdlybuf4s25_1
Xfanout173 wire177/A VGND VGND VPWR VPWR _0850_/S1 sky130_fd_sc_hd__clkdlybuf4s25_1
Xfanout184 fanout184/A VGND VGND VPWR VPWR _1158_/S0 sky130_fd_sc_hd__buf_8
Xfanout195 _0959_/B VGND VGND VPWR VPWR _1135_/S sky130_fd_sc_hd__dlymetal6s2s_1
XFILLER_42_274 VGND VGND VPWR VPWR sky130_fd_sc_hd__decap_3
XFILLER_6_120 VGND VGND VPWR VPWR sky130_fd_sc_hd__fill_1
XFILLER_8_47 VGND VGND VPWR VPWR sky130_fd_sc_hd__decap_3
XTAP_TAPCELL_ROW_12_177 VGND VPWR sky130_fd_sc_hd__tapvpwrvgnd_1
X_1202_ _1601_/A _0950_/Y _0951_/Y _1452_/A VGND VGND VPWR VPWR _1204_/A sky130_fd_sc_hd__o22a_2
X_1133_ _1133_/A _1133_/B VGND VGND VPWR VPWR _1133_/Y sky130_fd_sc_hd__nor2_2
X_1064_ _1057_/Y _1063_/Y _0925_/Y VGND VGND VPWR VPWR _1627_/B sky130_fd_sc_hd__a21oi_4
XFILLER_33_252 VGND VGND VPWR VPWR sky130_fd_sc_hd__decap_3
XFILLER_33_274 VGND VGND VPWR VPWR sky130_fd_sc_hd__decap_3
XFILLER_33_296 VGND VGND VPWR VPWR sky130_fd_sc_hd__decap_3
X_0917_ _0919_/A _0919_/B VGND VGND VPWR VPWR _0920_/A sky130_fd_sc_hd__and2_2
X_0848_ _1270_/A _0848_/B _1275_/C VGND VGND VPWR VPWR _0848_/X sky130_fd_sc_hd__and3_2
XTAP_TAPCELL_ROW_26_258 VGND VPWR sky130_fd_sc_hd__tapvpwrvgnd_1
XFILLER_33_22 VGND VGND VPWR VPWR sky130_fd_sc_hd__decap_3
XFILLER_15_252 VGND VGND VPWR VPWR sky130_fd_sc_hd__fill_2
XFILLER_15_274 VGND VGND VPWR VPWR sky130_fd_sc_hd__decap_3
X_1682_ _1682_/A _1682_/B _1682_/C _1682_/D VGND VGND VPWR VPWR _1682_/Y sky130_fd_sc_hd__nor4_4
Xmax_cap104 _0881_/B VGND VGND VPWR VPWR _1570_/A1 sky130_fd_sc_hd__clkbuf_4
Xmax_cap126 _1309_/A VGND VGND VPWR VPWR _1333_/A sky130_fd_sc_hd__clkbuf_2
XFILLER_38_300 VGND VGND VPWR VPWR sky130_fd_sc_hd__decap_3
X_1116_ _1116_/A _1243_/S _1116_/C _1116_/D VGND VGND VPWR VPWR _1116_/X sky130_fd_sc_hd__and4_2
X_1047_ _1048_/A _1048_/B VGND VGND VPWR VPWR _1479_/B sky130_fd_sc_hd__and2_2
XTAP_TAPCELL_ROW_0_115 VGND VPWR sky130_fd_sc_hd__tapvpwrvgnd_1
XFILLER_9_90 VGND VGND VPWR VPWR sky130_fd_sc_hd__decap_3
Xrebuffer526 fanout180/X VGND VGND VPWR VPWR _1264_/S1 sky130_fd_sc_hd__buf_2
XTAP_TAPCELL_ROW_31_283 VGND VPWR sky130_fd_sc_hd__tapvpwrvgnd_1
XTAP_TAPCELL_ROW_23_239 VGND VPWR sky130_fd_sc_hd__tapvpwrvgnd_1
XFILLER_28_44 VGND VGND VPWR VPWR sky130_fd_sc_hd__decap_3
XFILLER_28_55 VGND VGND VPWR VPWR sky130_fd_sc_hd__decap_3
XFILLER_28_88 VGND VGND VPWR VPWR sky130_fd_sc_hd__decap_3
XFILLER_44_32 VGND VGND VPWR VPWR sky130_fd_sc_hd__decap_3
XFILLER_44_65 VGND VGND VPWR VPWR sky130_fd_sc_hd__decap_3
XFILLER_12_266 VGND VGND VPWR VPWR sky130_fd_sc_hd__fill_1
XFILLER_5_15 VGND VGND VPWR VPWR sky130_fd_sc_hd__decap_3
XFILLER_8_215 VGND VGND VPWR VPWR sky130_fd_sc_hd__fill_1
XFILLER_8_226 VGND VGND VPWR VPWR sky130_fd_sc_hd__fill_1
XFILLER_8_259 VGND VGND VPWR VPWR sky130_fd_sc_hd__decap_3
XFILLER_39_119 VGND VGND VPWR VPWR sky130_fd_sc_hd__fill_1
XFILLER_5_48 VGND VGND VPWR VPWR sky130_fd_sc_hd__fill_1
XPHY_EDGE_ROW_13_Right_13 VGND VGND VPWR VPWR sky130_fd_sc_hd__decap_3
XPHY_EDGE_ROW_22_Right_22 VGND VGND VPWR VPWR sky130_fd_sc_hd__decap_3
X_1665_ _1243_/S _1600_/X _1664_/X VGND VGND VPWR VPWR _1665_/X sky130_fd_sc_hd__a21o_2
X_1596_ _1597_/B _1597_/C _1620_/A VGND VGND VPWR VPWR _1596_/X sky130_fd_sc_hd__a21bo_2
XFILLER_38_141 VGND VGND VPWR VPWR sky130_fd_sc_hd__decap_3
Xload_slew140 _1144_/S VGND VGND VPWR VPWR _1588_/S sky130_fd_sc_hd__clkbuf_4
XPHY_EDGE_ROW_31_Right_31 VGND VGND VPWR VPWR sky130_fd_sc_hd__decap_3
Xrebuffer389 rebuffer391/X VGND VGND VPWR VPWR output88/A sky130_fd_sc_hd__buf_6
Xrebuffer345 _0971_/A VGND VGND VPWR VPWR _1191_/A sky130_fd_sc_hd__buf_2
XPHY_EDGE_ROW_40_Right_40 VGND VGND VPWR VPWR sky130_fd_sc_hd__decap_3
XFILLER_30_67 VGND VGND VPWR VPWR sky130_fd_sc_hd__decap_3
XFILLER_39_65 VGND VGND VPWR VPWR sky130_fd_sc_hd__fill_2
XFILLER_29_185 VGND VGND VPWR VPWR sky130_fd_sc_hd__decap_3
XFILLER_44_144 VGND VGND VPWR VPWR sky130_fd_sc_hd__decap_3
XFILLER_44_155 VGND VGND VPWR VPWR sky130_fd_sc_hd__decap_3
XTAP_TAPCELL_ROW_42_345 VGND VPWR sky130_fd_sc_hd__tapvpwrvgnd_1
XFILLER_4_284 VGND VGND VPWR VPWR sky130_fd_sc_hd__decap_3
X_1450_ _1479_/A _1450_/B _1450_/C VGND VGND VPWR VPWR _1450_/Y sky130_fd_sc_hd__nand3b_2
X_1381_ _1226_/B _1226_/C _1275_/X _1379_/X _1380_/X VGND VGND VPWR VPWR _1381_/X
+ sky130_fd_sc_hd__a32o_2
X_1648_ _0831_/Y _1381_/X _1416_/X _1525_/X _1647_/X VGND VGND VPWR VPWR _1648_/X
+ sky130_fd_sc_hd__a221o_2
X_1579_ _1620_/B _1579_/B _1579_/C VGND VGND VPWR VPWR _1579_/Y sky130_fd_sc_hd__nand3_2
XFILLER_26_133 VGND VGND VPWR VPWR sky130_fd_sc_hd__decap_3
XFILLER_26_144 VGND VGND VPWR VPWR sky130_fd_sc_hd__decap_3
XFILLER_41_169 VGND VGND VPWR VPWR sky130_fd_sc_hd__decap_3
XFILLER_1_210 VGND VGND VPWR VPWR sky130_fd_sc_hd__decap_3
XFILLER_41_66 VGND VGND VPWR VPWR sky130_fd_sc_hd__fill_1
XFILLER_1_221 VGND VGND VPWR VPWR sky130_fd_sc_hd__decap_3
XFILLER_1_243 VGND VGND VPWR VPWR sky130_fd_sc_hd__decap_3
XFILLER_1_276 VGND VGND VPWR VPWR sky130_fd_sc_hd__decap_3
XFILLER_1_287 VGND VGND VPWR VPWR sky130_fd_sc_hd__decap_3
XFILLER_2_27 VGND VGND VPWR VPWR sky130_fd_sc_hd__fill_1
XFILLER_2_38 VGND VGND VPWR VPWR sky130_fd_sc_hd__decap_3
XFILLER_49_214 VGND VGND VPWR VPWR sky130_fd_sc_hd__decap_3
XFILLER_49_236 VGND VGND VPWR VPWR sky130_fd_sc_hd__decap_3
XFILLER_49_269 VGND VGND VPWR VPWR sky130_fd_sc_hd__decap_3
XFILLER_17_111 VGND VGND VPWR VPWR sky130_fd_sc_hd__fill_1
XFILLER_17_188 VGND VGND VPWR VPWR sky130_fd_sc_hd__decap_3
XFILLER_32_125 VGND VGND VPWR VPWR sky130_fd_sc_hd__decap_3
XFILLER_32_136 VGND VGND VPWR VPWR sky130_fd_sc_hd__decap_3
XFILLER_20_309 VGND VGND VPWR VPWR sky130_fd_sc_hd__fill_1
X_0950_ _0952_/A _0951_/B VGND VGND VPWR VPWR _0950_/Y sky130_fd_sc_hd__nor2_2
X_0881_ _1275_/A _0881_/B VGND VGND VPWR VPWR _0882_/B sky130_fd_sc_hd__nand2_2
XFILLER_49_3 VGND VGND VPWR VPWR sky130_fd_sc_hd__decap_3
X_1502_ _1359_/X _1501_/X _1502_/S VGND VGND VPWR VPWR _1502_/X sky130_fd_sc_hd__mux2_1
X_1433_ _1358_/X _1432_/X _1457_/S VGND VGND VPWR VPWR _1433_/X sky130_fd_sc_hd__mux2_1
XFILLER_48_280 VGND VGND VPWR VPWR sky130_fd_sc_hd__decap_3
X_1364_ _1452_/A _0991_/Y _1352_/A _1535_/A _1363_/Y VGND VGND VPWR VPWR _1364_/Y
+ sky130_fd_sc_hd__o221ai_2
X_1295_ _1333_/B _1295_/B _1295_/C VGND VGND VPWR VPWR _1295_/Y sky130_fd_sc_hd__nand3_2
XFILLER_23_147 VGND VGND VPWR VPWR sky130_fd_sc_hd__decap_3
XFILLER_23_169 VGND VGND VPWR VPWR sky130_fd_sc_hd__decap_3
XPHY_EDGE_ROW_52_Left_105 VGND VGND VPWR VPWR sky130_fd_sc_hd__decap_3
XFILLER_2_9 VGND VGND VPWR VPWR sky130_fd_sc_hd__decap_3
XFILLER_46_217 VGND VGND VPWR VPWR sky130_fd_sc_hd__decap_3
XFILLER_52_21 VGND VGND VPWR VPWR sky130_fd_sc_hd__decap_3
XFILLER_52_32 VGND VGND VPWR VPWR sky130_fd_sc_hd__decap_3
Xinput19 A[26] VGND VGND VPWR VPWR _0914_/B sky130_fd_sc_hd__clkdlybuf4s25_1
XTAP_TAPCELL_ROW_9_162 VGND VPWR sky130_fd_sc_hd__tapvpwrvgnd_1
XFILLER_37_206 VGND VGND VPWR VPWR sky130_fd_sc_hd__fill_1
X_1080_ _1313_/A _1246_/B VGND VGND VPWR VPWR _1080_/Y sky130_fd_sc_hd__nor2_2
XFILLER_20_128 VGND VGND VPWR VPWR sky130_fd_sc_hd__decap_3
XFILLER_45_250 VGND VGND VPWR VPWR sky130_fd_sc_hd__decap_3
XFILLER_45_272 VGND VGND VPWR VPWR sky130_fd_sc_hd__decap_3
X_0933_ _0934_/A _0941_/B VGND VGND VPWR VPWR _0935_/A sky130_fd_sc_hd__or2_2
X_0864_ _1069_/B _0878_/D VGND VGND VPWR VPWR _1104_/A sky130_fd_sc_hd__or2_2
XTAP_TAPCELL_ROW_15_197 VGND VPWR sky130_fd_sc_hd__tapvpwrvgnd_1
X_1416_ _1591_/A _1416_/B _1418_/C VGND VGND VPWR VPWR _1416_/X sky130_fd_sc_hd__and3_2
X_1347_ _1347_/A _1347_/B _1347_/C VGND VGND VPWR VPWR _1348_/C sky130_fd_sc_hd__or3_2
XFILLER_36_272 VGND VGND VPWR VPWR sky130_fd_sc_hd__decap_3
XFILLER_36_294 VGND VGND VPWR VPWR sky130_fd_sc_hd__decap_3
X_1278_ _1278_/A VGND VGND VPWR VPWR _1278_/Y sky130_fd_sc_hd__inv_2
XFILLER_22_24 VGND VGND VPWR VPWR sky130_fd_sc_hd__decap_3
XFILLER_22_46 VGND VGND VPWR VPWR sky130_fd_sc_hd__decap_3
XFILLER_51_264 VGND VGND VPWR VPWR sky130_fd_sc_hd__decap_3
XFILLER_0_6 VGND VGND VPWR VPWR sky130_fd_sc_hd__decap_3
XFILLER_3_305 VGND VGND VPWR VPWR sky130_fd_sc_hd__decap_3
XPHY_EDGE_ROW_5_Left_58 VGND VGND VPWR VPWR sky130_fd_sc_hd__decap_3
XFILLER_47_21 VGND VGND VPWR VPWR sky130_fd_sc_hd__decap_3
XFILLER_47_54 VGND VGND VPWR VPWR sky130_fd_sc_hd__fill_2
Xfanout141 _0833_/Y VGND VGND VPWR VPWR _1631_/A1 sky130_fd_sc_hd__buf_4
Xfanout152 input9/X VGND VGND VPWR VPWR _1034_/B sky130_fd_sc_hd__clkbuf_2
Xfanout163 _1379_/A VGND VGND VPWR VPWR _0955_/A sky130_fd_sc_hd__buf_4
Xfanout196 _0867_/A VGND VGND VPWR VPWR _0959_/B sky130_fd_sc_hd__buf_4
XFILLER_27_261 VGND VGND VPWR VPWR sky130_fd_sc_hd__decap_3
XFILLER_34_209 VGND VGND VPWR VPWR sky130_fd_sc_hd__decap_3
XFILLER_42_242 VGND VGND VPWR VPWR sky130_fd_sc_hd__decap_3
XFILLER_42_253 VGND VGND VPWR VPWR sky130_fd_sc_hd__decap_3
XFILLER_42_286 VGND VGND VPWR VPWR sky130_fd_sc_hd__fill_2
XFILLER_42_297 VGND VGND VPWR VPWR sky130_fd_sc_hd__decap_3
XFILLER_8_15 VGND VGND VPWR VPWR sky130_fd_sc_hd__decap_3
XFILLER_6_176 VGND VGND VPWR VPWR sky130_fd_sc_hd__decap_3
XFILLER_8_59 VGND VGND VPWR VPWR sky130_fd_sc_hd__decap_3
XTAP_TAPCELL_ROW_12_178 VGND VPWR sky130_fd_sc_hd__tapvpwrvgnd_1
X_1201_ _1201_/A VGND VGND VPWR VPWR _1201_/Y sky130_fd_sc_hd__inv_2
XFILLER_25_209 VGND VGND VPWR VPWR sky130_fd_sc_hd__decap_3
XFILLER_33_220 VGND VGND VPWR VPWR sky130_fd_sc_hd__decap_3
X_1132_ _1132_/A _1133_/B VGND VGND VPWR VPWR _1132_/X sky130_fd_sc_hd__or2_2
X_1063_ _1594_/A _1620_/B _1063_/C VGND VGND VPWR VPWR _1063_/Y sky130_fd_sc_hd__nor3_2
X_0916_ _1620_/B VGND VGND VPWR VPWR _0916_/Y sky130_fd_sc_hd__inv_2
X_0847_ _0878_/D _1069_/B _1069_/C VGND VGND VPWR VPWR _1246_/B sky130_fd_sc_hd__nand3b_2
XFILLER_17_57 VGND VGND VPWR VPWR sky130_fd_sc_hd__decap_3
XFILLER_24_264 VGND VGND VPWR VPWR sky130_fd_sc_hd__decap_3
XFILLER_33_34 VGND VGND VPWR VPWR sky130_fd_sc_hd__decap_3
XTAP_TAPCELL_ROW_26_259 VGND VPWR sky130_fd_sc_hd__tapvpwrvgnd_1
XFILLER_3_113 VGND VGND VPWR VPWR sky130_fd_sc_hd__fill_2
XFILLER_15_220 VGND VGND VPWR VPWR sky130_fd_sc_hd__decap_3
XFILLER_15_242 VGND VGND VPWR VPWR sky130_fd_sc_hd__fill_2
XFILLER_30_256 VGND VGND VPWR VPWR sky130_fd_sc_hd__decap_3
X_1681_ _1681_/A _1681_/B _1681_/C _1681_/D VGND VGND VPWR VPWR _1682_/C sky130_fd_sc_hd__or4_4
Xmax_cap127 _1026_/A VGND VGND VPWR VPWR _1354_/A sky130_fd_sc_hd__buf_6
X_1115_ _0914_/B _0910_/B _0905_/B _0896_/B _1599_/S wire177/X VGND VGND VPWR VPWR
+ _1115_/X sky130_fd_sc_hd__mux4_2
X_1046_ _1046_/A _1051_/B VGND VGND VPWR VPWR _1048_/B sky130_fd_sc_hd__nand2_2
XTAP_TAPCELL_ROW_0_116 VGND VPWR sky130_fd_sc_hd__tapvpwrvgnd_1
XFILLER_21_223 VGND VGND VPWR VPWR sky130_fd_sc_hd__fill_1
XFILLER_9_80 VGND VGND VPWR VPWR sky130_fd_sc_hd__decap_3
Xrebuffer527 _1280_/S0 VGND VGND VPWR VPWR _1125_/S0 sky130_fd_sc_hd__buf_2
XTAP_TAPCELL_ROW_31_284 VGND VPWR sky130_fd_sc_hd__tapvpwrvgnd_1
XFILLER_44_11 VGND VGND VPWR VPWR sky130_fd_sc_hd__decap_3
XFILLER_44_44 VGND VGND VPWR VPWR sky130_fd_sc_hd__decap_3
XFILLER_44_77 VGND VGND VPWR VPWR sky130_fd_sc_hd__fill_2
XFILLER_5_27 VGND VGND VPWR VPWR sky130_fd_sc_hd__decap_3
XFILLER_8_238 VGND VGND VPWR VPWR sky130_fd_sc_hd__decap_3
XPHY_EDGE_ROW_8_Left_61 VGND VGND VPWR VPWR sky130_fd_sc_hd__decap_3
XFILLER_47_197 VGND VGND VPWR VPWR sky130_fd_sc_hd__fill_1
XFILLER_50_307 VGND VGND VPWR VPWR sky130_fd_sc_hd__fill_1
XFILLER_7_260 VGND VGND VPWR VPWR sky130_fd_sc_hd__decap_3
X_1664_ _0861_/A _1629_/X _1663_/X _0856_/Y _1379_/A VGND VGND VPWR VPWR _1664_/X
+ sky130_fd_sc_hd__a221o_2
X_1595_ _1594_/B _1595_/A2 _1594_/A VGND VGND VPWR VPWR _1595_/X sky130_fd_sc_hd__a21o_4
XFILLER_38_131 VGND VGND VPWR VPWR sky130_fd_sc_hd__decap_3
XFILLER_38_175 VGND VGND VPWR VPWR sky130_fd_sc_hd__decap_3
XFILLER_38_197 VGND VGND VPWR VPWR sky130_fd_sc_hd__decap_3
Xload_slew174 _0850_/S1 VGND VGND VPWR VPWR _1432_/S1 sky130_fd_sc_hd__buf_4
Xload_slew185 _1158_/S0 VGND VGND VPWR VPWR _1413_/S sky130_fd_sc_hd__buf_6
XTAP_TAPCELL_ROW_36_310 VGND VPWR sky130_fd_sc_hd__tapvpwrvgnd_1
XFILLER_14_69 VGND VGND VPWR VPWR sky130_fd_sc_hd__fill_2
XFILLER_41_307 VGND VGND VPWR VPWR sky130_fd_sc_hd__decap_3
X_1029_ _0998_/A input6/X VGND VGND VPWR VPWR _1029_/X sky130_fd_sc_hd__and2b_2
XFILLER_30_46 VGND VGND VPWR VPWR sky130_fd_sc_hd__decap_3
XFILLER_30_79 VGND VGND VPWR VPWR sky130_fd_sc_hd__decap_3
XFILLER_5_219 VGND VGND VPWR VPWR sky130_fd_sc_hd__decap_3
Xrebuffer346 _0992_/B VGND VGND VPWR VPWR _1027_/B sky130_fd_sc_hd__buf_2
XFILLER_39_88 VGND VGND VPWR VPWR sky130_fd_sc_hd__decap_3
XFILLER_29_131 VGND VGND VPWR VPWR sky130_fd_sc_hd__decap_3
XFILLER_29_164 VGND VGND VPWR VPWR sky130_fd_sc_hd__decap_3
XFILLER_29_197 VGND VGND VPWR VPWR sky130_fd_sc_hd__decap_3
XFILLER_44_101 VGND VGND VPWR VPWR sky130_fd_sc_hd__fill_1
XFILLER_44_178 VGND VGND VPWR VPWR sky130_fd_sc_hd__decap_3
XPHY_EDGE_ROW_34_Left_87 VGND VGND VPWR VPWR sky130_fd_sc_hd__decap_3
XTAP_TAPCELL_ROW_50_390 VGND VPWR sky130_fd_sc_hd__tapvpwrvgnd_1
XTAP_TAPCELL_ROW_42_346 VGND VPWR sky130_fd_sc_hd__tapvpwrvgnd_1
XFILLER_4_263 VGND VGND VPWR VPWR sky130_fd_sc_hd__decap_3
XFILLER_4_296 VGND VGND VPWR VPWR sky130_fd_sc_hd__decap_3
X_1380_ _1116_/A _0832_/Y _1392_/C VGND VGND VPWR VPWR _1380_/X sky130_fd_sc_hd__o21a_2
XFILLER_35_189 VGND VGND VPWR VPWR sky130_fd_sc_hd__decap_3
XFILLER_6_70 VGND VGND VPWR VPWR sky130_fd_sc_hd__fill_1
X_1647_ _1647_/A1 _1646_/X _1643_/X _1647_/C1 VGND VGND VPWR VPWR _1647_/X sky130_fd_sc_hd__a211o_2
X_1578_ _1564_/X _0922_/Y _1571_/X _1577_/X VGND VGND VPWR VPWR _1676_/B sky130_fd_sc_hd__a211o_4
XFILLER_26_112 VGND VGND VPWR VPWR sky130_fd_sc_hd__decap_3
XFILLER_25_57 VGND VGND VPWR VPWR sky130_fd_sc_hd__decap_3
XFILLER_41_34 VGND VGND VPWR VPWR sky130_fd_sc_hd__fill_2
XFILLER_9_3 VGND VGND VPWR VPWR sky130_fd_sc_hd__decap_3
XFILLER_1_255 VGND VGND VPWR VPWR sky130_fd_sc_hd__decap_3
XFILLER_1_299 VGND VGND VPWR VPWR sky130_fd_sc_hd__decap_3
XFILLER_49_248 VGND VGND VPWR VPWR sky130_fd_sc_hd__decap_3
XFILLER_9_300 VGND VGND VPWR VPWR sky130_fd_sc_hd__fill_1
X_0880_ _1591_/A _1526_/S _1418_/C VGND VGND VPWR VPWR _0880_/X sky130_fd_sc_hd__and3_4
X_1501_ _1432_/X _1500_/X _1588_/S VGND VGND VPWR VPWR _1501_/X sky130_fd_sc_hd__mux2_1
X_1432_ _1034_/B input8/X input7/X input6/X _1455_/S _1432_/S1 VGND VGND VPWR VPWR
+ _1432_/X sky130_fd_sc_hd__mux4_2
X_1363_ _0992_/A _1027_/B _1453_/A1 VGND VGND VPWR VPWR _1363_/Y sky130_fd_sc_hd__o21ai_2
XFILLER_48_292 VGND VGND VPWR VPWR sky130_fd_sc_hd__decap_3
X_1294_ _1288_/A _1015_/A _1012_/B VGND VGND VPWR VPWR _1295_/C sky130_fd_sc_hd__o21a_2
XFILLER_31_181 VGND VGND VPWR VPWR sky130_fd_sc_hd__decap_3
XFILLER_11_15 VGND VGND VPWR VPWR sky130_fd_sc_hd__decap_3
XFILLER_14_137 VGND VGND VPWR VPWR sky130_fd_sc_hd__decap_3
XFILLER_36_45 VGND VGND VPWR VPWR sky130_fd_sc_hd__decap_3
XFILLER_36_89 VGND VGND VPWR VPWR sky130_fd_sc_hd__decap_3
XFILLER_39_292 VGND VGND VPWR VPWR sky130_fd_sc_hd__decap_3
XFILLER_52_44 VGND VGND VPWR VPWR sky130_fd_sc_hd__decap_3
XFILLER_52_66 VGND VGND VPWR VPWR sky130_fd_sc_hd__fill_1
XTAP_TAPCELL_ROW_9_163 VGND VPWR sky130_fd_sc_hd__tapvpwrvgnd_1
XPHY_EDGE_ROW_37_Left_90 VGND VGND VPWR VPWR sky130_fd_sc_hd__decap_3
XFILLER_45_284 VGND VGND VPWR VPWR sky130_fd_sc_hd__decap_3
X_0932_ _0932_/A _1511_/B VGND VGND VPWR VPWR _1509_/B sky130_fd_sc_hd__nand2_2
XTAP_TAPCELL_ROW_15_198 VGND VPWR sky130_fd_sc_hd__tapvpwrvgnd_1
XPHY_EDGE_ROW_21_Left_74 VGND VGND VPWR VPWR sky130_fd_sc_hd__decap_3
X_0863_ _1275_/A _0851_/X _0855_/X _0862_/X VGND VGND VPWR VPWR _0863_/X sky130_fd_sc_hd__o22a_2
X_1415_ _1338_/X _1414_/X _1457_/S VGND VGND VPWR VPWR _1415_/X sky130_fd_sc_hd__mux2_1
X_1346_ _1535_/A _1354_/B _1343_/X _1374_/A VGND VGND VPWR VPWR _1347_/C sky130_fd_sc_hd__a2bb2o_2
X_1277_ _1084_/X _1275_/X _1276_/X VGND VGND VPWR VPWR _1278_/A sky130_fd_sc_hd__a21oi_2
XFILLER_11_118 VGND VGND VPWR VPWR sky130_fd_sc_hd__decap_3
XFILLER_51_276 VGND VGND VPWR VPWR sky130_fd_sc_hd__decap_3
XFILLER_51_287 VGND VGND VPWR VPWR sky130_fd_sc_hd__decap_3
Xfanout120 _0869_/Y VGND VGND VPWR VPWR _1660_/A1 sky130_fd_sc_hd__clkdlybuf4s25_1
Xfanout131 _0877_/X VGND VGND VPWR VPWR _1418_/C sky130_fd_sc_hd__buf_2
XFILLER_47_33 VGND VGND VPWR VPWR sky130_fd_sc_hd__decap_3
XFILLER_47_77 VGND VGND VPWR VPWR sky130_fd_sc_hd__fill_1
Xfanout142 _0833_/Y VGND VGND VPWR VPWR _1220_/A sky130_fd_sc_hd__buf_6
Xfanout153 input8/X VGND VGND VPWR VPWR _1053_/B sky130_fd_sc_hd__dlymetal6s2s_1
Xfanout175 wire177/A VGND VGND VPWR VPWR _1358_/S1 sky130_fd_sc_hd__dlymetal6s2s_1
Xfanout186 fanout186/A VGND VGND VPWR VPWR _1280_/S0 sky130_fd_sc_hd__buf_8
Xfanout197 _0867_/A VGND VGND VPWR VPWR _0835_/A sky130_fd_sc_hd__clkbuf_2
XTAP_TAPCELL_ROW_6_144 VGND VPWR sky130_fd_sc_hd__tapvpwrvgnd_1
XFILLER_42_210 VGND VGND VPWR VPWR sky130_fd_sc_hd__decap_3
XFILLER_42_265 VGND VGND VPWR VPWR sky130_fd_sc_hd__decap_3
XFILLER_8_27 VGND VGND VPWR VPWR sky130_fd_sc_hd__fill_1
XFILLER_8_38 VGND VGND VPWR VPWR sky130_fd_sc_hd__decap_3
XFILLER_10_195 VGND VGND VPWR VPWR sky130_fd_sc_hd__fill_1
XFILLER_12_80 VGND VGND VPWR VPWR sky130_fd_sc_hd__decap_3
XTAP_TAPCELL_ROW_12_179 VGND VPWR sky130_fd_sc_hd__tapvpwrvgnd_1
X_1200_ _1107_/B _1117_/X _1199_/X _1175_/A VGND VGND VPWR VPWR _1201_/A sky130_fd_sc_hd__a22oi_2
X_1131_ _1133_/B _1129_/X _1130_/Y VGND VGND VPWR VPWR _1131_/X sky130_fd_sc_hd__o21a_2
X_1062_ _1575_/A _1573_/B VGND VGND VPWR VPWR _1063_/C sky130_fd_sc_hd__nand2_2
XFILLER_33_265 VGND VGND VPWR VPWR sky130_fd_sc_hd__decap_3
XFILLER_33_287 VGND VGND VPWR VPWR sky130_fd_sc_hd__decap_3
X_0915_ _1597_/B _0915_/B VGND VGND VPWR VPWR _1620_/B sky130_fd_sc_hd__and2_2
XFILLER_0_309 VGND VGND VPWR VPWR sky130_fd_sc_hd__fill_1
X_0846_ _0878_/D _1069_/B _1069_/C VGND VGND VPWR VPWR _1275_/C sky130_fd_sc_hd__and3b_2
X_1329_ _1351_/B _1329_/B _1329_/C VGND VGND VPWR VPWR _1348_/A sky130_fd_sc_hd__and3_2
XFILLER_24_221 VGND VGND VPWR VPWR sky130_fd_sc_hd__decap_3
XFILLER_24_276 VGND VGND VPWR VPWR sky130_fd_sc_hd__fill_2
XFILLER_33_57 VGND VGND VPWR VPWR sky130_fd_sc_hd__decap_3
XFILLER_3_169 VGND VGND VPWR VPWR sky130_fd_sc_hd__fill_2
XFILLER_47_302 VGND VGND VPWR VPWR sky130_fd_sc_hd__decap_3
XTAP_TAPCELL_ROW_17_205 VGND VPWR sky130_fd_sc_hd__tapvpwrvgnd_1
X_1680_ _1680_/A _1680_/B VGND VGND VPWR VPWR _1681_/D sky130_fd_sc_hd__or2_2
Xmax_cap128 _0981_/X VGND VGND VPWR VPWR _0982_/A sky130_fd_sc_hd__buf_6
XFILLER_24_3 VGND VGND VPWR VPWR sky130_fd_sc_hd__decap_3
X_1114_ _1373_/A0 _1113_/X _1124_/S VGND VGND VPWR VPWR _1114_/X sky130_fd_sc_hd__mux2_4
XTAP_TAPCELL_ROW_0_106 VGND VPWR sky130_fd_sc_hd__tapvpwrvgnd_1
XFILLER_21_213 VGND VGND VPWR VPWR sky130_fd_sc_hd__fill_1
X_1045_ _1046_/A _1051_/B VGND VGND VPWR VPWR _1048_/A sky130_fd_sc_hd__or2_2
Xrebuffer528 _1280_/S0 VGND VGND VPWR VPWR _0850_/S0 sky130_fd_sc_hd__buf_2
X_0829_ input7/X VGND VGND VPWR VPWR _0829_/Y sky130_fd_sc_hd__inv_2
XTAP_TAPCELL_ROW_31_285 VGND VPWR sky130_fd_sc_hd__tapvpwrvgnd_1
XFILLER_44_23 VGND VGND VPWR VPWR sky130_fd_sc_hd__decap_3
XTAP_TAPCELL_ROW_39_330 VGND VPWR sky130_fd_sc_hd__tapvpwrvgnd_1
XFILLER_8_206 VGND VGND VPWR VPWR sky130_fd_sc_hd__decap_3
XFILLER_5_39 VGND VGND VPWR VPWR sky130_fd_sc_hd__decap_3
XFILLER_10_9 VGND VGND VPWR VPWR sky130_fd_sc_hd__decap_3
X_1663_ _0891_/B _1644_/S _1081_/X VGND VGND VPWR VPWR _1663_/X sky130_fd_sc_hd__a21o_2
X_1594_ _1594_/A _1594_/B _1594_/C VGND VGND VPWR VPWR _1594_/Y sky130_fd_sc_hd__nand3_2
XPHY_EDGE_ROW_7_Right_7 VGND VGND VPWR VPWR sky130_fd_sc_hd__decap_3
XFILLER_38_187 VGND VGND VPWR VPWR sky130_fd_sc_hd__decap_3
XTAP_TAPCELL_ROW_36_311 VGND VPWR sky130_fd_sc_hd__tapvpwrvgnd_1
XFILLER_14_26 VGND VGND VPWR VPWR sky130_fd_sc_hd__fill_2
X_1028_ _1026_/A _1349_/B _1027_/X VGND VGND VPWR VPWR _1028_/X sky130_fd_sc_hd__a21o_2
Xrebuffer347 _0983_/C VGND VGND VPWR VPWR _1215_/B sky130_fd_sc_hd__buf_2
Xrebuffer336 _1280_/A1 VGND VGND VPWR VPWR _1020_/B sky130_fd_sc_hd__buf_2
XFILLER_44_113 VGND VGND VPWR VPWR sky130_fd_sc_hd__fill_1
XFILLER_44_124 VGND VGND VPWR VPWR sky130_fd_sc_hd__decap_3
XTAP_TAPCELL_ROW_50_391 VGND VPWR sky130_fd_sc_hd__tapvpwrvgnd_1
XTAP_TAPCELL_ROW_42_347 VGND VPWR sky130_fd_sc_hd__tapvpwrvgnd_1
XFILLER_20_91 VGND VGND VPWR VPWR sky130_fd_sc_hd__decap_3
XFILLER_4_275 VGND VGND VPWR VPWR sky130_fd_sc_hd__decap_3
XFILLER_35_135 VGND VGND VPWR VPWR sky130_fd_sc_hd__decap_3
XFILLER_50_138 VGND VGND VPWR VPWR sky130_fd_sc_hd__fill_2
X_1646_ _1243_/S _1587_/X _1645_/X VGND VGND VPWR VPWR _1646_/X sky130_fd_sc_hd__a21o_2
X_1577_ _1553_/Y _1572_/Y _1574_/X _1576_/X VGND VGND VPWR VPWR _1577_/X sky130_fd_sc_hd__o211a_2
XFILLER_25_36 VGND VGND VPWR VPWR sky130_fd_sc_hd__decap_3
XFILLER_26_124 VGND VGND VPWR VPWR sky130_fd_sc_hd__decap_3
XFILLER_41_116 VGND VGND VPWR VPWR sky130_fd_sc_hd__decap_3
XFILLER_41_57 VGND VGND VPWR VPWR sky130_fd_sc_hd__decap_3
XFILLER_1_234 VGND VGND VPWR VPWR sky130_fd_sc_hd__decap_3
XFILLER_1_267 VGND VGND VPWR VPWR sky130_fd_sc_hd__decap_3
XFILLER_2_18 VGND VGND VPWR VPWR sky130_fd_sc_hd__decap_3
XFILLER_2_29 VGND VGND VPWR VPWR sky130_fd_sc_hd__decap_3
XFILLER_25_190 VGND VGND VPWR VPWR sky130_fd_sc_hd__fill_1
XFILLER_32_105 VGND VGND VPWR VPWR sky130_fd_sc_hd__fill_2
XFILLER_40_182 VGND VGND VPWR VPWR sky130_fd_sc_hd__decap_3
X_1500_ _1469_/X _1499_/X _1568_/S VGND VGND VPWR VPWR _1500_/X sky130_fd_sc_hd__mux2_1
Xoutput90 _1681_/B VGND VGND VPWR VPWR result[29] sky130_fd_sc_hd__buf_6
X_1431_ _1034_/B _1053_/B _1455_/S VGND VGND VPWR VPWR _1431_/X sky130_fd_sc_hd__mux2_1
X_1362_ _1175_/A _1083_/X _1275_/X _1361_/X VGND VGND VPWR VPWR _1362_/X sky130_fd_sc_hd__a31o_2
X_1293_ _1333_/B _1293_/B _1273_/X VGND VGND VPWR VPWR _1293_/X sky130_fd_sc_hd__or3b_2
XFILLER_23_116 VGND VGND VPWR VPWR sky130_fd_sc_hd__decap_3
XFILLER_23_138 VGND VGND VPWR VPWR sky130_fd_sc_hd__decap_3
XFILLER_48_271 VGND VGND VPWR VPWR sky130_fd_sc_hd__decap_3
XFILLER_11_27 VGND VGND VPWR VPWR sky130_fd_sc_hd__decap_3
X_1629_ _0896_/B _0905_/B _1644_/S VGND VGND VPWR VPWR _1629_/X sky130_fd_sc_hd__mux2_1
XFILLER_36_35 VGND VGND VPWR VPWR sky130_fd_sc_hd__fill_2
XFILLER_39_260 VGND VGND VPWR VPWR sky130_fd_sc_hd__decap_3
XFILLER_36_57 VGND VGND VPWR VPWR sky130_fd_sc_hd__decap_3
XFILLER_36_79 VGND VGND VPWR VPWR sky130_fd_sc_hd__decap_3
XFILLER_52_12 VGND VGND VPWR VPWR sky130_fd_sc_hd__decap_3
XTAP_TAPCELL_ROW_9_164 VGND VPWR sky130_fd_sc_hd__tapvpwrvgnd_1
XFILLER_45_296 VGND VGND VPWR VPWR sky130_fd_sc_hd__decap_3
XFILLER_9_164 VGND VGND VPWR VPWR sky130_fd_sc_hd__decap_3
XFILLER_9_175 VGND VGND VPWR VPWR sky130_fd_sc_hd__decap_3
X_0931_ _0931_/A _0943_/B VGND VGND VPWR VPWR _1511_/B sky130_fd_sc_hd__nand2_2
X_0862_ _1226_/C _0858_/X _0859_/X _0861_/A _1178_/S VGND VGND VPWR VPWR _0862_/X
+ sky130_fd_sc_hd__a221o_2
XFILLER_28_208 VGND VGND VPWR VPWR sky130_fd_sc_hd__fill_2
X_1414_ _1375_/X _1413_/X _1568_/S VGND VGND VPWR VPWR _1414_/X sky130_fd_sc_hd__mux2_1
X_1345_ _1452_/A _1352_/B _0995_/A _1453_/A1 VGND VGND VPWR VPWR _1347_/B sky130_fd_sc_hd__a2bb2o_2
X_1276_ _1313_/A _1078_/X _1313_/B _1244_/X VGND VGND VPWR VPWR _1276_/X sky130_fd_sc_hd__a31o_2
XFILLER_11_108 VGND VGND VPWR VPWR sky130_fd_sc_hd__decap_3
XFILLER_36_263 VGND VGND VPWR VPWR sky130_fd_sc_hd__decap_3
XFILLER_36_285 VGND VGND VPWR VPWR sky130_fd_sc_hd__decap_3
XFILLER_51_222 VGND VGND VPWR VPWR sky130_fd_sc_hd__fill_2
XFILLER_51_233 VGND VGND VPWR VPWR sky130_fd_sc_hd__decap_3
XFILLER_51_299 VGND VGND VPWR VPWR sky130_fd_sc_hd__decap_3
XFILLER_47_12 VGND VGND VPWR VPWR sky130_fd_sc_hd__decap_3
Xfanout121 _1661_/A1 VGND VGND VPWR VPWR _1453_/A1 sky130_fd_sc_hd__buf_2
Xfanout132 _0856_/Y VGND VGND VPWR VPWR _1226_/C sky130_fd_sc_hd__buf_2
Xfanout154 _0869_/B VGND VGND VPWR VPWR _0878_/D sky130_fd_sc_hd__clkbuf_2
XTAP_TAPCELL_ROW_6_145 VGND VPWR sky130_fd_sc_hd__tapvpwrvgnd_1
XFILLER_47_45 VGND VGND VPWR VPWR sky130_fd_sc_hd__decap_3
XFILLER_47_67 VGND VGND VPWR VPWR sky130_fd_sc_hd__decap_3
Xfanout176 input44/X VGND VGND VPWR VPWR wire177/A sky130_fd_sc_hd__clkbuf_2
XFILLER_10_141 VGND VGND VPWR VPWR sky130_fd_sc_hd__decap_3
XFILLER_42_222 VGND VGND VPWR VPWR sky130_fd_sc_hd__fill_2
XFILLER_42_233 VGND VGND VPWR VPWR sky130_fd_sc_hd__decap_3
XFILLER_42_277 VGND VGND VPWR VPWR sky130_fd_sc_hd__decap_3
XFILLER_6_167 VGND VGND VPWR VPWR sky130_fd_sc_hd__decap_3
X_1130_ _1133_/B _1129_/X _1561_/A1 VGND VGND VPWR VPWR _1130_/Y sky130_fd_sc_hd__a21oi_2
XFILLER_33_255 VGND VGND VPWR VPWR sky130_fd_sc_hd__decap_3
XFILLER_33_277 VGND VGND VPWR VPWR sky130_fd_sc_hd__decap_3
X_1061_ _1573_/B VGND VGND VPWR VPWR _1061_/Y sky130_fd_sc_hd__inv_2
XFILLER_33_299 VGND VGND VPWR VPWR sky130_fd_sc_hd__decap_3
X_0914_ _0914_/A _0914_/B VGND VGND VPWR VPWR _0915_/B sky130_fd_sc_hd__or2_2
X_0845_ _0840_/X _0844_/X _1266_/A VGND VGND VPWR VPWR _0848_/B sky130_fd_sc_hd__mux2_4
XFILLER_24_200 VGND VGND VPWR VPWR sky130_fd_sc_hd__fill_2
X_1328_ _1327_/B _1327_/C _1354_/B VGND VGND VPWR VPWR _1329_/C sky130_fd_sc_hd__a21bo_2
X_1259_ _1288_/B _1255_/X _1334_/A2 _1258_/Y _1104_/X VGND VGND VPWR VPWR _1259_/X
+ sky130_fd_sc_hd__a311o_2
XFILLER_24_299 VGND VGND VPWR VPWR sky130_fd_sc_hd__fill_2
XFILLER_33_25 VGND VGND VPWR VPWR sky130_fd_sc_hd__decap_3
XPHY_EDGE_ROW_49_Left_102 VGND VGND VPWR VPWR sky130_fd_sc_hd__decap_3
XFILLER_3_137 VGND VGND VPWR VPWR sky130_fd_sc_hd__fill_2
XFILLER_15_277 VGND VGND VPWR VPWR sky130_fd_sc_hd__decap_3
XTAP_TAPCELL_ROW_25_250 VGND VPWR sky130_fd_sc_hd__tapvpwrvgnd_1
XTAP_TAPCELL_ROW_17_206 VGND VPWR sky130_fd_sc_hd__tapvpwrvgnd_1
XFILLER_2_170 VGND VGND VPWR VPWR sky130_fd_sc_hd__decap_3
XFILLER_2_192 VGND VGND VPWR VPWR sky130_fd_sc_hd__decap_3
Xmax_cap129 _0955_/Y VGND VGND VPWR VPWR _1154_/A sky130_fd_sc_hd__clkbuf_2
XFILLER_17_3 VGND VGND VPWR VPWR sky130_fd_sc_hd__fill_2
XFILLER_38_303 VGND VGND VPWR VPWR sky130_fd_sc_hd__decap_3
X_1113_ _1052_/B _1051_/B _0943_/B _0942_/B _1469_/S wire177/X VGND VGND VPWR VPWR
+ _1113_/X sky130_fd_sc_hd__mux4_2
X_1044_ _1046_/A _1051_/B VGND VGND VPWR VPWR _1044_/Y sky130_fd_sc_hd__nor2_2
XTAP_TAPCELL_ROW_48_375 VGND VPWR sky130_fd_sc_hd__tapvpwrvgnd_1
XTAP_TAPCELL_ROW_0_107 VGND VPWR sky130_fd_sc_hd__tapvpwrvgnd_1
XFILLER_21_225 VGND VGND VPWR VPWR sky130_fd_sc_hd__decap_3
XFILLER_9_71 VGND VGND VPWR VPWR sky130_fd_sc_hd__decap_3
XFILLER_9_93 VGND VGND VPWR VPWR sky130_fd_sc_hd__decap_3
Xrebuffer529 _1158_/S0 VGND VGND VPWR VPWR _1396_/S0 sky130_fd_sc_hd__buf_2
X_0828_ _1037_/A VGND VGND VPWR VPWR _1053_/A sky130_fd_sc_hd__inv_2
XTAP_TAPCELL_ROW_31_286 VGND VPWR sky130_fd_sc_hd__tapvpwrvgnd_1
XFILLER_28_47 VGND VGND VPWR VPWR sky130_fd_sc_hd__fill_1
XFILLER_28_58 VGND VGND VPWR VPWR sky130_fd_sc_hd__decap_3
XFILLER_44_35 VGND VGND VPWR VPWR sky130_fd_sc_hd__decap_3
XFILLER_5_18 VGND VGND VPWR VPWR sky130_fd_sc_hd__decap_3
XFILLER_18_91 VGND VGND VPWR VPWR sky130_fd_sc_hd__decap_3
XFILLER_50_309 VGND VGND VPWR VPWR sky130_fd_sc_hd__fill_1
X_1662_ _1398_/X _1419_/B _1661_/X VGND VGND VPWR VPWR _1668_/A sky130_fd_sc_hd__a21o_2
Xload_slew143 _1220_/A VGND VGND VPWR VPWR _1265_/S sky130_fd_sc_hd__clkbuf_2
Xload_slew187 _1280_/S0 VGND VGND VPWR VPWR fanout184/A sky130_fd_sc_hd__buf_8
Xload_slew198 _0835_/A VGND VGND VPWR VPWR _1076_/S sky130_fd_sc_hd__buf_6
X_1593_ _1637_/A2 _1580_/X _1579_/Y _1592_/X VGND VGND VPWR VPWR _1677_/A sky130_fd_sc_hd__a31o_4
XFILLER_38_122 VGND VGND VPWR VPWR sky130_fd_sc_hd__decap_3
XFILLER_38_144 VGND VGND VPWR VPWR sky130_fd_sc_hd__fill_1
X_1027_ _0992_/A _1027_/B VGND VGND VPWR VPWR _1027_/X sky130_fd_sc_hd__and2b_2
XTAP_TAPCELL_ROW_36_312 VGND VPWR sky130_fd_sc_hd__tapvpwrvgnd_1
Xrebuffer348 _0982_/A VGND VGND VPWR VPWR _0983_/C sky130_fd_sc_hd__buf_2
Xrebuffer337 _1280_/A1 VGND VGND VPWR VPWR _1160_/A1 sky130_fd_sc_hd__buf_2
XFILLER_39_24 VGND VGND VPWR VPWR sky130_fd_sc_hd__fill_1
XFILLER_29_188 VGND VGND VPWR VPWR sky130_fd_sc_hd__fill_1
XFILLER_39_46 VGND VGND VPWR VPWR sky130_fd_sc_hd__fill_2
XFILLER_32_309 VGND VGND VPWR VPWR sky130_fd_sc_hd__fill_1
XFILLER_44_147 VGND VGND VPWR VPWR sky130_fd_sc_hd__fill_1
XFILLER_4_287 VGND VGND VPWR VPWR sky130_fd_sc_hd__decap_3
XFILLER_35_169 VGND VGND VPWR VPWR sky130_fd_sc_hd__decap_3
XFILLER_6_61 VGND VGND VPWR VPWR sky130_fd_sc_hd__decap_3
X_1645_ _0861_/A _1613_/X _1644_/X _1226_/C VGND VGND VPWR VPWR _1645_/X sky130_fd_sc_hd__a22o_2
X_1576_ _1656_/A _1581_/B VGND VGND VPWR VPWR _1576_/X sky130_fd_sc_hd__and2_2
XFILLER_14_309 VGND VGND VPWR VPWR sky130_fd_sc_hd__fill_1
XFILLER_26_136 VGND VGND VPWR VPWR sky130_fd_sc_hd__decap_3
XFILLER_26_147 VGND VGND VPWR VPWR sky130_fd_sc_hd__decap_3
XFILLER_41_25 VGND VGND VPWR VPWR sky130_fd_sc_hd__decap_3
XFILLER_1_246 VGND VGND VPWR VPWR sky130_fd_sc_hd__decap_3
XFILLER_1_279 VGND VGND VPWR VPWR sky130_fd_sc_hd__fill_1
XFILLER_49_217 VGND VGND VPWR VPWR sky130_fd_sc_hd__decap_3
XFILLER_49_239 VGND VGND VPWR VPWR sky130_fd_sc_hd__decap_3
XFILLER_17_169 VGND VGND VPWR VPWR sky130_fd_sc_hd__decap_3
XFILLER_15_81 VGND VGND VPWR VPWR sky130_fd_sc_hd__decap_3
XFILLER_32_128 VGND VGND VPWR VPWR sky130_fd_sc_hd__fill_1
XFILLER_32_139 VGND VGND VPWR VPWR sky130_fd_sc_hd__fill_1
XFILLER_40_150 VGND VGND VPWR VPWR sky130_fd_sc_hd__decap_3
XFILLER_49_6 VGND VGND VPWR VPWR sky130_fd_sc_hd__decap_3
X_1430_ _1430_/A _1430_/B VGND VGND VPWR VPWR _1430_/X sky130_fd_sc_hd__or2_2
XFILLER_0_290 VGND VGND VPWR VPWR sky130_fd_sc_hd__decap_3
XFILLER_48_250 VGND VGND VPWR VPWR sky130_fd_sc_hd__fill_2
Xoutput80 _1671_/A VGND VGND VPWR VPWR result[1] sky130_fd_sc_hd__clkdlybuf4s25_1
Xoutput91 _1671_/B VGND VGND VPWR VPWR result[2] sky130_fd_sc_hd__clkdlybuf4s25_1
X_1361_ _1313_/A _1313_/B _1195_/X _1244_/X VGND VGND VPWR VPWR _1361_/X sky130_fd_sc_hd__a31o_2
X_1292_ _1273_/X _1022_/Y _1333_/B VGND VGND VPWR VPWR _1292_/X sky130_fd_sc_hd__a21bo_2
XFILLER_48_283 VGND VGND VPWR VPWR sky130_fd_sc_hd__decap_3
X_1628_ _1643_/A1 _0897_/B _1635_/A _1660_/A1 _1647_/C1 VGND VGND VPWR VPWR _1628_/X
+ sky130_fd_sc_hd__a221o_2
X_1559_ _1415_/X _1416_/X _1558_/X _1647_/A1 _1555_/X VGND VGND VPWR VPWR _1559_/X
+ sky130_fd_sc_hd__a221o_2
XFILLER_36_25 VGND VGND VPWR VPWR sky130_fd_sc_hd__decap_3
XFILLER_39_272 VGND VGND VPWR VPWR sky130_fd_sc_hd__decap_3
XFILLER_22_172 VGND VGND VPWR VPWR sky130_fd_sc_hd__decap_3
XFILLER_22_194 VGND VGND VPWR VPWR sky130_fd_sc_hd__fill_2
XFILLER_52_24 VGND VGND VPWR VPWR sky130_fd_sc_hd__decap_3
XFILLER_52_35 VGND VGND VPWR VPWR sky130_fd_sc_hd__decap_3
XFILLER_52_57 VGND VGND VPWR VPWR sky130_fd_sc_hd__decap_3
XTAP_TAPCELL_ROW_9_165 VGND VPWR sky130_fd_sc_hd__tapvpwrvgnd_1
XFILLER_26_80 VGND VGND VPWR VPWR sky130_fd_sc_hd__decap_3
XFILLER_26_91 VGND VGND VPWR VPWR sky130_fd_sc_hd__decap_3
XFILLER_45_253 VGND VGND VPWR VPWR sky130_fd_sc_hd__decap_3
XFILLER_45_275 VGND VGND VPWR VPWR sky130_fd_sc_hd__decap_3
X_0930_ _0931_/A _0943_/B VGND VGND VPWR VPWR _0932_/A sky130_fd_sc_hd__or2_2
X_0861_ _0861_/A VGND VGND VPWR VPWR _1612_/A sky130_fd_sc_hd__inv_2
XFILLER_47_3 VGND VGND VPWR VPWR sky130_fd_sc_hd__decap_3
X_1413_ _1053_/B input7/X _1413_/S VGND VGND VPWR VPWR _1413_/X sky130_fd_sc_hd__mux2_1
XFILLER_36_242 VGND VGND VPWR VPWR sky130_fd_sc_hd__decap_3
XFILLER_36_253 VGND VGND VPWR VPWR sky130_fd_sc_hd__decap_3
XFILLER_3_51 VGND VGND VPWR VPWR sky130_fd_sc_hd__fill_1
X_1344_ _1570_/A1 _1340_/X _1342_/X _1598_/A VGND VGND VPWR VPWR _1347_/A sky130_fd_sc_hd__a22o_2
X_1275_ _1275_/A _1275_/B _1275_/C VGND VGND VPWR VPWR _1275_/X sky130_fd_sc_hd__and3_2
XFILLER_36_297 VGND VGND VPWR VPWR sky130_fd_sc_hd__decap_3
XFILLER_51_267 VGND VGND VPWR VPWR sky130_fd_sc_hd__decap_3
XFILLER_22_27 VGND VGND VPWR VPWR sky130_fd_sc_hd__fill_1
XFILLER_22_49 VGND VGND VPWR VPWR sky130_fd_sc_hd__decap_3
XFILLER_3_308 VGND VGND VPWR VPWR sky130_fd_sc_hd__fill_2
XFILLER_0_9 VGND VGND VPWR VPWR sky130_fd_sc_hd__decap_3
XFILLER_19_209 VGND VGND VPWR VPWR sky130_fd_sc_hd__decap_3
XFILLER_47_24 VGND VGND VPWR VPWR sky130_fd_sc_hd__decap_3
Xfanout111 _0880_/X VGND VGND VPWR VPWR _1647_/A1 sky130_fd_sc_hd__clkbuf_4
Xfanout122 _1661_/A1 VGND VGND VPWR VPWR _1643_/A1 sky130_fd_sc_hd__clkdlybuf4s25_1
Xfanout133 _1600_/S VGND VGND VPWR VPWR _1568_/S sky130_fd_sc_hd__buf_4
Xfanout144 _0833_/Y VGND VGND VPWR VPWR _1175_/A sky130_fd_sc_hd__clkdlybuf4s25_1
Xfanout155 _0874_/C VGND VGND VPWR VPWR _1069_/C sky130_fd_sc_hd__clkbuf_2
Xfanout166 _1243_/S VGND VGND VPWR VPWR _1193_/A sky130_fd_sc_hd__dlymetal6s4s_1
Xfanout188 fanout188/A VGND VGND VPWR VPWR _1469_/S sky130_fd_sc_hd__buf_8
Xfanout199 input33/X VGND VGND VPWR VPWR _0867_/A sky130_fd_sc_hd__buf_6
XTAP_TAPCELL_ROW_6_146 VGND VPWR sky130_fd_sc_hd__tapvpwrvgnd_1
XFILLER_27_264 VGND VGND VPWR VPWR sky130_fd_sc_hd__decap_3
XFILLER_42_245 VGND VGND VPWR VPWR sky130_fd_sc_hd__decap_3
XPHY_EDGE_ROW_29_Right_29 VGND VGND VPWR VPWR sky130_fd_sc_hd__decap_3
XFILLER_42_256 VGND VGND VPWR VPWR sky130_fd_sc_hd__decap_3
XFILLER_6_102 VGND VGND VPWR VPWR sky130_fd_sc_hd__decap_3
XFILLER_8_18 VGND VGND VPWR VPWR sky130_fd_sc_hd__decap_3
XFILLER_8_29 VGND VGND VPWR VPWR sky130_fd_sc_hd__decap_3
XPHY_EDGE_ROW_38_Right_38 VGND VGND VPWR VPWR sky130_fd_sc_hd__decap_3
XFILLER_10_197 VGND VGND VPWR VPWR sky130_fd_sc_hd__fill_1
XFILLER_6_179 VGND VGND VPWR VPWR sky130_fd_sc_hd__decap_3
X_1060_ _1575_/B _1060_/B VGND VGND VPWR VPWR _1573_/B sky130_fd_sc_hd__nand2_2
XPHY_EDGE_ROW_47_Right_47 VGND VGND VPWR VPWR sky130_fd_sc_hd__decap_3
XFILLER_18_253 VGND VGND VPWR VPWR sky130_fd_sc_hd__fill_2
XFILLER_18_264 VGND VGND VPWR VPWR sky130_fd_sc_hd__fill_2
XFILLER_33_223 VGND VGND VPWR VPWR sky130_fd_sc_hd__fill_1
XTAP_TAPCELL_ROW_28_270 VGND VPWR sky130_fd_sc_hd__tapvpwrvgnd_1
X_0913_ _0914_/A _0914_/B VGND VGND VPWR VPWR _1597_/B sky130_fd_sc_hd__nand2_2
X_0844_ _1175_/B _0843_/X _1220_/A VGND VGND VPWR VPWR _0844_/X sky130_fd_sc_hd__mux2_4
XFILLER_24_212 VGND VGND VPWR VPWR sky130_fd_sc_hd__decap_3
X_1327_ _1354_/B _1327_/B _1327_/C VGND VGND VPWR VPWR _1329_/B sky130_fd_sc_hd__nand3b_2
X_1258_ _1255_/X _1334_/A2 _1288_/B VGND VGND VPWR VPWR _1258_/Y sky130_fd_sc_hd__a21oi_2
X_1189_ _1270_/A _1180_/X _1186_/X _1188_/X VGND VGND VPWR VPWR _1189_/X sky130_fd_sc_hd__a211o_2
XFILLER_33_37 VGND VGND VPWR VPWR sky130_fd_sc_hd__fill_2
XFILLER_15_223 VGND VGND VPWR VPWR sky130_fd_sc_hd__fill_1
XTAP_TAPCELL_ROW_25_251 VGND VPWR sky130_fd_sc_hd__tapvpwrvgnd_1
XTAP_TAPCELL_ROW_17_207 VGND VPWR sky130_fd_sc_hd__tapvpwrvgnd_1
XFILLER_30_259 VGND VGND VPWR VPWR sky130_fd_sc_hd__decap_3
XFILLER_0_41 VGND VGND VPWR VPWR sky130_fd_sc_hd__decap_3
XFILLER_0_85 VGND VGND VPWR VPWR sky130_fd_sc_hd__decap_3
X_1112_ _0941_/B _0947_/B _1059_/B _0919_/B _1112_/S0 wire177/X VGND VGND VPWR VPWR
+ _1112_/X sky130_fd_sc_hd__mux4_2
X_1043_ _1043_/A _1452_/B VGND VGND VPWR VPWR _1479_/A sky130_fd_sc_hd__and2_2
XTAP_TAPCELL_ROW_48_376 VGND VPWR sky130_fd_sc_hd__tapvpwrvgnd_1
XTAP_TAPCELL_ROW_0_108 VGND VPWR sky130_fd_sc_hd__tapvpwrvgnd_1
X_0827_ _1034_/A VGND VGND VPWR VPWR _0827_/Y sky130_fd_sc_hd__inv_2
XFILLER_28_15 VGND VGND VPWR VPWR sky130_fd_sc_hd__fill_1
XFILLER_12_226 VGND VGND VPWR VPWR sky130_fd_sc_hd__decap_3
XFILLER_44_14 VGND VGND VPWR VPWR sky130_fd_sc_hd__decap_3
XFILLER_44_47 VGND VGND VPWR VPWR sky130_fd_sc_hd__decap_3
XFILLER_12_248 VGND VGND VPWR VPWR sky130_fd_sc_hd__decap_3
XTAP_TAPCELL_ROW_22_232 VGND VPWR sky130_fd_sc_hd__tapvpwrvgnd_1
XFILLER_18_81 VGND VGND VPWR VPWR sky130_fd_sc_hd__decap_3
XFILLER_34_80 VGND VGND VPWR VPWR sky130_fd_sc_hd__decap_3
XFILLER_11_281 VGND VGND VPWR VPWR sky130_fd_sc_hd__decap_3
XFILLER_7_241 VGND VGND VPWR VPWR sky130_fd_sc_hd__fill_2
XFILLER_7_263 VGND VGND VPWR VPWR sky130_fd_sc_hd__decap_3
X_1661_ _1661_/A1 _0888_/B _1659_/Y _1660_/X VGND VGND VPWR VPWR _1661_/X sky130_fd_sc_hd__a211o_2
X_1592_ _1656_/A _1582_/X _1597_/C _1590_/X _1591_/X VGND VGND VPWR VPWR _1592_/X
+ sky130_fd_sc_hd__a311o_2
XFILLER_38_134 VGND VGND VPWR VPWR sky130_fd_sc_hd__decap_3
XFILLER_26_307 VGND VGND VPWR VPWR sky130_fd_sc_hd__fill_1
XFILLER_38_178 VGND VGND VPWR VPWR sky130_fd_sc_hd__fill_2
X_1026_ _1026_/A _1349_/B VGND VGND VPWR VPWR _1351_/A sky130_fd_sc_hd__nand2_2
XTAP_TAPCELL_ROW_36_313 VGND VPWR sky130_fd_sc_hd__tapvpwrvgnd_1
XFILLER_30_27 VGND VGND VPWR VPWR sky130_fd_sc_hd__fill_1
Xrebuffer338 fanout158/X VGND VGND VPWR VPWR _1261_/A sky130_fd_sc_hd__buf_2
XFILLER_30_49 VGND VGND VPWR VPWR sky130_fd_sc_hd__decap_3
XFILLER_29_134 VGND VGND VPWR VPWR sky130_fd_sc_hd__decap_3
XFILLER_29_167 VGND VGND VPWR VPWR sky130_fd_sc_hd__fill_1
XFILLER_44_137 VGND VGND VPWR VPWR sky130_fd_sc_hd__decap_3
XFILLER_4_266 VGND VGND VPWR VPWR sky130_fd_sc_hd__decap_3
XFILLER_20_71 VGND VGND VPWR VPWR sky130_fd_sc_hd__fill_2
XFILLER_20_82 VGND VGND VPWR VPWR sky130_fd_sc_hd__fill_2
XFILLER_29_80 VGND VGND VPWR VPWR sky130_fd_sc_hd__decap_3
XFILLER_4_299 VGND VGND VPWR VPWR sky130_fd_sc_hd__decap_3
XFILLER_35_126 VGND VGND VPWR VPWR sky130_fd_sc_hd__decap_3
X_1644_ _0891_/B _0896_/B _1644_/S VGND VGND VPWR VPWR _1644_/X sky130_fd_sc_hd__mux2_1
X_1575_ _1575_/A _1575_/B VGND VGND VPWR VPWR _1581_/B sky130_fd_sc_hd__or2_2
XFILLER_25_27 VGND VGND VPWR VPWR sky130_fd_sc_hd__decap_3
XFILLER_34_170 VGND VGND VPWR VPWR sky130_fd_sc_hd__decap_3
XFILLER_34_192 VGND VGND VPWR VPWR sky130_fd_sc_hd__decap_3
XFILLER_41_129 VGND VGND VPWR VPWR sky130_fd_sc_hd__decap_3
X_1009_ _1010_/A _1019_/B VGND VGND VPWR VPWR _1012_/A sky130_fd_sc_hd__or2_2
XFILLER_1_225 VGND VGND VPWR VPWR sky130_fd_sc_hd__decap_3
XFILLER_1_258 VGND VGND VPWR VPWR sky130_fd_sc_hd__decap_3
XFILLER_9_6 VGND VGND VPWR VPWR sky130_fd_sc_hd__decap_3
XFILLER_15_60 VGND VGND VPWR VPWR sky130_fd_sc_hd__decap_3
XFILLER_31_70 VGND VGND VPWR VPWR sky130_fd_sc_hd__decap_3
Xoutput70 output70/A VGND VGND VPWR VPWR result[10] sky130_fd_sc_hd__buf_8
X_1360_ _1201_/Y _1359_/X _1502_/S VGND VGND VPWR VPWR _1360_/X sky130_fd_sc_hd__mux2_1
XFILLER_48_262 VGND VGND VPWR VPWR sky130_fd_sc_hd__decap_3
XFILLER_48_295 VGND VGND VPWR VPWR sky130_fd_sc_hd__decap_3
Xoutput81 _1679_/C VGND VGND VPWR VPWR result[20] sky130_fd_sc_hd__buf_8
Xoutput92 _1682_/A VGND VGND VPWR VPWR result[30] sky130_fd_sc_hd__buf_6
X_1291_ _1291_/A _1291_/B _1291_/C VGND VGND VPWR VPWR _1673_/C sky130_fd_sc_hd__or3_4
XFILLER_11_18 VGND VGND VPWR VPWR sky130_fd_sc_hd__decap_3
XFILLER_31_162 VGND VGND VPWR VPWR sky130_fd_sc_hd__decap_3
XFILLER_31_184 VGND VGND VPWR VPWR sky130_fd_sc_hd__decap_3
X_1627_ _1627_/A _1627_/B VGND VGND VPWR VPWR _1627_/X sky130_fd_sc_hd__or2_4
X_1558_ _1487_/X _1557_/X _1588_/S VGND VGND VPWR VPWR _1558_/X sky130_fd_sc_hd__mux2_1
X_1489_ _1339_/X _1488_/X _1502_/S VGND VGND VPWR VPWR _1489_/X sky130_fd_sc_hd__mux2_1
XFILLER_36_48 VGND VGND VPWR VPWR sky130_fd_sc_hd__decap_3
XFILLER_39_240 VGND VGND VPWR VPWR sky130_fd_sc_hd__decap_3
XFILLER_39_295 VGND VGND VPWR VPWR sky130_fd_sc_hd__decap_3
XTAP_TAPCELL_ROW_52_400 VGND VPWR sky130_fd_sc_hd__tapvpwrvgnd_1
XFILLER_52_47 VGND VGND VPWR VPWR sky130_fd_sc_hd__decap_3
XFILLER_7_3 VGND VGND VPWR VPWR sky130_fd_sc_hd__decap_3
XFILLER_45_221 VGND VGND VPWR VPWR sky130_fd_sc_hd__decap_3
XFILLER_45_287 VGND VGND VPWR VPWR sky130_fd_sc_hd__decap_3
XFILLER_13_195 VGND VGND VPWR VPWR sky130_fd_sc_hd__fill_2
X_0860_ _1137_/A _1600_/S VGND VGND VPWR VPWR _0861_/A sky130_fd_sc_hd__nor2_2
XFILLER_3_30 VGND VGND VPWR VPWR sky130_fd_sc_hd__decap_3
X_1412_ _1440_/B _1549_/A2 _1410_/X _1411_/Y _1561_/A1 VGND VGND VPWR VPWR _1425_/A
+ sky130_fd_sc_hd__a311oi_2
X_1343_ _0838_/X _1343_/A1 _0849_/X _0839_/X _1391_/S0 _1472_/A VGND VGND VPWR VPWR
+ _1343_/X sky130_fd_sc_hd__mux4_2
XFILLER_36_221 VGND VGND VPWR VPWR sky130_fd_sc_hd__decap_3
X_1274_ _1272_/A _1272_/B _1099_/X _1272_/Y _1273_/X VGND VGND VPWR VPWR _1291_/A
+ sky130_fd_sc_hd__o2111a_2
XFILLER_22_17 VGND VGND VPWR VPWR sky130_fd_sc_hd__fill_1
XFILLER_51_279 VGND VGND VPWR VPWR sky130_fd_sc_hd__fill_1
XTAP_TAPCELL_ROW_14_190 VGND VPWR sky130_fd_sc_hd__tapvpwrvgnd_1
X_0989_ _1215_/B _1215_/C _0988_/Y VGND VGND VPWR VPWR _0989_/Y sky130_fd_sc_hd__o21ai_2
XFILLER_47_36 VGND VGND VPWR VPWR sky130_fd_sc_hd__decap_3
Xfanout112 _1659_/A VGND VGND VPWR VPWR _1452_/A sky130_fd_sc_hd__clkdlybuf4s15_2
Xfanout123 _0865_/X VGND VGND VPWR VPWR _1661_/A1 sky130_fd_sc_hd__clkdlybuf4s25_1
Xfanout145 _1502_/S VGND VGND VPWR VPWR _1472_/A sky130_fd_sc_hd__clkdlybuf4s25_1
Xfanout156 _1116_/D VGND VGND VPWR VPWR _1313_/A sky130_fd_sc_hd__buf_4
Xfanout178 fanout178/A VGND VGND VPWR VPWR fanout178/X sky130_fd_sc_hd__buf_8
XTAP_TAPCELL_ROW_6_147 VGND VPWR sky130_fd_sc_hd__tapvpwrvgnd_1
XFILLER_42_268 VGND VGND VPWR VPWR sky130_fd_sc_hd__decap_3
XFILLER_12_83 VGND VGND VPWR VPWR sky130_fd_sc_hd__fill_1
XPHY_EDGE_ROW_25_Left_78 VGND VGND VPWR VPWR sky130_fd_sc_hd__decap_3
XFILLER_33_235 VGND VGND VPWR VPWR sky130_fd_sc_hd__fill_2
XFILLER_33_268 VGND VGND VPWR VPWR sky130_fd_sc_hd__decap_3
X_0912_ _0914_/A _0914_/B VGND VGND VPWR VPWR _1594_/B sky130_fd_sc_hd__nand2b_2
X_0843_ _1059_/B _0919_/B _0914_/B _0910_/B _1586_/S wire177/X VGND VGND VPWR VPWR
+ _0843_/X sky130_fd_sc_hd__mux4_2
X_1326_ _1252_/B _1252_/C _1016_/Y VGND VGND VPWR VPWR _1327_/C sky130_fd_sc_hd__a21o_2
XTAP_TAPCELL_ROW_3_128 VGND VPWR sky130_fd_sc_hd__tapvpwrvgnd_1
XFILLER_24_224 VGND VGND VPWR VPWR sky130_fd_sc_hd__fill_1
XFILLER_33_16 VGND VGND VPWR VPWR sky130_fd_sc_hd__decap_3
X_1257_ _1173_/A _1254_/X _1173_/C _1256_/X VGND VGND VPWR VPWR _1257_/X sky130_fd_sc_hd__o31a_4
X_1188_ _1351_/B _1181_/X _1187_/X _1560_/A1 VGND VGND VPWR VPWR _1188_/X sky130_fd_sc_hd__a22o_2
XFILLER_32_290 VGND VGND VPWR VPWR sky130_fd_sc_hd__decap_3
XFILLER_47_305 VGND VGND VPWR VPWR sky130_fd_sc_hd__decap_3
XTAP_TAPCELL_ROW_17_208 VGND VPWR sky130_fd_sc_hd__tapvpwrvgnd_1
XTAP_TAPCELL_ROW_25_252 VGND VPWR sky130_fd_sc_hd__tapvpwrvgnd_1
XFILLER_23_60 VGND VGND VPWR VPWR sky130_fd_sc_hd__decap_3
XFILLER_24_6 VGND VGND VPWR VPWR sky130_fd_sc_hd__decap_3
XFILLER_0_75 VGND VGND VPWR VPWR sky130_fd_sc_hd__fill_1
X_1111_ _1178_/S _1246_/B VGND VGND VPWR VPWR _1313_/B sky130_fd_sc_hd__nor2_2
X_1042_ _1042_/A _1052_/B VGND VGND VPWR VPWR _1452_/B sky130_fd_sc_hd__nand2_2
XTAP_TAPCELL_ROW_48_377 VGND VPWR sky130_fd_sc_hd__tapvpwrvgnd_1
XTAP_TAPCELL_ROW_0_109 VGND VPWR sky130_fd_sc_hd__tapvpwrvgnd_1
X_0826_ _0919_/B VGND VGND VPWR VPWR _0826_/Y sky130_fd_sc_hd__inv_2
X_1309_ _1309_/A _1309_/B VGND VGND VPWR VPWR _1309_/Y sky130_fd_sc_hd__xnor2_2
XFILLER_12_205 VGND VGND VPWR VPWR sky130_fd_sc_hd__decap_3
XFILLER_44_26 VGND VGND VPWR VPWR sky130_fd_sc_hd__fill_2
XFILLER_8_209 VGND VGND VPWR VPWR sky130_fd_sc_hd__decap_3
XTAP_TAPCELL_ROW_22_233 VGND VPWR sky130_fd_sc_hd__tapvpwrvgnd_1
XFILLER_7_220 VGND VGND VPWR VPWR sky130_fd_sc_hd__decap_3
X_1660_ _1660_/A1 _1657_/A _1392_/C _1392_/A VGND VGND VPWR VPWR _1660_/X sky130_fd_sc_hd__a22o_2
X_1591_ _1591_/A _1591_/B VGND VGND VPWR VPWR _1591_/X sky130_fd_sc_hd__and2_2
XFILLER_22_3 VGND VGND VPWR VPWR sky130_fd_sc_hd__decap_3
XFILLER_38_113 VGND VGND VPWR VPWR sky130_fd_sc_hd__decap_3
Xload_slew167 _1193_/A VGND VGND VPWR VPWR _1391_/S0 sky130_fd_sc_hd__buf_4
Xload_slew189 _1469_/S VGND VGND VPWR VPWR _1070_/S0 sky130_fd_sc_hd__buf_8
XFILLER_14_29 VGND VGND VPWR VPWR sky130_fd_sc_hd__decap_3
X_1025_ _0994_/A _1025_/B VGND VGND VPWR VPWR _1349_/B sky130_fd_sc_hd__and2b_2
XTAP_TAPCELL_ROW_36_314 VGND VPWR sky130_fd_sc_hd__tapvpwrvgnd_1
XPHY_EDGE_ROW_28_Left_81 VGND VGND VPWR VPWR sky130_fd_sc_hd__decap_3
XPHY_EDGE_ROW_12_Left_65 VGND VGND VPWR VPWR sky130_fd_sc_hd__decap_3
Xrebuffer339 _0984_/B VGND VGND VPWR VPWR _0976_/B sky130_fd_sc_hd__buf_4
XFILLER_29_113 VGND VGND VPWR VPWR sky130_fd_sc_hd__fill_2
XFILLER_44_127 VGND VGND VPWR VPWR sky130_fd_sc_hd__fill_2
XFILLER_20_94 VGND VGND VPWR VPWR sky130_fd_sc_hd__decap_3
XFILLER_4_278 VGND VGND VPWR VPWR sky130_fd_sc_hd__decap_3
XFILLER_31_300 VGND VGND VPWR VPWR sky130_fd_sc_hd__decap_3
XFILLER_35_138 VGND VGND VPWR VPWR sky130_fd_sc_hd__fill_1
XFILLER_45_80 VGND VGND VPWR VPWR sky130_fd_sc_hd__decap_3
XFILLER_50_119 VGND VGND VPWR VPWR sky130_fd_sc_hd__fill_1
XFILLER_6_52 VGND VGND VPWR VPWR sky130_fd_sc_hd__decap_3
X_1643_ _1643_/A1 _0892_/B _0901_/B _1660_/A1 _1642_/Y VGND VGND VPWR VPWR _1643_/X
+ sky130_fd_sc_hd__a221o_2
XFILLER_6_85 VGND VGND VPWR VPWR sky130_fd_sc_hd__decap_3
X_1574_ _1549_/X _1552_/C _1573_/X VGND VGND VPWR VPWR _1574_/X sky130_fd_sc_hd__a21o_2
XFILLER_26_127 VGND VGND VPWR VPWR sky130_fd_sc_hd__decap_3
XFILLER_25_39 VGND VGND VPWR VPWR sky130_fd_sc_hd__decap_3
XFILLER_41_119 VGND VGND VPWR VPWR sky130_fd_sc_hd__decap_3
X_1008_ _1309_/A _1333_/B VGND VGND VPWR VPWR _1016_/A sky130_fd_sc_hd__and2_2
XFILLER_1_237 VGND VGND VPWR VPWR sky130_fd_sc_hd__decap_3
XFILLER_40_130 VGND VGND VPWR VPWR sky130_fd_sc_hd__decap_3
XFILLER_40_185 VGND VGND VPWR VPWR sky130_fd_sc_hd__decap_3
Xoutput71 _1675_/A VGND VGND VPWR VPWR result[11] sky130_fd_sc_hd__buf_8
Xoutput82 _1679_/D VGND VGND VPWR VPWR result[21] sky130_fd_sc_hd__buf_6
Xoutput93 output93/A VGND VGND VPWR VPWR result[31] sky130_fd_sc_hd__buf_8
XFILLER_0_281 VGND VGND VPWR VPWR sky130_fd_sc_hd__decap_3
XFILLER_48_274 VGND VGND VPWR VPWR sky130_fd_sc_hd__decap_3
X_1290_ _1288_/A _1015_/A _1513_/A1 _1287_/X _1295_/B VGND VGND VPWR VPWR _1291_/B
+ sky130_fd_sc_hd__o2111a_2
XFILLER_23_119 VGND VGND VPWR VPWR sky130_fd_sc_hd__decap_3
X_1626_ _1621_/A _1609_/B _1635_/A _0899_/B VGND VGND VPWR VPWR _1626_/Y sky130_fd_sc_hd__o211ai_2
X_1557_ _1523_/X _1556_/X _1568_/S VGND VGND VPWR VPWR _1557_/X sky130_fd_sc_hd__mux2_1
X_1488_ _1414_/X _1487_/X _1588_/S VGND VGND VPWR VPWR _1488_/X sky130_fd_sc_hd__mux2_1
XFILLER_39_263 VGND VGND VPWR VPWR sky130_fd_sc_hd__fill_1
XFILLER_52_15 VGND VGND VPWR VPWR sky130_fd_sc_hd__decap_3
XTAP_TAPCELL_ROW_52_401 VGND VPWR sky130_fd_sc_hd__tapvpwrvgnd_1
XFILLER_22_141 VGND VGND VPWR VPWR sky130_fd_sc_hd__decap_3
XFILLER_26_71 VGND VGND VPWR VPWR sky130_fd_sc_hd__decap_3
XFILLER_45_299 VGND VGND VPWR VPWR sky130_fd_sc_hd__decap_3
XFILLER_9_134 VGND VGND VPWR VPWR sky130_fd_sc_hd__decap_3
XFILLER_9_167 VGND VGND VPWR VPWR sky130_fd_sc_hd__fill_1
XFILLER_9_178 VGND VGND VPWR VPWR sky130_fd_sc_hd__decap_3
XFILLER_3_42 VGND VGND VPWR VPWR sky130_fd_sc_hd__decap_3
XFILLER_3_64 VGND VGND VPWR VPWR sky130_fd_sc_hd__decap_3
X_1411_ _1549_/A2 _1410_/X _1440_/B VGND VGND VPWR VPWR _1411_/Y sky130_fd_sc_hd__a21oi_2
X_1342_ _1313_/B _1341_/Y _1244_/X VGND VGND VPWR VPWR _1342_/X sky130_fd_sc_hd__a21o_2
X_1273_ _1273_/A1 _1252_/C _1015_/A _1015_/B _1272_/A VGND VGND VPWR VPWR _1273_/X
+ sky130_fd_sc_hd__a221o_2
XFILLER_36_200 VGND VGND VPWR VPWR sky130_fd_sc_hd__decap_3
XFILLER_36_266 VGND VGND VPWR VPWR sky130_fd_sc_hd__decap_3
XFILLER_36_288 VGND VGND VPWR VPWR sky130_fd_sc_hd__decap_3
XFILLER_51_225 VGND VGND VPWR VPWR sky130_fd_sc_hd__fill_1
XFILLER_51_236 VGND VGND VPWR VPWR sky130_fd_sc_hd__decap_3
XFILLER_51_258 VGND VGND VPWR VPWR sky130_fd_sc_hd__decap_3
X_0988_ _0981_/A _0988_/B VGND VGND VPWR VPWR _0988_/Y sky130_fd_sc_hd__nand2b_2
XTAP_TAPCELL_ROW_14_191 VGND VPWR sky130_fd_sc_hd__tapvpwrvgnd_1
X_1609_ _1621_/A _1609_/B VGND VGND VPWR VPWR _1609_/X sky130_fd_sc_hd__or2_2
Xfanout102 _1099_/X VGND VGND VPWR VPWR _1351_/B sky130_fd_sc_hd__clkdlybuf4s25_1
XFILLER_27_211 VGND VGND VPWR VPWR sky130_fd_sc_hd__fill_1
XFILLER_47_15 VGND VGND VPWR VPWR sky130_fd_sc_hd__decap_3
XFILLER_47_48 VGND VGND VPWR VPWR sky130_fd_sc_hd__decap_3
Xfanout124 _0852_/Y VGND VGND VPWR VPWR _1374_/A sky130_fd_sc_hd__clkdlybuf4s25_1
Xfanout135 _1359_/S VGND VGND VPWR VPWR _1339_/S sky130_fd_sc_hd__buf_4
Xfanout146 _1502_/S VGND VGND VPWR VPWR _1430_/A sky130_fd_sc_hd__clkdlybuf4s25_1
Xfanout157 fanout158/X VGND VGND VPWR VPWR _0970_/A sky130_fd_sc_hd__buf_8
Xfanout168 input55/X VGND VGND VPWR VPWR fanout168/X sky130_fd_sc_hd__buf_6
XTAP_TAPCELL_ROW_6_148 VGND VPWR sky130_fd_sc_hd__tapvpwrvgnd_1
XFILLER_42_236 VGND VGND VPWR VPWR sky130_fd_sc_hd__decap_3
XFILLER_10_111 VGND VGND VPWR VPWR sky130_fd_sc_hd__decap_3
XFILLER_10_144 VGND VGND VPWR VPWR sky130_fd_sc_hd__decap_3
XFILLER_50_280 VGND VGND VPWR VPWR sky130_fd_sc_hd__decap_3
XFILLER_6_126 VGND VGND VPWR VPWR sky130_fd_sc_hd__decap_3
XPHY_EDGE_ROW_0_Left_53 VGND VGND VPWR VPWR sky130_fd_sc_hd__decap_3
XFILLER_37_92 VGND VGND VPWR VPWR sky130_fd_sc_hd__decap_3
XFILLER_33_258 VGND VGND VPWR VPWR sky130_fd_sc_hd__fill_1
X_0911_ _1601_/B _0911_/B VGND VGND VPWR VPWR _1620_/A sky130_fd_sc_hd__nor2_1
X_0842_ _0905_/B _0896_/B _0891_/B _1392_/A _1076_/S _1145_/S VGND VGND VPWR VPWR
+ _1175_/B sky130_fd_sc_hd__mux4_2
XFILLER_52_3 VGND VGND VPWR VPWR sky130_fd_sc_hd__decap_3
XTAP_TAPCELL_ROW_11_172 VGND VPWR sky130_fd_sc_hd__tapvpwrvgnd_1
XFILLER_17_18 VGND VGND VPWR VPWR sky130_fd_sc_hd__decap_3
X_1325_ _1309_/Y _1351_/B _1312_/Y _1324_/X VGND VGND VPWR VPWR _1675_/A sky130_fd_sc_hd__a211o_4
X_1256_ _0951_/Y _1191_/A _1254_/C _1254_/D _0950_/Y VGND VGND VPWR VPWR _1256_/X
+ sky130_fd_sc_hd__a2111o_2
XTAP_TAPCELL_ROW_3_129 VGND VPWR sky130_fd_sc_hd__tapvpwrvgnd_1
XFILLER_33_28 VGND VGND VPWR VPWR sky130_fd_sc_hd__decap_3
X_1187_ _1187_/A0 _0849_/X _0850_/X _0855_/B _1265_/S _1275_/A VGND VGND VPWR VPWR
+ _1187_/X sky130_fd_sc_hd__mux4_2
XPHY_EDGE_ROW_42_Left_95 VGND VGND VPWR VPWR sky130_fd_sc_hd__decap_3
XTAP_TAPCELL_ROW_17_209 VGND VPWR sky130_fd_sc_hd__tapvpwrvgnd_1
XFILLER_15_236 VGND VGND VPWR VPWR sky130_fd_sc_hd__decap_3
XFILLER_15_269 VGND VGND VPWR VPWR sky130_fd_sc_hd__fill_1
XFILLER_23_72 VGND VGND VPWR VPWR sky130_fd_sc_hd__decap_3
XTAP_TAPCELL_ROW_25_253 VGND VPWR sky130_fd_sc_hd__tapvpwrvgnd_1
XFILLER_2_173 VGND VGND VPWR VPWR sky130_fd_sc_hd__fill_1
XFILLER_2_195 VGND VGND VPWR VPWR sky130_fd_sc_hd__fill_1
XFILLER_38_306 VGND VGND VPWR VPWR sky130_fd_sc_hd__fill_2
XFILLER_48_80 VGND VGND VPWR VPWR sky130_fd_sc_hd__decap_3
X_1110_ _1270_/A _1110_/A2 _1096_/X _1109_/Y VGND VGND VPWR VPWR _1671_/A sky130_fd_sc_hd__a211o_2
XFILLER_0_21 VGND VGND VPWR VPWR sky130_fd_sc_hd__decap_3
XFILLER_0_32 VGND VGND VPWR VPWR sky130_fd_sc_hd__decap_3
XFILLER_9_30 VGND VGND VPWR VPWR sky130_fd_sc_hd__decap_3
X_1041_ _1042_/A _1052_/B VGND VGND VPWR VPWR _1043_/A sky130_fd_sc_hd__or2_2
XTAP_TAPCELL_ROW_48_378 VGND VPWR sky130_fd_sc_hd__tapvpwrvgnd_1
XFILLER_9_74 VGND VGND VPWR VPWR sky130_fd_sc_hd__decap_3
XFILLER_9_96 VGND VGND VPWR VPWR sky130_fd_sc_hd__fill_2
X_0825_ _0896_/B VGND VGND VPWR VPWR _0825_/Y sky130_fd_sc_hd__inv_2
XFILLER_44_309 VGND VGND VPWR VPWR sky130_fd_sc_hd__fill_1
X_1308_ _0830_/Y _1006_/B _1292_/X VGND VGND VPWR VPWR _1309_/B sky130_fd_sc_hd__a21boi_4
X_1239_ _1661_/A1 _0978_/A _0983_/B _1555_/B2 _1238_/Y VGND VGND VPWR VPWR _1249_/A
+ sky130_fd_sc_hd__a221o_2
XFILLER_20_250 VGND VGND VPWR VPWR sky130_fd_sc_hd__fill_2
XFILLER_44_38 VGND VGND VPWR VPWR sky130_fd_sc_hd__decap_3
XTAP_TAPCELL_ROW_22_234 VGND VPWR sky130_fd_sc_hd__tapvpwrvgnd_1
XTAP_TAPCELL_ROW_45_359 VGND VPWR sky130_fd_sc_hd__tapvpwrvgnd_1
XFILLER_11_250 VGND VGND VPWR VPWR sky130_fd_sc_hd__decap_3
XFILLER_34_71 VGND VGND VPWR VPWR sky130_fd_sc_hd__decap_3
X_1590_ _1301_/X _1419_/B _1589_/X VGND VGND VPWR VPWR _1590_/X sky130_fd_sc_hd__a21o_2
XFILLER_26_309 VGND VGND VPWR VPWR sky130_fd_sc_hd__fill_1
XFILLER_38_103 VGND VGND VPWR VPWR sky130_fd_sc_hd__fill_1
XFILLER_38_125 VGND VGND VPWR VPWR sky130_fd_sc_hd__decap_3
XFILLER_38_169 VGND VGND VPWR VPWR sky130_fd_sc_hd__decap_3
Xload_slew179 fanout178/X VGND VGND VPWR VPWR _1145_/S sky130_fd_sc_hd__buf_6
X_1024_ _1016_/A _1293_/B _1023_/X VGND VGND VPWR VPWR _1327_/B sky130_fd_sc_hd__a21oi_2
XFILLER_30_18 VGND VGND VPWR VPWR sky130_fd_sc_hd__decap_3
XFILLER_30_29 VGND VGND VPWR VPWR sky130_fd_sc_hd__decap_3
Xrebuffer307 _1627_/B VGND VGND VPWR VPWR _1609_/B sky130_fd_sc_hd__buf_4
XFILLER_29_169 VGND VGND VPWR VPWR sky130_fd_sc_hd__fill_1
XFILLER_37_191 VGND VGND VPWR VPWR sky130_fd_sc_hd__decap_3
XFILLER_52_194 VGND VGND VPWR VPWR sky130_fd_sc_hd__fill_2
XFILLER_4_257 VGND VGND VPWR VPWR sky130_fd_sc_hd__decap_3
XFILLER_29_60 VGND VGND VPWR VPWR sky130_fd_sc_hd__decap_3
XFILLER_29_71 VGND VGND VPWR VPWR sky130_fd_sc_hd__decap_3
XFILLER_35_106 VGND VGND VPWR VPWR sky130_fd_sc_hd__decap_3
XFILLER_43_150 VGND VGND VPWR VPWR sky130_fd_sc_hd__fill_1
XFILLER_45_70 VGND VGND VPWR VPWR sky130_fd_sc_hd__fill_2
XTAP_TAPCELL_ROW_41_340 VGND VPWR sky130_fd_sc_hd__tapvpwrvgnd_1
XFILLER_6_64 VGND VGND VPWR VPWR sky130_fd_sc_hd__decap_3
X_1642_ _1659_/A _1654_/B VGND VGND VPWR VPWR _1642_/Y sky130_fd_sc_hd__nor2_2
XFILLER_3_290 VGND VGND VPWR VPWR sky130_fd_sc_hd__decap_3
X_1573_ _1575_/A _1573_/B VGND VGND VPWR VPWR _1573_/X sky130_fd_sc_hd__or2_2
XFILLER_26_106 VGND VGND VPWR VPWR sky130_fd_sc_hd__decap_3
XFILLER_26_139 VGND VGND VPWR VPWR sky130_fd_sc_hd__fill_1
X_1007_ _1007_/A _1007_/B VGND VGND VPWR VPWR _1333_/B sky130_fd_sc_hd__nand2_2
XFILLER_34_183 VGND VGND VPWR VPWR sky130_fd_sc_hd__decap_3
XFILLER_41_28 VGND VGND VPWR VPWR sky130_fd_sc_hd__decap_3
XFILLER_1_249 VGND VGND VPWR VPWR sky130_fd_sc_hd__decap_3
XFILLER_15_84 VGND VGND VPWR VPWR sky130_fd_sc_hd__fill_2
XFILLER_25_172 VGND VGND VPWR VPWR sky130_fd_sc_hd__fill_1
XFILLER_40_153 VGND VGND VPWR VPWR sky130_fd_sc_hd__decap_3
XFILLER_40_197 VGND VGND VPWR VPWR sky130_fd_sc_hd__decap_3
XFILLER_0_271 VGND VGND VPWR VPWR sky130_fd_sc_hd__decap_3
XFILLER_49_9 VGND VGND VPWR VPWR sky130_fd_sc_hd__decap_3
Xoutput72 _1669_/D VGND VGND VPWR VPWR result[12] sky130_fd_sc_hd__buf_6
Xoutput83 _1680_/B VGND VGND VPWR VPWR result[22] sky130_fd_sc_hd__buf_6
Xoutput94 _1671_/C VGND VGND VPWR VPWR result[3] sky130_fd_sc_hd__dlymetal6s2s_1
XFILLER_0_293 VGND VGND VPWR VPWR sky130_fd_sc_hd__decap_3
XFILLER_16_150 VGND VGND VPWR VPWR sky130_fd_sc_hd__decap_3
XFILLER_48_231 VGND VGND VPWR VPWR sky130_fd_sc_hd__decap_3
XFILLER_48_253 VGND VGND VPWR VPWR sky130_fd_sc_hd__decap_3
XFILLER_48_286 VGND VGND VPWR VPWR sky130_fd_sc_hd__decap_3
X_1625_ _1637_/A2 _1609_/X _1608_/Y _1624_/X VGND VGND VPWR VPWR _1678_/D sky130_fd_sc_hd__a31o_4
X_1556_ _1059_/B _0947_/B _1586_/S VGND VGND VPWR VPWR _1556_/X sky130_fd_sc_hd__mux2_1
XFILLER_39_220 VGND VGND VPWR VPWR sky130_fd_sc_hd__decap_3
XFILLER_39_275 VGND VGND VPWR VPWR sky130_fd_sc_hd__decap_3
XFILLER_39_286 VGND VGND VPWR VPWR sky130_fd_sc_hd__decap_3
X_1487_ _1455_/X _1486_/X _1568_/S VGND VGND VPWR VPWR _1487_/X sky130_fd_sc_hd__mux2_1
XFILLER_52_27 VGND VGND VPWR VPWR sky130_fd_sc_hd__fill_1
XFILLER_52_38 VGND VGND VPWR VPWR sky130_fd_sc_hd__decap_3
XTAP_TAPCELL_ROW_52_402 VGND VPWR sky130_fd_sc_hd__tapvpwrvgnd_1
XFILLER_22_153 VGND VGND VPWR VPWR sky130_fd_sc_hd__decap_3
XFILLER_22_197 VGND VGND VPWR VPWR sky130_fd_sc_hd__decap_3
XFILLER_45_201 VGND VGND VPWR VPWR sky130_fd_sc_hd__decap_3
XFILLER_45_256 VGND VGND VPWR VPWR sky130_fd_sc_hd__decap_3
XFILLER_45_278 VGND VGND VPWR VPWR sky130_fd_sc_hd__fill_2
XFILLER_13_120 VGND VGND VPWR VPWR sky130_fd_sc_hd__fill_1
XFILLER_26_83 VGND VGND VPWR VPWR sky130_fd_sc_hd__fill_1
XFILLER_26_94 VGND VGND VPWR VPWR sky130_fd_sc_hd__decap_3
XFILLER_9_113 VGND VGND VPWR VPWR sky130_fd_sc_hd__decap_3
XFILLER_47_6 VGND VGND VPWR VPWR sky130_fd_sc_hd__decap_3
X_1410_ _1332_/X _1406_/X _1409_/X _1406_/B VGND VGND VPWR VPWR _1410_/X sky130_fd_sc_hd__o22a_2
XFILLER_3_21 VGND VGND VPWR VPWR sky130_fd_sc_hd__decap_3
X_1341_ _1275_/B _1177_/A _1177_/B VGND VGND VPWR VPWR _1341_/Y sky130_fd_sc_hd__o21ai_2
X_1272_ _1272_/A _1272_/B _1272_/C VGND VGND VPWR VPWR _1272_/Y sky130_fd_sc_hd__nand3_2
XFILLER_36_256 VGND VGND VPWR VPWR sky130_fd_sc_hd__fill_2
X_0987_ _1208_/A _0986_/X _0985_/X VGND VGND VPWR VPWR _1215_/C sky130_fd_sc_hd__a21oi_2
XTAP_TAPCELL_ROW_14_192 VGND VPWR sky130_fd_sc_hd__tapvpwrvgnd_1
X_1608_ _1621_/A _1609_/B VGND VGND VPWR VPWR _1608_/Y sky130_fd_sc_hd__nand2_2
Xfanout103 _1099_/X VGND VGND VPWR VPWR _1637_/A2 sky130_fd_sc_hd__clkdlybuf4s25_1
Xfanout114 _1632_/A3 VGND VGND VPWR VPWR _1585_/A3 sky130_fd_sc_hd__buf_2
Xfanout125 _0852_/Y VGND VGND VPWR VPWR _1560_/A1 sky130_fd_sc_hd__clkdlybuf4s25_1
Xfanout147 _1502_/S VGND VGND VPWR VPWR _1526_/S sky130_fd_sc_hd__buf_4
X_1539_ _1499_/X _1538_/X _1568_/S VGND VGND VPWR VPWR _1539_/X sky130_fd_sc_hd__mux2_1
XTAP_TAPCELL_ROW_6_149 VGND VPWR sky130_fd_sc_hd__tapvpwrvgnd_1
XFILLER_27_267 VGND VGND VPWR VPWR sky130_fd_sc_hd__decap_3
XFILLER_47_27 VGND VGND VPWR VPWR sky130_fd_sc_hd__decap_3
Xfanout158 _1392_/B VGND VGND VPWR VPWR fanout158/X sky130_fd_sc_hd__buf_6
XFILLER_10_123 VGND VGND VPWR VPWR sky130_fd_sc_hd__decap_3
XFILLER_10_134 VGND VGND VPWR VPWR sky130_fd_sc_hd__decap_3
XFILLER_42_248 VGND VGND VPWR VPWR sky130_fd_sc_hd__decap_3
XFILLER_42_259 VGND VGND VPWR VPWR sky130_fd_sc_hd__decap_3
XFILLER_50_292 VGND VGND VPWR VPWR sky130_fd_sc_hd__decap_3
XFILLER_12_63 VGND VGND VPWR VPWR sky130_fd_sc_hd__decap_3
XFILLER_6_105 VGND VGND VPWR VPWR sky130_fd_sc_hd__decap_3
XFILLER_37_71 VGND VGND VPWR VPWR sky130_fd_sc_hd__fill_1
XPHY_EDGE_ROW_16_Right_16 VGND VGND VPWR VPWR sky130_fd_sc_hd__decap_3
XFILLER_41_270 VGND VGND VPWR VPWR sky130_fd_sc_hd__decap_3
XFILLER_41_292 VGND VGND VPWR VPWR sky130_fd_sc_hd__decap_3
X_0910_ _0910_/A _0910_/B VGND VGND VPWR VPWR _0911_/B sky130_fd_sc_hd__and2_2
X_0841_ _0891_/B _1116_/A _0867_/A VGND VGND VPWR VPWR _1226_/B sky130_fd_sc_hd__mux2_1
XTAP_TAPCELL_ROW_11_173 VGND VPWR sky130_fd_sc_hd__tapvpwrvgnd_1
XPHY_EDGE_ROW_25_Right_25 VGND VGND VPWR VPWR sky130_fd_sc_hd__decap_3
XFILLER_45_3 VGND VGND VPWR VPWR sky130_fd_sc_hd__fill_1
X_1324_ _1374_/A _1316_/X _1323_/X _1315_/Y VGND VGND VPWR VPWR _1324_/X sky130_fd_sc_hd__a211o_2
X_1255_ _0974_/Y _1217_/B _1238_/B VGND VGND VPWR VPWR _1255_/X sky130_fd_sc_hd__o21a_2
X_1186_ _1270_/A input27/X _1632_/A3 _1185_/X VGND VGND VPWR VPWR _1186_/X sky130_fd_sc_hd__a31o_2
XPHY_EDGE_ROW_34_Right_34 VGND VGND VPWR VPWR sky130_fd_sc_hd__decap_3
XFILLER_24_215 VGND VGND VPWR VPWR sky130_fd_sc_hd__decap_3
XFILLER_32_281 VGND VGND VPWR VPWR sky130_fd_sc_hd__decap_3
XTAP_TAPCELL_ROW_34_298 VGND VPWR sky130_fd_sc_hd__tapvpwrvgnd_1
XPHY_EDGE_ROW_43_Right_43 VGND VGND VPWR VPWR sky130_fd_sc_hd__decap_3
XPHY_EDGE_ROW_52_Right_52 VGND VGND VPWR VPWR sky130_fd_sc_hd__decap_3
XFILLER_23_51 VGND VGND VPWR VPWR sky130_fd_sc_hd__decap_3
XFILLER_2_141 VGND VGND VPWR VPWR sky130_fd_sc_hd__fill_2
XFILLER_0_44 VGND VGND VPWR VPWR sky130_fd_sc_hd__fill_2
X_1040_ _1442_/A _1440_/B VGND VGND VPWR VPWR _1040_/Y sky130_fd_sc_hd__nand2_2
XFILLER_0_88 VGND VGND VPWR VPWR sky130_fd_sc_hd__fill_1
XFILLER_21_207 VGND VGND VPWR VPWR sky130_fd_sc_hd__decap_3
XFILLER_9_42 VGND VGND VPWR VPWR sky130_fd_sc_hd__fill_1
XTAP_TAPCELL_ROW_48_379 VGND VPWR sky130_fd_sc_hd__tapvpwrvgnd_1
XFILLER_28_29 VGND VGND VPWR VPWR sky130_fd_sc_hd__fill_1
XFILLER_44_17 VGND VGND VPWR VPWR sky130_fd_sc_hd__decap_3
X_1307_ _1351_/B _1292_/X _1293_/X _1306_/X VGND VGND VPWR VPWR _1670_/B sky130_fd_sc_hd__a31o_4
X_1238_ _1452_/A _1238_/B VGND VGND VPWR VPWR _1238_/Y sky130_fd_sc_hd__nor2_2
X_1169_ _1169_/A _1169_/B _1169_/C _1168_/X VGND VGND VPWR VPWR _1169_/X sky130_fd_sc_hd__or4b_2
XFILLER_12_229 VGND VGND VPWR VPWR sky130_fd_sc_hd__decap_3
XTAP_TAPCELL_ROW_22_235 VGND VPWR sky130_fd_sc_hd__tapvpwrvgnd_1
XFILLER_34_50 VGND VGND VPWR VPWR sky130_fd_sc_hd__fill_1
XFILLER_34_83 VGND VGND VPWR VPWR sky130_fd_sc_hd__fill_1
XFILLER_34_94 VGND VGND VPWR VPWR sky130_fd_sc_hd__decap_3
XFILLER_7_200 VGND VGND VPWR VPWR sky130_fd_sc_hd__decap_3
XFILLER_7_266 VGND VGND VPWR VPWR sky130_fd_sc_hd__decap_3
Xwire164 _0955_/A VGND VGND VPWR VPWR _1178_/S sky130_fd_sc_hd__clkbuf_4
Xload_slew136 _1339_/S VGND VGND VPWR VPWR _1281_/S sky130_fd_sc_hd__buf_6
Xload_slew169 fanout168/X VGND VGND VPWR VPWR _0833_/A sky130_fd_sc_hd__buf_6
XFILLER_38_137 VGND VGND VPWR VPWR sky130_fd_sc_hd__decap_3
XFILLER_46_192 VGND VGND VPWR VPWR sky130_fd_sc_hd__decap_3
X_1023_ _0830_/Y _1006_/B _1309_/A _1018_/X VGND VGND VPWR VPWR _1023_/X sky130_fd_sc_hd__a31o_2
XFILLER_29_137 VGND VGND VPWR VPWR sky130_fd_sc_hd__decap_3
XPHY_EDGE_ROW_2_Right_2 VGND VGND VPWR VPWR sky130_fd_sc_hd__decap_3
XFILLER_40_302 VGND VGND VPWR VPWR sky130_fd_sc_hd__decap_3
XFILLER_44_118 VGND VGND VPWR VPWR sky130_fd_sc_hd__decap_3
XFILLER_20_85 VGND VGND VPWR VPWR sky130_fd_sc_hd__decap_3
XFILLER_4_269 VGND VGND VPWR VPWR sky130_fd_sc_hd__decap_3
XFILLER_29_83 VGND VGND VPWR VPWR sky130_fd_sc_hd__decap_3
XFILLER_35_129 VGND VGND VPWR VPWR sky130_fd_sc_hd__decap_3
XFILLER_43_195 VGND VGND VPWR VPWR sky130_fd_sc_hd__decap_3
XTAP_TAPCELL_ROW_41_341 VGND VPWR sky130_fd_sc_hd__tapvpwrvgnd_1
XFILLER_6_21 VGND VGND VPWR VPWR sky130_fd_sc_hd__decap_3
XFILLER_6_32 VGND VGND VPWR VPWR sky130_fd_sc_hd__decap_3
XFILLER_6_76 VGND VGND VPWR VPWR sky130_fd_sc_hd__fill_1
X_1641_ _1641_/A _1641_/B VGND VGND VPWR VPWR _1641_/Y sky130_fd_sc_hd__nor2_2
X_1572_ _1575_/A _1575_/B VGND VGND VPWR VPWR _1572_/Y sky130_fd_sc_hd__nand2_2
XFILLER_19_181 VGND VGND VPWR VPWR sky130_fd_sc_hd__decap_3
XFILLER_34_173 VGND VGND VPWR VPWR sky130_fd_sc_hd__decap_3
X_1006_ _1006_/A _1006_/B VGND VGND VPWR VPWR _1007_/B sky130_fd_sc_hd__nand2_2
XFILLER_34_195 VGND VGND VPWR VPWR sky130_fd_sc_hd__fill_1
XFILLER_1_228 VGND VGND VPWR VPWR sky130_fd_sc_hd__decap_3
XFILLER_9_9 VGND VGND VPWR VPWR sky130_fd_sc_hd__decap_3
XFILLER_15_41 VGND VGND VPWR VPWR sky130_fd_sc_hd__decap_3
XFILLER_15_63 VGND VGND VPWR VPWR sky130_fd_sc_hd__decap_3
XFILLER_40_176 VGND VGND VPWR VPWR sky130_fd_sc_hd__decap_3
XFILLER_31_40 VGND VGND VPWR VPWR sky130_fd_sc_hd__decap_3
XFILLER_31_73 VGND VGND VPWR VPWR sky130_fd_sc_hd__decap_3
XFILLER_31_95 VGND VGND VPWR VPWR sky130_fd_sc_hd__decap_3
Xoutput73 _1669_/B VGND VGND VPWR VPWR result[13] sky130_fd_sc_hd__buf_6
Xoutput84 _1681_/A VGND VGND VPWR VPWR result[23] sky130_fd_sc_hd__buf_6
Xoutput95 _1671_/D VGND VGND VPWR VPWR result[4] sky130_fd_sc_hd__clkbuf_2
XFILLER_31_110 VGND VGND VPWR VPWR sky130_fd_sc_hd__fill_2
XFILLER_48_265 VGND VGND VPWR VPWR sky130_fd_sc_hd__decap_3
XFILLER_48_298 VGND VGND VPWR VPWR sky130_fd_sc_hd__decap_3
XFILLER_16_195 VGND VGND VPWR VPWR sky130_fd_sc_hd__fill_1
XFILLER_31_165 VGND VGND VPWR VPWR sky130_fd_sc_hd__decap_3
XFILLER_31_187 VGND VGND VPWR VPWR sky130_fd_sc_hd__decap_3
XFILLER_31_198 VGND VGND VPWR VPWR sky130_fd_sc_hd__decap_3
X_1624_ _1591_/A _1342_/X _1616_/X _1623_/X VGND VGND VPWR VPWR _1624_/X sky130_fd_sc_hd__a211o_4
X_1555_ _1643_/A1 _1060_/B _1061_/Y _1555_/B2 _1554_/X VGND VGND VPWR VPWR _1555_/X
+ sky130_fd_sc_hd__a221o_2
XFILLER_36_29 VGND VGND VPWR VPWR sky130_fd_sc_hd__decap_3
XFILLER_39_243 VGND VGND VPWR VPWR sky130_fd_sc_hd__fill_2
XFILLER_39_254 VGND VGND VPWR VPWR sky130_fd_sc_hd__decap_3
XFILLER_39_298 VGND VGND VPWR VPWR sky130_fd_sc_hd__decap_3
X_1486_ _0943_/B _1051_/B _1486_/S VGND VGND VPWR VPWR _1486_/X sky130_fd_sc_hd__mux2_1
XTAP_TAPCELL_ROW_52_403 VGND VPWR sky130_fd_sc_hd__tapvpwrvgnd_1
XFILLER_6_309 VGND VGND VPWR VPWR sky130_fd_sc_hd__fill_1
XFILLER_7_6 VGND VGND VPWR VPWR sky130_fd_sc_hd__decap_3
XFILLER_26_40 VGND VGND VPWR VPWR sky130_fd_sc_hd__decap_3
XFILLER_26_62 VGND VGND VPWR VPWR sky130_fd_sc_hd__decap_3
XFILLER_13_132 VGND VGND VPWR VPWR sky130_fd_sc_hd__decap_3
XFILLER_42_72 VGND VGND VPWR VPWR sky130_fd_sc_hd__fill_2
XFILLER_42_83 VGND VGND VPWR VPWR sky130_fd_sc_hd__fill_1
XFILLER_9_169 VGND VGND VPWR VPWR sky130_fd_sc_hd__decap_3
X_1340_ _1183_/X _1339_/X _1526_/S VGND VGND VPWR VPWR _1340_/X sky130_fd_sc_hd__mux2_2
XFILLER_36_224 VGND VGND VPWR VPWR sky130_fd_sc_hd__decap_3
XFILLER_3_33 VGND VGND VPWR VPWR sky130_fd_sc_hd__decap_3
X_1271_ _1271_/A _1271_/B _1271_/C _1259_/X VGND VGND VPWR VPWR _1673_/B sky130_fd_sc_hd__or4b_4
X_0986_ _0970_/A _0986_/B VGND VGND VPWR VPWR _0986_/X sky130_fd_sc_hd__and2b_2
XTAP_TAPCELL_ROW_14_193 VGND VPWR sky130_fd_sc_hd__tapvpwrvgnd_1
X_1607_ _1656_/A _1596_/X _1597_/Y _1606_/X VGND VGND VPWR VPWR _1678_/B sky130_fd_sc_hd__a31o_4
Xfanout115 _0874_/X VGND VGND VPWR VPWR _1632_/A3 sky130_fd_sc_hd__clkdlybuf4s25_1
Xfanout137 _1631_/A1 VGND VGND VPWR VPWR _1359_/S sky130_fd_sc_hd__clkbuf_2
Xfanout148 _0832_/Y VGND VGND VPWR VPWR _1502_/S sky130_fd_sc_hd__clkbuf_2
Xfanout159 _1392_/B VGND VGND VPWR VPWR _0852_/A sky130_fd_sc_hd__clkdlybuf4s25_1
X_1538_ _0947_/B _0941_/B _1538_/S VGND VGND VPWR VPWR _1538_/X sky130_fd_sc_hd__mux2_1
X_1469_ _1051_/B _1052_/B _1469_/S VGND VGND VPWR VPWR _1469_/X sky130_fd_sc_hd__mux2_1
XFILLER_47_39 VGND VGND VPWR VPWR sky130_fd_sc_hd__decap_3
XFILLER_35_290 VGND VGND VPWR VPWR sky130_fd_sc_hd__decap_3
XFILLER_50_271 VGND VGND VPWR VPWR sky130_fd_sc_hd__decap_3
XFILLER_6_117 VGND VGND VPWR VPWR sky130_fd_sc_hd__decap_3
XFILLER_2_301 VGND VGND VPWR VPWR sky130_fd_sc_hd__decap_3
XFILLER_5_3 VGND VGND VPWR VPWR sky130_fd_sc_hd__decap_3
XFILLER_33_249 VGND VGND VPWR VPWR sky130_fd_sc_hd__decap_3
X_0840_ _0838_/X _1187_/A0 _1265_/S VGND VGND VPWR VPWR _0840_/X sky130_fd_sc_hd__mux2_4
XTAP_TAPCELL_ROW_11_174 VGND VPWR sky130_fd_sc_hd__tapvpwrvgnd_1
X_1323_ _1570_/A1 _1319_/X _1320_/X _1322_/X VGND VGND VPWR VPWR _1323_/X sky130_fd_sc_hd__a211o_2
X_1254_ _1254_/A _1254_/B _1254_/C _1254_/D VGND VGND VPWR VPWR _1254_/X sky130_fd_sc_hd__or4_4
X_1185_ _0880_/X _1183_/X _1184_/X _0971_/B VGND VGND VPWR VPWR _1185_/X sky130_fd_sc_hd__a22o_2
XFILLER_32_293 VGND VGND VPWR VPWR sky130_fd_sc_hd__decap_3
XFILLER_33_19 VGND VGND VPWR VPWR sky130_fd_sc_hd__decap_3
XTAP_TAPCELL_ROW_34_299 VGND VPWR sky130_fd_sc_hd__tapvpwrvgnd_1
X_0969_ _0986_/B _0970_/A VGND VGND VPWR VPWR _0971_/A sky130_fd_sc_hd__nand2_4
XFILLER_47_308 VGND VGND VPWR VPWR sky130_fd_sc_hd__fill_2
XFILLER_23_30 VGND VGND VPWR VPWR sky130_fd_sc_hd__decap_3
XFILLER_23_63 VGND VGND VPWR VPWR sky130_fd_sc_hd__decap_3
XFILLER_2_197 VGND VGND VPWR VPWR sky130_fd_sc_hd__decap_3
XFILLER_0_12 VGND VGND VPWR VPWR sky130_fd_sc_hd__decap_3
XFILLER_24_9 VGND VGND VPWR VPWR sky130_fd_sc_hd__fill_2
XFILLER_9_21 VGND VGND VPWR VPWR sky130_fd_sc_hd__decap_3
XTAP_TAPCELL_ROW_16_200 VGND VPWR sky130_fd_sc_hd__tapvpwrvgnd_1
XFILLER_29_308 VGND VGND VPWR VPWR sky130_fd_sc_hd__fill_2
X_1306_ _1513_/A1 _1295_/Y _1296_/X _1305_/X VGND VGND VPWR VPWR _1306_/X sky130_fd_sc_hd__a31o_4
XFILLER_44_29 VGND VGND VPWR VPWR sky130_fd_sc_hd__decap_3
X_1237_ _1143_/X _1391_/A2 _1316_/A3 _1160_/X _1124_/S _1472_/A VGND VGND VPWR VPWR
+ _1237_/X sky130_fd_sc_hd__mux4_2
X_1168_ _1601_/A _1173_/A _1166_/A _0882_/B _1167_/X VGND VGND VPWR VPWR _1168_/X
+ sky130_fd_sc_hd__o221a_2
X_1099_ _1116_/D _1100_/B VGND VGND VPWR VPWR _1099_/X sky130_fd_sc_hd__and2_2
XTAP_TAPCELL_ROW_30_280 VGND VPWR sky130_fd_sc_hd__tapvpwrvgnd_1
XTAP_TAPCELL_ROW_22_236 VGND VPWR sky130_fd_sc_hd__tapvpwrvgnd_1
XFILLER_18_85 VGND VGND VPWR VPWR sky130_fd_sc_hd__decap_3
XFILLER_47_105 VGND VGND VPWR VPWR sky130_fd_sc_hd__fill_1
XFILLER_11_241 VGND VGND VPWR VPWR sky130_fd_sc_hd__decap_3
XFILLER_34_62 VGND VGND VPWR VPWR sky130_fd_sc_hd__decap_3
XFILLER_50_50 VGND VGND VPWR VPWR sky130_fd_sc_hd__decap_3
XFILLER_7_223 VGND VGND VPWR VPWR sky130_fd_sc_hd__fill_1
XFILLER_22_6 VGND VGND VPWR VPWR sky130_fd_sc_hd__fill_2
XFILLER_38_116 VGND VGND VPWR VPWR sky130_fd_sc_hd__decap_3
XFILLER_46_182 VGND VGND VPWR VPWR sky130_fd_sc_hd__decap_3
X_1022_ _1293_/B VGND VGND VPWR VPWR _1022_/Y sky130_fd_sc_hd__inv_2
XFILLER_37_182 VGND VGND VPWR VPWR sky130_fd_sc_hd__decap_3
XFILLER_4_226 VGND VGND VPWR VPWR sky130_fd_sc_hd__fill_1
XTAP_TAPCELL_ROW_50_386 VGND VPWR sky130_fd_sc_hd__tapvpwrvgnd_1
XFILLER_20_97 VGND VGND VPWR VPWR sky130_fd_sc_hd__decap_3
XFILLER_29_51 VGND VGND VPWR VPWR sky130_fd_sc_hd__decap_3
XFILLER_45_50 VGND VGND VPWR VPWR sky130_fd_sc_hd__decap_3
XFILLER_45_83 VGND VGND VPWR VPWR sky130_fd_sc_hd__decap_3
XFILLER_31_303 VGND VGND VPWR VPWR sky130_fd_sc_hd__decap_3
XFILLER_43_174 VGND VGND VPWR VPWR sky130_fd_sc_hd__decap_3
XFILLER_3_270 VGND VGND VPWR VPWR sky130_fd_sc_hd__decap_3
XFILLER_3_281 VGND VGND VPWR VPWR sky130_fd_sc_hd__decap_3
XFILLER_6_55 VGND VGND VPWR VPWR sky130_fd_sc_hd__decap_3
XFILLER_6_88 VGND VGND VPWR VPWR sky130_fd_sc_hd__fill_2
XFILLER_6_99 VGND VGND VPWR VPWR sky130_fd_sc_hd__decap_3
X_1640_ _0901_/B _0900_/X _1640_/A3 _1464_/A VGND VGND VPWR VPWR _1641_/B sky130_fd_sc_hd__a31o_2
X_1571_ _1591_/A _1278_/Y _1282_/X _1419_/B _1570_/X VGND VGND VPWR VPWR _1571_/X
+ sky130_fd_sc_hd__a221o_2
XPHY_EDGE_ROW_16_Left_69 VGND VGND VPWR VPWR sky130_fd_sc_hd__decap_3
XFILLER_34_141 VGND VGND VPWR VPWR sky130_fd_sc_hd__decap_3
X_1005_ _1006_/A _1006_/B VGND VGND VPWR VPWR _1007_/A sky130_fd_sc_hd__or2_2
XFILLER_1_207 VGND VGND VPWR VPWR sky130_fd_sc_hd__decap_3
XFILLER_15_75 VGND VGND VPWR VPWR sky130_fd_sc_hd__decap_3
XFILLER_25_196 VGND VGND VPWR VPWR sky130_fd_sc_hd__fill_1
XFILLER_40_100 VGND VGND VPWR VPWR sky130_fd_sc_hd__decap_3
XFILLER_40_133 VGND VGND VPWR VPWR sky130_fd_sc_hd__decap_3
XFILLER_40_166 VGND VGND VPWR VPWR sky130_fd_sc_hd__fill_1
XFILLER_0_251 VGND VGND VPWR VPWR sky130_fd_sc_hd__fill_1
XFILLER_0_262 VGND VGND VPWR VPWR sky130_fd_sc_hd__decap_3
XFILLER_0_284 VGND VGND VPWR VPWR sky130_fd_sc_hd__decap_3
XFILLER_48_222 VGND VGND VPWR VPWR sky130_fd_sc_hd__decap_3
XFILLER_48_277 VGND VGND VPWR VPWR sky130_fd_sc_hd__decap_3
Xoutput74 _1675_/B VGND VGND VPWR VPWR result[14] sky130_fd_sc_hd__clkbuf_2
Xoutput85 _1676_/A VGND VGND VPWR VPWR result[24] sky130_fd_sc_hd__buf_6
Xoutput96 _1672_/B VGND VGND VPWR VPWR result[5] sky130_fd_sc_hd__buf_6
XFILLER_16_130 VGND VGND VPWR VPWR sky130_fd_sc_hd__decap_3
XFILLER_16_141 VGND VGND VPWR VPWR sky130_fd_sc_hd__decap_3
XFILLER_16_174 VGND VGND VPWR VPWR sky130_fd_sc_hd__decap_3
X_1623_ _1656_/A _1623_/B _1623_/C VGND VGND VPWR VPWR _1623_/X sky130_fd_sc_hd__and3_4
X_1554_ _1059_/A _1059_/B _1585_/A3 _1537_/A VGND VGND VPWR VPWR _1554_/X sky130_fd_sc_hd__a31o_2
X_1485_ _1485_/A _1485_/B VGND VGND VPWR VPWR _1485_/Y sky130_fd_sc_hd__nor2_2
.ends
